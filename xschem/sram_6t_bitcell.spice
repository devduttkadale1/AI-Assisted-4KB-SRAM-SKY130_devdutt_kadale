* 6T SRAM Bitcell - SKY130 TT
.subckt sram_6t_bitcell BL BLB WL VDD GND
M1 Q  WL BL  GND sky130_fd_pr__nfet_01v8 W=1.0u L=0.15u
M2 QB WL BLB GND sky130_fd_pr__nfet_01v8 W=1.0u L=0.15u
M3 Q  QB GND GND sky130_fd_pr__nfet_01v8 W=1.0u L=0.15u
M4 QB Q  GND GND sky130_fd_pr__nfet_01v8 W=1.0u L=0.15u
M5 Q  QB VDD VDD sky130_fd_pr__pfet_01v8 W=0.5u L=0.15u
M6 QB Q  VDD VDD sky130_fd_pr__pfet_01v8 W=0.5u L=0.15u
.ends sram_6t_bitcell
