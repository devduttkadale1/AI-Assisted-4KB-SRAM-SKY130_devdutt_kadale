* 6T SRAM Bitcell Testbench - Hold SNM Test
* Devdutt Kadale

.option scale=1e-6
* Load only core MOSFET models directly
.include "/home/devdutt/skywater-pdk-libs-sky130_fd_pr/models/corners/tt/sky130_fd_pr__nfet_01v8__tt.corner.spice"
.include "/home/devdutt/skywater-pdk-libs-sky130_fd_pr/models/corners/tt/sky130_fd_pr__pfet_01v8__tt.corner.spice"

.include sram_6t_bitcell.spice

Xbitcell BL BLB WL VDD GND sram_6t_bitcell

VDD VDD GND DC 1.8
VWL WL  GND DC 0
VBL BL  GND DC 1.8
VBLB BLB GND DC 1.8

.op
.dc VDD 0 1.8 0.01
.save V(Q) V(QB)
.end
