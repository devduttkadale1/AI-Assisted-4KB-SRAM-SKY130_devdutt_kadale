* NGSPICE file created from sram_6t_cell.ext - technology: sky130A

.subckt sram_6t_cell VDD GND BL GND_uq1
X0 a_768_4# a_824_34# a_768_4# GND_uq1 sky130_fd_pr__nfet_01v8 ad=1.4534 pd=10.4 as=1.4534 ps=10.4 w=1.99 l=0.16
X1 a_88_4# a_144_34# a_88_4# GND_uq1 sky130_fd_pr__nfet_01v8 ad=1.4534 pd=10.4 as=1.4534 ps=10.4 w=1.99 l=0.16
X2 a_1056_536# a_1024_510# a_968_536# w_0_500# sky130_fd_pr__pfet_01v8 ad=0.3192 pd=2.84 as=0.3192 ps=2.84 w=1.14 l=0.16
X3 a_968_4# a_1024_34# a_968_4# GND_uq1 sky130_fd_pr__nfet_01v8 ad=1.4534 pd=10.4 as=1.4534 ps=10.4 w=1.99 l=0.16
X4 a_176_536# a_144_510# a_88_536# w_0_500# sky130_fd_pr__pfet_01v8 ad=0.3192 pd=2.84 as=0.3192 ps=2.84 w=1.14 l=0.16
X5 a_288_4# a_344_34# a_288_4# GND_uq1 sky130_fd_pr__nfet_01v8 ad=1.4534 pd=10.4 as=1.4534 ps=10.4 w=1.99 l=0.16
C0 VDD_uq0 a_1024_510# 0
C1 a_176_536# m1_0_0# 0.00113f
C2 a_824_34# w_0_500# 0.00497f
C3 a_144_34# a_144_510# 0.00985f
C4 BL_uq0 a_824_34# 0.0014f
C5 a_824_34# WL 0.00774f
C6 VDD WL 0
C7 GND a_1056_536# 0.0016f
C8 BLB a_1024_510# 0.004f
C9 m1_0_0# GND_uq0 0.01467f
C10 m1_940_750# a_1056_536# 0.00545f
C11 a_344_34# w_0_500# 0.00497f
C12 a_824_34# a_1024_34# 0.00248f
C13 m1_0_750# a_144_510# 0.00671f
C14 BL_uq0 a_344_34# 0.00877f
C15 a_344_34# WL 0.00774f
C16 m1_940_750# VDD_uq0 0.01467f
C17 WL a_968_536# 0.00535f
C18 GND a_768_4# 0
C19 VDD_uq0 GND_uq0 0.02816f
C20 a_144_34# w_0_500# 0
C21 BL_uq0 a_144_34# 0.00668f
C22 m1_0_0# a_88_4# 0.0235f
C23 GND_uq0 a_768_4# 0.01325f
C24 GND m1_940_0# 0.096f
C25 GND BLB 0.0264f
C26 a_1024_510# a_144_510# 0
C27 m1_940_750# m1_940_0# 0.00117f
C28 m1_0_750# w_0_500# 0.01833f
C29 a_288_4# GND_uq0 0.01325f
C30 m1_940_0# GND_uq0 0.01467f
C31 m1_0_750# WL 0.00102f
C32 a_88_536# m1_0_750# 0.00545f
C33 GND a_968_4# 0.01979f
C34 m1_940_750# a_968_4# 0.00427f
C35 w_0_500# a_1024_510# 0.02803f
C36 m1_0_0# a_288_4# 0.00146f
C37 BL_uq0 a_1024_510# 0
C38 m1_940_750# a_144_510# 0
C39 BL GND_uq0 0.00461f
C40 BLB a_1056_536# 0.00412f
C41 VDD_uq0 a_768_4# 0.00269f
C42 a_1024_34# a_1024_510# 0.00985f
C43 a_824_34# a_344_34# 0
C44 VDD_uq0 a_288_4# 0.00269f
C45 BL_uq0 a_176_536# 0.00509f
C46 a_176_536# WL 0.00535f
C47 m1_940_0# a_768_4# 0.00146f
C48 GND w_0_500# 0.00423f
C49 BLB a_768_4# 0.02684f
C50 m1_940_750# w_0_500# 0.01781f
C51 m1_0_0# a_144_510# 0
C52 GND WL 0
C53 BLB a_288_4# 0.00345f
C54 m1_940_750# WL 0.00102f
C55 GND_uq0 w_0_500# 0.0078f
C56 GND_uq0 WL 0.00269f
C57 GND a_1024_34# 0.00774f
C58 a_344_34# a_144_34# 0.00248f
C59 m1_940_750# a_1024_34# 0.00136f
C60 BL VDD_uq0 0.02218f
C61 VDD_uq0 a_144_510# 0
C62 a_486_4# GND_uq0 0.03724f
C63 m1_0_0# w_0_500# 0.00366f
C64 m1_940_0# a_968_4# 0.01259f
C65 BLB a_968_4# 0.01385f
C66 m1_0_0# WL 0
C67 BL_uq0 a_88_4# 0.01643f
C68 a_88_4# WL 0.00761f
C69 VDD a_1024_510# 0
C70 BL BLB 0.01258f
C71 BLB a_144_510# 0
C72 a_144_34# m1_0_750# 0.00164f
C73 a_88_536# m1_0_0# 0.00113f
C74 VDD_uq0 w_0_500# 0.03731f
C75 VDD_uq0 WL 0.00625f
C76 BL_uq0 a_768_4# 0.00345f
C77 WL a_768_4# 0.01738f
C78 m1_940_0# w_0_500# 0
C79 VDD_uq0 a_486_4# 0.01096f
C80 BL_uq0 a_288_4# 0.02684f
C81 BLB w_0_500# 0.03802f
C82 a_288_4# WL 0.01738f
C83 BL_uq0 BLB 0.0522f
C84 m1_940_0# WL 0
C85 VDD m1_940_750# 0.11733f
C86 BLB WL 0.03127f
C87 a_824_34# GND_uq0 0.003f
C88 m1_0_750# a_1024_510# 0
C89 a_1024_34# m1_940_0# 0.00182f
C90 BLB a_1024_34# 0.00572f
C91 BLB a_486_4# 0.02246f
C92 GND a_968_536# 0.0016f
C93 a_344_34# GND_uq0 0.003f
C94 m1_940_750# a_968_536# 0.00545f
C95 WL a_968_4# 0.00761f
C96 BL BL_uq0 0.01258f
C97 w_0_500# a_144_510# 0.02803f
C98 a_176_536# m1_0_750# 0.00545f
C99 BL WL 0.0244f
C100 BL_uq0 a_144_510# 0.004f
C101 a_344_34# m1_0_0# 0
C102 VDD_uq0 a_824_34# 0
C103 a_144_34# m1_0_0# 0.00567f
C104 BL_uq0 w_0_500# 0.03809f
C105 WL w_0_500# 0.06285f
C106 VDD_uq0 a_344_34# 0
C107 GND a_1024_510# 0.00102f
C108 BL_uq0 WL 0.03127f
C109 a_824_34# m1_940_0# 0
C110 m1_940_750# a_1024_510# 0.00671f
C111 a_824_34# BLB 0.00877f
C112 m1_0_750# m1_0_0# 0.01525f
C113 a_1024_34# w_0_500# 0
C114 m1_0_750# a_88_4# 0.00538f
C115 BL_uq0 a_88_536# 0.00412f
C116 BL_uq0 a_486_4# 0.02246f
C117 a_486_4# WL 0.0334f
C118 a_344_34# BLB 0.0014f
C119 BLB a_968_536# 0.00509f
C120 VDD_uq0 m1_0_750# 0.01467f
C121 GND m1_940_750# 0.01676f
C122 GND GND_uq1 0.02893f
C123 VDD GND_uq1 0.12993f
C124 m1_940_0# GND_uq1 0.06827f ; **FLOATING
C125 GND_uq0 GND_uq1 0.11267f ; **FLOATING
C126 m1_0_0# GND_uq1 0.07811f ; **FLOATING
C127 BLB GND_uq1 0.12247f ; **FLOATING
C128 BL_uq0 GND_uq1 0.13109f ; **FLOATING
C129 m1_940_750# GND_uq1 0.02505f ; **FLOATING
C130 VDD_uq0 GND_uq1 0.10569f ; **FLOATING
C131 m1_0_750# GND_uq1 0.07159f ; **FLOATING
C132 WL GND_uq1 0.21498f ; **FLOATING
C133 a_968_4# GND_uq1 0.0166f
C134 a_768_4# GND_uq1 0.01717f
C135 a_288_4# GND_uq1 0.01717f
C136 a_88_4# GND_uq1 0.0166f
C137 a_1056_536# GND_uq1 0.0079f
C138 a_968_536# GND_uq1 0.0079f
C139 a_176_536# GND_uq1 0.0079f
C140 a_88_536# GND_uq1 0.0079f
C141 w_0_500# GND_uq1 1.08f
.ends
