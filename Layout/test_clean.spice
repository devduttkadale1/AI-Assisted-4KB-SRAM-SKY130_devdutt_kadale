* NGSPICE file created from sram_6t_cell.ext - technology: sky130A

.subckt sram_6t_cell VDD GND BL GND_uq1
X0 a_2532_40# a_2500_0# a_2400_40# GND_uq1 sky130_fd_pr__nfet_01v8 ad=0.324 pd=2.28 as=0.3 ps=2.2 w=0.6 l=0.16
X1 a_768_4# a_824_34# a_768_4# GND_uq1 sky130_fd_pr__nfet_01v8 ad=1.4534 pd=10.4 as=1.4534 ps=10.4 w=1.99 l=0.16
X2 a_88_4# a_144_34# a_88_4# GND_uq1 sky130_fd_pr__nfet_01v8 ad=1.4534 pd=10.4 as=1.4534 ps=10.4 w=1.99 l=0.16
X3 a_1056_536# a_1024_510# a_968_536# w_0_500# sky130_fd_pr__pfet_01v8 ad=0.3192 pd=2.84 as=0.3192 ps=2.84 w=1.14 l=0.16
X4 a_968_4# a_1024_34# a_968_4# GND_uq1 sky130_fd_pr__nfet_01v8 ad=1.4534 pd=10.4 as=1.4534 ps=10.4 w=1.99 l=0.16
X5 a_176_536# a_144_510# a_88_536# w_0_500# sky130_fd_pr__pfet_01v8 ad=0.3192 pd=2.84 as=0.3192 ps=2.84 w=1.14 l=0.16
X6 a_288_4# a_344_34# a_288_4# GND_uq1 sky130_fd_pr__nfet_01v8 ad=1.4534 pd=10.4 as=1.4534 ps=10.4 w=1.99 l=0.16
.ends
