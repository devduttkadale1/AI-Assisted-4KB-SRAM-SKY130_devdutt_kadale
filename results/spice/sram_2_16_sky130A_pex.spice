* NGSPICE file created from sram_2_16_sky130A_flat.ext - technology: sky130A

.subckt sram_2_16_sky130A_flat
X0 a_739_3829# din0[1] a_685_3829# w_431_3679# sky130_fd_pr__pfet_01v8 ad=0.3192 pd=2.44 as=0.3276 ps=2.46 w=0.84 l=0.15
X1 control_logic_rw_0.pnand2_1_0.nmos_m1_w0_840_sactive_dli_0.S control_logic_rw_0.pand2_0.Z a_n2515_1369# din0[1] sky130_fd_pr__nfet_01v8 ad=0.1848 pd=1.28 as=0.3276 ps=2.46 w=0.84 l=0.15
X2 a_n4427_9861# control_logic_rw_0.delay_chain_0.out a_n4480_9861# w_n5644_9540# sky130_fd_pr__pfet_01v8 ad=0.3276 pd=2.46 as=0.3192 ps=2.44 w=0.84 l=0.15
X3 a_n4741_6649# control_logic_rw_0.delay_chain_0.pinv_11_19.Z a_n4794_6649# w_n5644_6180# sky130_fd_pr__pfet_01v8 ad=0.3276 pd=2.46 as=0.3192 ps=2.44 w=0.84 l=0.15
X4 din0[1] bank_0.replica_bitcell_array_0.wl_0_13 bank_0.replica_bitcell_array_0.bitcell_array_0.cell_1rw_2.qb din0[1] sky130_fd_pr__nfet_01v8 ad=0.1428 pd=1.52 as=0.3864 ps=2.1 w=0.42 l=0.15
X5 bank_0.replica_bitcell_array_0.dummy_array_3_0.dummy_cell_1rw_8.q bank_0.replica_bitcell_array_0.dummy_array_3_0.dummy_cell_1rw_8.qb din0[1] din0[1] sky130_fd_pr__nfet_01v8 ad=0.3864 pd=2.1 as=0.441 ps=3.22 w=1.26 l=0.15
X6 bank_0.replica_bitcell_array_0.dummy_array_3_0.dummy_cell_1rw_13.q bank_0.replica_bitcell_array_0.dummy_array_3_0.dummy_cell_1rw_13.qb din0[1] din0[1] sky130_fd_pr__nfet_01v8 ad=0.3864 pd=2.1 as=0.441 ps=3.22 w=1.26 l=0.15
X7 a_n753_n919# control_logic_rw_0.pdriver_0_0.pinv_7_0.A a_n831_n919# din0[1] sky130_fd_pr__nfet_01v8 ad=0.1795 pd=1.2 as=0.1795 ps=1.2 w=0.57 l=0.15
X8 a_n4427_2449# control_logic_rw_0.delay_chain_0.pinv_11_44.Z a_n4480_2449# din0[1] sky130_fd_pr__nfet_01v8 ad=0.1638 pd=1.62 as=0.1596 ps=1.6 w=0.42 l=0.15
X9 din0[1] bank_0.replica_bitcell_array_0.wl_0_9 bank_0.replica_bitcell_array_0.bitcell_array_0.cell_1rw_22.qb din0[1] sky130_fd_pr__nfet_01v8 ad=0.1428 pd=1.52 as=0.3864 ps=2.1 w=0.42 l=0.15
X10 bank_0.replica_bitcell_array_0.replica_column_0.replica_cell_1rw_7.q din0[1] din0[1] din0[1] sky130_fd_pr__nfet_01v8 ad=0.3864 pd=2.1 as=0.441 ps=3.22 w=1.26 l=0.15
X11 a_739_6883# row_addr_dff_0.dout_2 a_685_6883# w_431_6733# sky130_fd_pr__pfet_01v8 ad=0.3192 pd=2.44 as=0.3276 ps=2.46 w=0.84 l=0.15
X12 a_2789_6373# bank_0.port_address_0.hierarchical_decoder_0.predecode_5 bank_0.port_address_0.hierarchical_decoder_0.and2_dec_10.pnand2_0.nmos_m1_w0_840_sactive_dli_0.S din0[1] sky130_fd_pr__nfet_01v8 ad=0.3192 pd=2.44 as=0.1848 ps=1.28 w=0.84 l=0.15
X13 bank_0.replica_bitcell_array_0.replica_column_0.replica_cell_1rw_12.q din0[1] din0[1] din0[1] sky130_fd_pr__nfet_01v8 ad=0.3864 pd=2.1 as=0.441 ps=3.22 w=1.26 l=0.15
X14 a_n3839_n661# control_logic_rw_0.dff_buf_array_0.dff_buf_0_1.pinv_0_0.A a_n3917_n661# w_n4225_n767# sky130_fd_pr__pfet_01v8 ad=0.3192 pd=2.44 as=0.2646 ps=1.47 w=0.84 l=0.15
X15 bank_0.port_address_0.hierarchical_decoder_0.and2_dec_15.pnand2_0.nmos_m1_w0_840_sactive_dli_0.S bank_0.port_address_0.hierarchical_decoder_0.predecode_0 a_2676_3467# din0[1] sky130_fd_pr__nfet_01v8 ad=0.1848 pd=1.28 as=0.3276 ps=2.46 w=0.84 l=0.15
X16 a_3797_7433# din0[1] a_3743_7433# din0[1] sky130_fd_pr__nfet_01v8 ad=0.1596 pd=1.6 as=0.1638 ps=1.62 w=0.42 l=0.15
X17 a_n2147_n661# control_logic_rw_0.pdriver_0_0.pinv_4_0.A a_n2201_n661# w_n2769_n767# sky130_fd_pr__pfet_01v8 ad=0.2646 pd=1.47 as=0.3276 ps=2.46 w=0.84 l=0.15
X18 a_n4741_9169# control_logic_rw_0.delay_chain_0.out a_n4794_9169# din0[1] sky130_fd_pr__nfet_01v8 ad=0.1638 pd=1.62 as=0.1596 ps=1.6 w=0.42 l=0.15
X19 row_addr_dff_0.dff_2.net4 row_addr_dff_0.dff_2.clkb row_addr_dff_0.dff_2.net3 din0[1] sky130_fd_pr__pfet_01v8 ad=0.2915 pd=1.61 as=0.352 ps=2.38 w=0.55 l=0.15
X20 bank_0.replica_bitcell_array_0.bitcell_array_0.cell_1rw_29.qb bank_0.replica_bitcell_array_0.wl_0_2 din0[1] din0[1] sky130_fd_pr__nfet_01v8 ad=0.3864 pd=2.1 as=0.1428 ps=1.52 w=0.42 l=0.15
X21 a_n3369_n227# control_logic_rw_0.dff_buf_array_0.dout_bar_0 a_n3447_n227# din0[1] sky130_fd_pr__nfet_01v8 ad=0.2128 pd=1.88 as=0.1764 ps=1.19 w=0.56 l=0.15
X22 a_n5369_8181# control_logic_rw_0.delay_chain_0.pinv_11_14.Z a_n5422_8181# w_n5644_7860# sky130_fd_pr__pfet_01v8 ad=0.3276 pd=2.46 as=0.3192 ps=2.44 w=0.84 l=0.15
X23 din0[1] bank_0.replica_bitcell_array_0.replica_column_0.replica_cell_1rw_11.q din0[1] din0[1] sky130_fd_pr__nfet_01v8 ad=0.3864 pd=2.1 as=157.76331 ps=1.18502k w=1.26 l=0.15
X24 din0[1] bank_0.replica_bitcell_array_0.replica_column_0.replica_cell_1rw_16.q din0[1] din0[1] sky130_fd_pr__nfet_01v8 ad=0.3864 pd=2.1 as=0 ps=0 w=1.26 l=0.15
X25 bank_0.replica_bitcell_array_0.bitcell_array_0.cell_1rw_0.q bank_0.replica_bitcell_array_0.bitcell_array_0.cell_1rw_0.qb din0[1] din0[1] sky130_fd_pr__pfet_01v8 ad=0.1925 pd=1.8 as=0.1925 ps=1.8 w=0.55 l=0.15
X26 bank_0.replica_bitcell_array_0.dummy_array_3_0.dummy_cell_1rw_4.qb bank_0.replica_bitcell_array_0.wl_0_12 a_5530_9619# din0[1] sky130_fd_pr__nfet_01v8 ad=0.3864 pd=2.1 as=0.1428 ps=1.52 w=0.42 l=0.15
X27 din0[1] bank_0.replica_bitcell_array_0.bitcell_array_0.cell_1rw_10.q bank_0.replica_bitcell_array_0.bitcell_array_0.cell_1rw_10.qb din0[1] sky130_fd_pr__nfet_01v8 ad=0.441 pd=3.22 as=0.3864 ps=2.1 w=1.26 l=0.15
X28 a_n1377_298# control_logic_rw_0.pdriver_1_0.pinv_6_0.A a_n1431_298# w_n2769_44# sky130_fd_pr__pfet_01v8 ad=0.3307 pd=1.68 as=0.4095 ps=2.88 w=1.05 l=0.15
X29 din0[1] row_addr_dff_0.dout_1 row_addr_dff_0.dff_2.net5 din0[1] sky130_fd_pr__nfet_01v8 ad=0.168 pd=1.22 as=0.2352 ps=1.96 w=0.42 l=0.15
X30 a_3483_10955# control_logic_rw_0.wl_en a_3424_10955# w_2422_10805# sky130_fd_pr__pfet_01v8 ad=0.3192 pd=2.44 as=0.1848 ps=1.28 w=0.84 l=0.15
X31 din0[1] bank_0.replica_bitcell_array_0.bitcell_array_0.cell_1rw_2.q bank_0.replica_bitcell_array_0.bitcell_array_0.cell_1rw_2.qb din0[1] sky130_fd_pr__pfet_01v8 ad=0.1925 pd=1.8 as=0.1925 ps=1.8 w=0.55 l=0.15
X32 bank_0.port_address_0.hierarchical_decoder_0.and2_dec_4.pnand2_0.nmos_m1_w0_840_sactive_dli_0.S bank_0.port_address_0.hierarchical_decoder_0.predecode_3 a_2676_9427# din0[1] sky130_fd_pr__nfet_01v8 ad=0.1848 pd=1.28 as=0.3276 ps=2.46 w=0.84 l=0.15
X33 a_3797_6011# din0[1] a_3743_6011# w_2422_5715# sky130_fd_pr__pfet_01v8 ad=0.3192 pd=2.44 as=0.3276 ps=2.46 w=0.84 l=0.15
X34 a_n5369_4969# control_logic_rw_0.delay_chain_0.pinv_11_29.Z a_n5422_4969# w_n5644_4500# sky130_fd_pr__pfet_01v8 ad=0.3276 pd=2.46 as=0.3192 ps=2.44 w=0.84 l=0.15
X35 a_4490_11469# bank_0.replica_bitcell_array_0.wl_0_15 bank_0.replica_bitcell_array_0.dummy_array_2_0.dummy_cell_1rw_1.qb din0[1] sky130_fd_pr__nfet_01v8 ad=0.1428 pd=1.52 as=0.3864 ps=2.1 w=0.42 l=0.15
X36 bank_0.port_address_0.wordline_driver_array_0.wordline_driver_11.pnand2_0.nmos_m1_w0_840_sli_dactiv_uq0 bank_0.port_address_0.wordline_driver_array_0.in_4 a_3370_5503# din0[1] sky130_fd_pr__nfet_01v8 ad=0.1848 pd=1.28 as=0.3276 ps=2.46 w=0.84 l=0.15
X37 din0[1] bank_0.replica_bitcell_array_0.wl_0_12 din0[1] din0[1] sky130_fd_pr__nfet_01v8 ad=0.3864 pd=2.1 as=0 ps=0 w=0.42 l=0.15
X38 din0[1] bank_0.replica_bitcell_array_0.dummy_array_2_0.dummy_cell_1rw_11.q bank_0.replica_bitcell_array_0.dummy_array_2_0.dummy_cell_1rw_11.qb din0[1] sky130_fd_pr__nfet_01v8 ad=0.441 pd=3.22 as=0.3864 ps=2.1 w=1.26 l=0.15
X39 a_n1352_n227# control_logic_rw_0.dff_buf_array_0.dout_bar_0 a_n1430_n227# din0[1] sky130_fd_pr__nfet_01v8 ad=0.1764 pd=1.19 as=0.1764 ps=1.19 w=0.56 l=0.15
X40 din0[1] din0[1] din0[1] din0[1] sky130_fd_pr__pfet_01v8 ad=0.0696 pd=0.9 as=92.5816 ps=881.59998 w=0.19 l=10m
X41 a_3103_3975# din0[1] a_3049_3975# w_2422_3679# sky130_fd_pr__pfet_01v8 ad=0.3192 pd=2.44 as=0.3276 ps=2.46 w=0.84 l=0.15
X42 a_n1723_599# control_logic_rw_0.pdriver_1_0.pinv_8_0.Z a_n1801_599# din0[1] sky130_fd_pr__nfet_01v8 ad=0.1596 pd=1.6 as=0.1323 ps=1.05 w=0.42 l=0.15
X43 a_n5369_7489# control_logic_rw_0.delay_chain_0.pinv_11_14.Z a_n5422_7489# din0[1] sky130_fd_pr__nfet_01v8 ad=0.1638 pd=1.62 as=0.1596 ps=1.6 w=0.42 l=0.15
X44 a_n1919_2223# control_logic_rw_0.dff_buf_array_0.dout_1 a_n1997_2223# din0[1] sky130_fd_pr__nfet_01v8 ad=0.1596 pd=1.6 as=0.1323 ps=1.05 w=0.42 l=0.15
X45 bank_0.replica_bitcell_array_0.dummy_array_3_0.dummy_cell_1rw_2.q bank_0.replica_bitcell_array_0.dummy_array_3_0.dummy_cell_1rw_2.qb din0[1] din0[1] sky130_fd_pr__pfet_01v8 ad=0.1925 pd=1.8 as=0.1925 ps=1.8 w=0.55 l=0.15
X46 bank_0.replica_bitcell_array_0.bitcell_array_0.cell_1rw_1.q bank_0.replica_bitcell_array_0.bitcell_array_0.cell_1rw_1.qb din0[1] din0[1] sky130_fd_pr__nfet_01v8 ad=0.3864 pd=2.1 as=0.441 ps=3.22 w=1.26 l=0.15
X47 a_n1588_n107# control_logic_rw_0.dff_buf_array_0.dout_bar_0 a_n1666_n107# din0[1] sky130_fd_pr__nfet_01v8 ad=0.1764 pd=1.19 as=0.1764 ps=1.19 w=0.56 l=0.15
X48 a_n2461_299# control_logic_rw_0.dff_buf_array_0.dout_bar_0 a_n2515_299# w_n2769_44# sky130_fd_pr__pfet_01v8 ad=0.3192 pd=2.44 as=0.3276 ps=2.46 w=0.84 l=0.15
X49 din0[1] bank_0.replica_bitcell_array_0.dummy_array_0.dummy_cell_1rw_0.q bank_0.replica_bitcell_array_0.dummy_array_0.dummy_cell_1rw_0.qb din0[1] sky130_fd_pr__pfet_01v8 ad=0.1925 pd=1.8 as=0.1925 ps=1.8 w=0.55 l=0.15
X50 din0[1] din0[1] din0[1] din0[1] sky130_fd_pr__nfet_01v8 ad=0.1823 pd=1.84 as=0 ps=0 w=0.33 l=0.08
X51 bank_0.replica_bitcell_array_0.dummy_array_3_0.dummy_cell_1rw_3.q bank_0.replica_bitcell_array_0.dummy_array_3_0.dummy_cell_1rw_3.qb din0[1] din0[1] sky130_fd_pr__pfet_01v8 ad=0.1925 pd=1.8 as=0.1925 ps=1.8 w=0.55 l=0.15
X52 bank_0.replica_bitcell_array_0.bitcell_array_0.cell_1rw_7.q bank_0.replica_bitcell_array_0.wl_0_8 din0[1] din0[1] sky130_fd_pr__nfet_01v8 ad=0.3864 pd=2.1 as=0.1428 ps=1.52 w=0.42 l=0.15
X53 a_n4427_6649# control_logic_rw_0.delay_chain_0.pinv_11_19.Z a_n4480_6649# w_n5644_6180# sky130_fd_pr__pfet_01v8 ad=0.3276 pd=2.46 as=0.3192 ps=2.44 w=0.84 l=0.15
X54 control_logic_rw_0.dff_buf_array_0.dff_buf_0_0.dff_0.net4 din0[1] control_logic_rw_0.dff_buf_array_0.dff_buf_0_0.dff_0.net3 din0[1] sky130_fd_pr__nfet_01v8 ad=0.2226 pd=1.48 as=0.273 ps=2.14 w=0.42 l=0.15
X55 a_n1567_n919# control_logic_rw_0.pdriver_0_0.pinv_6_0.A a_n1645_n919# din0[1] sky130_fd_pr__nfet_01v8 ad=0.1638 pd=1.15 as=0.1638 ps=1.15 w=0.52 l=0.15
X56 a_4793_1712# control_logic_rw_0.p_en_bar a_4739_1712# w_4605_1519# sky130_fd_pr__pfet_01v8 ad=0.3192 pd=2.44 as=0.3276 ps=2.46 w=0.84 l=0.15
X57 din0[1] bank_0.replica_bitcell_array_0.dummy_array_2_0.dummy_cell_1rw_17.q bank_0.replica_bitcell_array_0.dummy_array_2_0.dummy_cell_1rw_17.qb din0[1] sky130_fd_pr__pfet_01v8 ad=0.1925 pd=1.8 as=0.1925 ps=1.8 w=0.55 l=0.15
X58 din0[1] bank_0.replica_bitcell_array_0.wl_0_13 din0[1] din0[1] sky130_fd_pr__nfet_01v8 ad=0.1428 pd=1.52 as=0 ps=0 w=0.42 l=0.15
X59 a_n1763_927# control_logic_rw_0.dff_buf_array_0.dout_bar_0 a_n1841_927# w_n2769_857# sky130_fd_pr__pfet_01v8 ad=0.378 pd=1.83 as=0.378 ps=1.83 w=1.2 l=0.15
X60 a_3103_8919# din0[1] a_3049_8919# w_2422_8769# sky130_fd_pr__pfet_01v8 ad=0.3192 pd=2.44 as=0.3276 ps=2.46 w=0.84 l=0.15
X61 bank_0.replica_bitcell_array_0.dummy_array_2_0.dummy_cell_1rw_8.q bank_0.replica_bitcell_array_0.wl_0_8 a_4421_7583# din0[1] sky130_fd_pr__nfet_01v8 ad=0.3864 pd=2.1 as=0.1428 ps=1.52 w=0.42 l=0.15
X62 a_3483_4485# control_logic_rw_0.wl_en bank_0.port_address_0.wordline_driver_array_0.wordline_driver_13.pnand2_0.nmos_m1_w0_840_sli_dactiv_uq0 din0[1] sky130_fd_pr__nfet_01v8 ad=0.3192 pd=2.44 as=0.1848 ps=1.28 w=0.84 l=0.15
X63 a_3797_10955# din0[1] a_3743_10955# w_2422_10805# sky130_fd_pr__pfet_01v8 ad=0.3192 pd=2.44 as=0.3276 ps=2.46 w=0.84 l=0.15
X64 a_3797_9469# din0[1] a_3743_9469# din0[1] sky130_fd_pr__nfet_01v8 ad=0.1596 pd=1.6 as=0.1638 ps=1.62 w=0.42 l=0.15
X65 bank_0.replica_bitcell_array_0.bitcell_array_0.cell_1rw_25.qb bank_0.replica_bitcell_array_0.wl_0_6 din0[1] din0[1] sky130_fd_pr__nfet_01v8 ad=0.3864 pd=2.1 as=0.1428 ps=1.52 w=0.42 l=0.15
X66 bank_0.replica_bitcell_array_0.bitcell_array_0.cell_1rw_29.q bank_0.replica_bitcell_array_0.bitcell_array_0.cell_1rw_29.qb din0[1] din0[1] sky130_fd_pr__pfet_01v8 ad=0.1925 pd=1.8 as=0.1925 ps=1.8 w=0.55 l=0.15
X67 a_2730_10083# bank_0.port_address_0.hierarchical_decoder_0.predecode_1 a_2676_10083# w_2422_9787# sky130_fd_pr__pfet_01v8 ad=0.1848 pd=1.28 as=0.3276 ps=2.46 w=0.84 l=0.15
X68 bank_0.replica_bitcell_array_0.dummy_array_3_0.dummy_cell_1rw_8.q bank_0.replica_bitcell_array_0.dummy_array_3_0.dummy_cell_1rw_8.qb din0[1] din0[1] sky130_fd_pr__pfet_01v8 ad=0.1925 pd=1.8 as=0.1925 ps=1.8 w=0.55 l=0.15
X69 bank_0.replica_bitcell_array_0.bitcell_array_0.cell_1rw_15.qb bank_0.replica_bitcell_array_0.wl_0_0 din0[1] din0[1] sky130_fd_pr__nfet_01v8 ad=0.3864 pd=2.1 as=0.1428 ps=1.52 w=0.42 l=0.15
X70 a_n4427_9169# control_logic_rw_0.delay_chain_0.out a_n4480_9169# din0[1] sky130_fd_pr__nfet_01v8 ad=0.1638 pd=1.62 as=0.1596 ps=1.6 w=0.42 l=0.15
X71 din0[1] bank_0.replica_bitcell_array_0.replica_column_0.replica_cell_1rw_7.q din0[1] din0[1] sky130_fd_pr__nfet_01v8 ad=0.3864 pd=2.1 as=0 ps=0 w=1.26 l=0.15
X72 din0[1] bank_0.replica_bitcell_array_0.replica_column_0.replica_cell_1rw_12.q din0[1] din0[1] sky130_fd_pr__nfet_01v8 ad=0.3864 pd=2.1 as=0 ps=0 w=1.26 l=0.15
X73 a_3483_10445# control_logic_rw_0.wl_en bank_0.port_address_0.wordline_driver_array_0.wordline_driver_2.pnand2_0.nmos_m1_w0_840_sli_dactive_uq0 din0[1] sky130_fd_pr__nfet_01v8 ad=0.3192 pd=2.44 as=0.1848 ps=1.28 w=0.84 l=0.15
X74 a_1822_7433# din0[1] a_1768_7433# din0[1] sky130_fd_pr__nfet_01v8 ad=0.1596 pd=1.6 as=0.1638 ps=1.62 w=0.42 l=0.15
X75 data_dff_0.dff_1.clkb din0[1] din0[1] din0[1] sky130_fd_pr__pfet_01v8 ad=0.253 pd=2.02 as=0.253 ps=2.02 w=0.55 l=0.15
X76 a_3797_8047# din0[1] a_3743_8047# w_2422_7751# sky130_fd_pr__pfet_01v8 ad=0.3192 pd=2.44 as=0.3276 ps=2.46 w=0.84 l=0.15
X77 bank_0.replica_bitcell_array_0.replica_column_0.replica_cell_1rw_7.q din0[1] din0[1] din0[1] sky130_fd_pr__pfet_01v8 ad=0.1925 pd=1.8 as=0.1925 ps=1.8 w=0.55 l=0.15
X78 bank_0.replica_bitcell_array_0.dummy_array_2_0.dummy_cell_1rw_16.qb bank_0.replica_bitcell_array_0.wl_0_0 a_4490_3511# din0[1] sky130_fd_pr__nfet_01v8 ad=0.3864 pd=2.1 as=0.1428 ps=1.52 w=0.42 l=0.15
X79 a_3797_3829# din0[1] a_3743_3829# w_2422_3679# sky130_fd_pr__pfet_01v8 ad=0.3192 pd=2.44 as=0.3276 ps=2.46 w=0.84 l=0.15
X80 control_logic_rw_0.dff_buf_array_0.dff_buf_0_0.dff_0.net3 control_logic_rw_0.dff_buf_array_0.dff_buf_0_0.dff_0.net1 din0[1] din0[1] sky130_fd_pr__pfet_01v8 ad=0.3465 pd=2.36 as=0.22 ps=1.35 w=0.55 l=0.15
X81 bank_0.replica_bitcell_array_0.dummy_array_2_0.dummy_cell_1rw_0.q bank_0.replica_bitcell_array_0.dummy_array_2_0.dummy_cell_1rw_0.qb din0[1] din0[1] sky130_fd_pr__pfet_01v8 ad=0.1925 pd=1.8 as=0.1925 ps=1.8 w=0.55 l=0.15
X82 a_3424_9065# bank_0.port_address_0.wordline_driver_array_0.in_11 a_3370_9065# w_2422_8769# sky130_fd_pr__pfet_01v8 ad=0.1848 pd=1.28 as=0.3276 ps=2.46 w=0.84 l=0.15
X83 bank_0.port_address_0.wordline_driver_array_0.wordline_driver_7.pnand2_0.nmos_m1_w0_840_sli_dactive_uq0 bank_0.port_address_0.wordline_driver_array_0.in_8 a_3370_7539# din0[1] sky130_fd_pr__nfet_01v8 ad=0.1848 pd=1.28 as=0.3276 ps=2.46 w=0.84 l=0.15
X84 din0[1] bank_0.replica_bitcell_array_0.wl_0_15 bank_0.replica_bitcell_array_0.bitcell_array_0.cell_1rw_0.q din0[1] sky130_fd_pr__nfet_01v8 ad=0.1428 pd=1.52 as=0.3864 ps=2.1 w=0.42 l=0.15
X85 a_3424_4847# bank_0.port_address_0.wordline_driver_array_0.in_2 a_3370_4847# w_2422_4697# sky130_fd_pr__pfet_01v8 ad=0.1848 pd=1.28 as=0.3276 ps=2.46 w=0.84 l=0.15
X86 din0[1] bank_0.replica_bitcell_array_0.bitcell_array_0.cell_1rw_31.q bank_0.replica_bitcell_array_0.bitcell_array_0.cell_1rw_31.qb din0[1] sky130_fd_pr__pfet_01v8 ad=0.1925 pd=1.8 as=0.1925 ps=1.8 w=0.55 l=0.15
X87 bank_0.replica_bitcell_array_0.replica_column_0.replica_cell_1rw_0.q din0[1] din0[1] din0[1] sky130_fd_pr__pfet_01v8 ad=0.1925 pd=1.8 as=0.1925 ps=1.8 w=0.55 l=0.15
X88 din0[1] bank_0.replica_bitcell_array_0.bitcell_array_0.cell_1rw_27.q bank_0.replica_bitcell_array_0.bitcell_array_0.cell_1rw_27.qb din0[1] sky130_fd_pr__nfet_01v8 ad=0.441 pd=3.22 as=0.3864 ps=2.1 w=1.26 l=0.15
X89 a_3103_5397# din0[1] a_3049_5397# din0[1] sky130_fd_pr__nfet_01v8 ad=0.1596 pd=1.6 as=0.1638 ps=1.62 w=0.42 l=0.15
X90 a_3103_10083# din0[1] a_3049_10083# w_2422_9787# sky130_fd_pr__pfet_01v8 ad=0.3192 pd=2.44 as=0.3276 ps=2.46 w=0.84 l=0.15
X91 din0[1] bank_0.replica_bitcell_array_0.dummy_array_0.dummy_cell_1rw_1.q bank_0.replica_bitcell_array_0.dummy_array_0.dummy_cell_1rw_1.qb din0[1] sky130_fd_pr__nfet_01v8 ad=0.441 pd=3.22 as=0.3864 ps=2.1 w=1.26 l=0.15
X92 din0[1] bank_0.replica_bitcell_array_0.dummy_array_3_0.dummy_cell_1rw_6.q bank_0.replica_bitcell_array_0.dummy_array_3_0.dummy_cell_1rw_6.qb din0[1] sky130_fd_pr__pfet_01v8 ad=0.1925 pd=1.8 as=0.1925 ps=1.8 w=0.55 l=0.15
X93 a_n1065_n691# control_logic_rw_0.pdriver_0_0.pinv_7_0.A a_n1143_n691# w_n2769_n767# sky130_fd_pr__pfet_01v8 ad=0.3622 pd=1.78 as=0.3622 ps=1.78 w=1.15 l=0.15
X94 bank_0.replica_bitcell_array_0.bitcell_array_0.cell_1rw_24.q bank_0.replica_bitcell_array_0.bitcell_array_0.cell_1rw_24.qb din0[1] din0[1] sky130_fd_pr__pfet_01v8 ad=0.1925 pd=1.8 as=0.1925 ps=1.8 w=0.55 l=0.15
X95 data_dff_0.dff_1.clkb din0[1] din0[1] din0[1] sky130_fd_pr__nfet_01v8 ad=0.1932 pd=1.76 as=0.1932 ps=1.76 w=0.42 l=0.15
X96 din0[1] bank_0.replica_bitcell_array_0.dummy_array_0_0.dummy_cell_1rw_0.q bank_0.replica_bitcell_array_0.dummy_array_0_0.dummy_cell_1rw_0.qb din0[1] sky130_fd_pr__pfet_01v8 ad=0.1925 pd=1.8 as=0.1925 ps=1.8 w=0.55 l=0.15
X97 a_3797_9575# din0[1] a_3743_9575# din0[1] sky130_fd_pr__nfet_01v8 ad=0.1596 pd=1.6 as=0.1638 ps=1.62 w=0.42 l=0.15
X98 din0[1] bank_0.replica_bitcell_array_0.dummy_array_3_0.dummy_cell_1rw_7.q bank_0.replica_bitcell_array_0.dummy_array_3_0.dummy_cell_1rw_7.qb din0[1] sky130_fd_pr__nfet_01v8 ad=0.441 pd=3.22 as=0.3864 ps=2.1 w=1.26 l=0.15
X99 data_dff_0.dff_0.net2 data_dff_0.dff_0.clkb data_dff_0.dff_0.net1 din0[1] sky130_fd_pr__pfet_01v8 ad=0.374 pd=2.46 as=0.2915 ps=1.61 w=0.55 l=0.15
X100 a_3797_6883# din0[1] a_3743_6883# w_2422_6733# sky130_fd_pr__pfet_01v8 ad=0.3192 pd=2.44 as=0.3276 ps=2.46 w=0.84 l=0.15
X101 bank_0.replica_bitcell_array_0.bitcell_array_0.cell_1rw_2.q bank_0.replica_bitcell_array_0.bitcell_array_0.cell_1rw_2.qb din0[1] din0[1] sky130_fd_pr__nfet_01v8 ad=0.3864 pd=2.1 as=0.441 ps=3.22 w=1.26 l=0.15
X102 din0[1] bank_0.replica_bitcell_array_0.replica_column_0.replica_cell_1rw_5.q din0[1] din0[1] sky130_fd_pr__pfet_01v8 ad=0.1925 pd=1.8 as=0 ps=0 w=0.55 l=0.15
X103 a_5530_6379# bank_0.replica_bitcell_array_0.wl_0_5 bank_0.replica_bitcell_array_0.dummy_array_3_0.dummy_cell_1rw_11.qb din0[1] sky130_fd_pr__nfet_01v8 ad=0.1428 pd=1.52 as=0.3864 ps=2.1 w=0.42 l=0.15
X104 row_addr_dff_0.dff_1.net2 row_addr_dff_0.dff_3.clk row_addr_dff_0.dff_1.net1 din0[1] sky130_fd_pr__nfet_01v8 ad=0.2856 pd=2.2 as=0.2226 ps=1.48 w=0.42 l=0.15
X105 din0[1] bank_0.replica_bitcell_array_0.wl_0_5 din0[1] din0[1] sky130_fd_pr__nfet_01v8 ad=0.1428 pd=1.52 as=0 ps=0 w=0.42 l=0.15
X106 a_n2088_1411# control_logic_rw_0.delay_chain_0.out a_n2142_1411# din0[1] sky130_fd_pr__nfet_01v8 ad=0.1596 pd=1.6 as=0.1638 ps=1.62 w=0.42 l=0.15
X107 bank_0.replica_bitcell_array_0.bitcell_array_0.cell_1rw_31.q bank_0.replica_bitcell_array_0.wl_0_0 din0[1] din0[1] sky130_fd_pr__nfet_01v8 ad=0.3864 pd=2.1 as=0.1428 ps=1.52 w=0.42 l=0.15
X108 bank_0.replica_bitcell_array_0.bitcell_array_0.cell_1rw_17.q bank_0.replica_bitcell_array_0.bitcell_array_0.cell_1rw_17.qb din0[1] din0[1] sky130_fd_pr__pfet_01v8 ad=0.1925 pd=1.8 as=0.1925 ps=1.8 w=0.55 l=0.15
X109 bank_0.replica_bitcell_array_0.replica_column_0.replica_cell_1rw_1.q din0[1] din0[1] din0[1] sky130_fd_pr__nfet_01v8 ad=0.3864 pd=2.1 as=0.441 ps=3.22 w=1.26 l=0.15
X110 din0[1] bank_0.replica_bitcell_array_0.wl_0_11 bank_0.replica_bitcell_array_0.bitcell_array_0.cell_1rw_4.qb din0[1] sky130_fd_pr__nfet_01v8 ad=0.1428 pd=1.52 as=0.3864 ps=2.1 w=0.42 l=0.15
X111 a_1508_7539# row_addr_dff_0.dout_3 bank_0.port_address_0.hierarchical_decoder_0.hierarchical_predecode2x4_0.and2_dec_1.pnand2_0.nmos_m_uq0 din0[1] sky130_fd_pr__nfet_01v8 ad=0.3192 pd=2.44 as=0.1848 ps=1.28 w=0.84 l=0.15
X112 a_1508_4847# row_addr_dff_0.dout_1 a_1449_4847# w_1141_4697# sky130_fd_pr__pfet_01v8 ad=0.3192 pd=2.44 as=0.1848 ps=1.28 w=0.84 l=0.15
X113 control_logic_rw_0.pand3_0.pnand3_0_0.nmos_m1_w0_840_sactive_dactive_0.S control_logic_rw_0.dff_buf_array_0.dout_bar_0 a_n2515_705# din0[1] sky130_fd_pr__nfet_01v8 ad=0.1848 pd=1.28 as=0.3276 ps=2.46 w=0.84 l=0.15
X114 bank_0.replica_bitcell_array_0.bitcell_array_0.cell_1rw_17.qb bank_0.replica_bitcell_array_0.wl_0_14 din0[1] din0[1] sky130_fd_pr__nfet_01v8 ad=0.3864 pd=2.1 as=0.1428 ps=1.52 w=0.42 l=0.15
X115 data_dff_0.dff_0.net2 din0[1] data_dff_0.dff_0.net1 din0[1] sky130_fd_pr__nfet_01v8 ad=0.2856 pd=2.2 as=0.2226 ps=1.48 w=0.42 l=0.15
X116 din0[1] din0[1] din0[1] din0[1] sky130_fd_pr__nfet_01v8 ad=0.1936 pd=1.34 as=0 ps=0 w=0.57 l=0.15
X117 a_n441_n691# control_logic_rw_0.pdriver_0_0.pinv_7_0.A a_n519_n691# w_n2769_n767# sky130_fd_pr__pfet_01v8 ad=0.3622 pd=1.78 as=0.3622 ps=1.78 w=1.15 l=0.15
X118 bank_0.replica_bitcell_array_0.bitcell_array_0.cell_1rw_18.q bank_0.replica_bitcell_array_0.bitcell_array_0.cell_1rw_18.qb din0[1] din0[1] sky130_fd_pr__pfet_01v8 ad=0.1925 pd=1.8 as=0.1925 ps=1.8 w=0.55 l=0.15
X119 a_4490_9433# bank_0.replica_bitcell_array_0.wl_0_11 bank_0.replica_bitcell_array_0.dummy_array_2_0.dummy_cell_1rw_5.qb din0[1] sky130_fd_pr__nfet_01v8 ad=0.1428 pd=1.52 as=0.3864 ps=2.1 w=0.42 l=0.15
X120 a_n5055_7383# control_logic_rw_0.delay_chain_0.pinv_11_19.Z a_n5108_7383# din0[1] sky130_fd_pr__nfet_01v8 ad=0.1638 pd=1.62 as=0.1596 ps=1.6 w=0.42 l=0.15
X121 a_n5055_6501# control_logic_rw_0.delay_chain_0.pinv_11_24.Z a_n5108_6501# w_n5644_6180# sky130_fd_pr__pfet_01v8 ad=0.3276 pd=2.46 as=0.3192 ps=2.44 w=0.84 l=0.15
X122 bank_0.replica_bitcell_array_0.dummy_array_3_0.dummy_cell_1rw_4.q bank_0.replica_bitcell_array_0.dummy_array_3_0.dummy_cell_1rw_4.qb din0[1] din0[1] sky130_fd_pr__nfet_01v8 ad=0.3864 pd=2.1 as=0.441 ps=3.22 w=1.26 l=0.15
X123 bank_0.replica_bitcell_array_0.dummy_array_3_0.dummy_cell_1rw_9.q bank_0.replica_bitcell_array_0.dummy_array_3_0.dummy_cell_1rw_9.qb din0[1] din0[1] sky130_fd_pr__nfet_01v8 ad=0.3864 pd=2.1 as=0.441 ps=3.22 w=1.26 l=0.15
X124 bank_0.replica_bitcell_array_0.bitcell_array_0.cell_1rw_25.q bank_0.replica_bitcell_array_0.bitcell_array_0.cell_1rw_25.qb din0[1] din0[1] sky130_fd_pr__pfet_01v8 ad=0.1925 pd=1.8 as=0.1925 ps=1.8 w=0.55 l=0.15
X125 din0[1] bank_0.replica_bitcell_array_0.bitcell_array_0.cell_1rw_26.q bank_0.replica_bitcell_array_0.bitcell_array_0.cell_1rw_26.qb din0[1] sky130_fd_pr__pfet_01v8 ad=0.1925 pd=1.8 as=0.1925 ps=1.8 w=0.55 l=0.15
X126 control_logic_rw_0.pand2_1.pnand2_0_0.nmos_m1_w0_840_sactive_dli_0.S control_logic_rw_0.pinv_3_1.Z a_n2201_n255# din0[1] sky130_fd_pr__nfet_01v8 ad=0.1848 pd=1.28 as=0.3276 ps=2.46 w=0.84 l=0.15
X127 din0[1] control_logic_rw_0.dff_buf_array_0.dff_buf_0_0.dff_0.net3 control_logic_rw_0.dff_buf_array_0.dff_buf_0_0.dff_0.net2 din0[1] sky130_fd_pr__pfet_01v8 ad=0.22 pd=1.35 as=0.2915 ps=2.16 w=0.55 l=0.15
X128 a_n4741_5703# control_logic_rw_0.delay_chain_0.pinv_11_29.Z a_n4794_5703# din0[1] sky130_fd_pr__nfet_01v8 ad=0.1638 pd=1.62 as=0.1596 ps=1.6 w=0.42 l=0.15
X129 din0[1] bank_0.replica_bitcell_array_0.replica_column_0.replica_cell_1rw_0.q din0[1] din0[1] sky130_fd_pr__pfet_01v8 ad=0.1925 pd=1.8 as=0 ps=0 w=0.55 l=0.15
X130 bank_0.replica_bitcell_array_0.replica_column_0.replica_cell_1rw_3.q din0[1] din0[1] din0[1] sky130_fd_pr__nfet_01v8 ad=0.3864 pd=2.1 as=0.441 ps=3.22 w=1.26 l=0.15
X131 bank_0.replica_bitcell_array_0.dummy_array_3_0.dummy_cell_1rw_4.q bank_0.replica_bitcell_array_0.wl_0_12 a_5461_9619# din0[1] sky130_fd_pr__nfet_01v8 ad=0.3864 pd=2.1 as=0.1428 ps=1.52 w=0.42 l=0.15
X132 bank_0.replica_bitcell_array_0.replica_column_0.replica_cell_1rw_8.q din0[1] din0[1] din0[1] sky130_fd_pr__nfet_01v8 ad=0.3864 pd=2.1 as=0.441 ps=3.22 w=1.26 l=0.15
X133 a_n4741_3289# control_logic_rw_0.delay_chain_0.pinv_11_39.Z a_n4794_3289# w_n5644_2820# sky130_fd_pr__pfet_01v8 ad=0.3276 pd=2.46 as=0.3192 ps=2.44 w=0.84 l=0.15
X134 bank_0.replica_bitcell_array_0.dummy_array_2_0.dummy_cell_1rw_1.q bank_0.replica_bitcell_array_0.dummy_array_2_0.dummy_cell_1rw_1.qb din0[1] din0[1] sky130_fd_pr__nfet_01v8 ad=0.3864 pd=2.1 as=0.441 ps=3.22 w=1.26 l=0.15
X135 bank_0.port_address_0.hierarchical_decoder_0.and2_dec_11.pnand2_0.nmos_m1_w0_840_sactive_dli_0.S bank_0.port_address_0.hierarchical_decoder_0.predecode_0 a_2676_5503# din0[1] sky130_fd_pr__nfet_01v8 ad=0.1848 pd=1.28 as=0.3276 ps=2.46 w=0.84 l=0.15
X136 din0[1] din0[1] din0[1] din0[1] sky130_fd_pr__nfet_01v8 ad=0.2751 pd=1.65 as=0 ps=0 w=0.42 l=0.15
X137 bank_0.replica_bitcell_array_0.dummy_array_3_0.dummy_cell_1rw_0.q bank_0.replica_bitcell_array_0.dummy_array_3_0.dummy_cell_1rw_0.qb din0[1] din0[1] sky130_fd_pr__nfet_01v8 ad=0.3864 pd=2.1 as=0.441 ps=3.22 w=1.26 l=0.15
X138 din0[1] bank_0.replica_bitcell_array_0.wl_0_1 bank_0.replica_bitcell_array_0.bitcell_array_0.cell_1rw_14.q din0[1] sky130_fd_pr__nfet_01v8 ad=0.1428 pd=1.52 as=0.3864 ps=2.1 w=0.42 l=0.15
X139 a_n2402_n107# control_logic_rw_0.pand2_0.pnand2_0_0.nmos_m1_w0_840_sactive_dli_0.G control_logic_rw_0.pand2_0.pnand2_0_0.nmos_m1_w0_840_sactive_dli_0.S din0[1] sky130_fd_pr__nfet_01v8 ad=0.3192 pd=2.44 as=0.1848 ps=1.28 w=0.84 l=0.15
X140 din0[1] bank_0.replica_bitcell_array_0.wl_0_13 bank_0.replica_bitcell_array_0.replica_column_0.replica_cell_1rw_2.q din0[1] sky130_fd_pr__nfet_01v8 ad=0.1428 pd=1.52 as=0.3864 ps=2.1 w=0.42 l=0.15
X141 bank_0.replica_bitcell_array_0.bitcell_array_0.cell_1rw_13.q bank_0.replica_bitcell_array_0.bitcell_array_0.cell_1rw_13.qb din0[1] din0[1] sky130_fd_pr__pfet_01v8 ad=0.1925 pd=1.8 as=0.1925 ps=1.8 w=0.55 l=0.15
X142 bank_0.port_address_0.wordline_driver_array_0.wordline_driver_14.pnand2_0.nmos_m1_w0_840_sli_dactiv_uq0 bank_0.port_address_0.wordline_driver_array_0.in_1 a_3370_4337# din0[1] sky130_fd_pr__nfet_01v8 ad=0.1848 pd=1.28 as=0.3276 ps=2.46 w=0.84 l=0.15
X143 a_n1997_705# control_logic_rw_0.dff_buf_array_0.dout_bar_0 a_n2051_705# din0[1] sky130_fd_pr__nfet_01v8 ad=0.189 pd=1.23 as=0.234 ps=1.98 w=0.6 l=0.15
X144 bank_0.replica_bitcell_array_0.replica_column_0.replica_cell_1rw_3.q bank_0.replica_bitcell_array_0.wl_0_12 din0[1] din0[1] sky130_fd_pr__nfet_01v8 ad=0.3864 pd=2.1 as=0.1428 ps=1.52 w=0.42 l=0.15
X145 din0[1] bank_0.replica_bitcell_array_0.bitcell_array_0.cell_1rw_20.q bank_0.replica_bitcell_array_0.bitcell_array_0.cell_1rw_20.qb din0[1] sky130_fd_pr__pfet_01v8 ad=0.1925 pd=1.8 as=0.1925 ps=1.8 w=0.55 l=0.15
X146 din0[1] bank_0.replica_bitcell_array_0.bitcell_array_0.cell_1rw_27.q bank_0.replica_bitcell_array_0.bitcell_array_0.cell_1rw_27.qb din0[1] sky130_fd_pr__pfet_01v8 ad=0.1925 pd=1.8 as=0.1925 ps=1.8 w=0.55 l=0.15
X147 a_1822_8047# din0[1] a_1768_8047# w_1141_7751# sky130_fd_pr__pfet_01v8 ad=0.3192 pd=2.44 as=0.3276 ps=2.46 w=0.84 l=0.15
X148 a_4421_4343# bank_0.replica_bitcell_array_0.wl_0_1 bank_0.replica_bitcell_array_0.dummy_array_2_0.dummy_cell_1rw_15.q din0[1] sky130_fd_pr__nfet_01v8 ad=0.1428 pd=1.52 as=0.3864 ps=2.1 w=0.42 l=0.15
X149 din0[1] bank_0.replica_bitcell_array_0.bitcell_array_0.cell_1rw_23.q bank_0.replica_bitcell_array_0.bitcell_array_0.cell_1rw_23.qb din0[1] sky130_fd_pr__nfet_01v8 ad=0.441 pd=3.22 as=0.3864 ps=2.1 w=1.26 l=0.15
X150 din0[1] bank_0.replica_bitcell_array_0.bitcell_array_0.cell_1rw_28.q bank_0.replica_bitcell_array_0.bitcell_array_0.cell_1rw_28.qb din0[1] sky130_fd_pr__nfet_01v8 ad=0.441 pd=3.22 as=0.3864 ps=2.1 w=1.26 l=0.15
X151 bank_0.replica_bitcell_array_0.dummy_array_2_0.dummy_cell_1rw_14.q bank_0.replica_bitcell_array_0.dummy_array_2_0.dummy_cell_1rw_14.qb din0[1] din0[1] sky130_fd_pr__pfet_01v8 ad=0.1925 pd=1.8 as=0.1925 ps=1.8 w=0.55 l=0.15
X152 a_1822_3829# din0[1] a_1768_3829# w_1141_3679# sky130_fd_pr__pfet_01v8 ad=0.3192 pd=2.44 as=0.3276 ps=2.46 w=0.84 l=0.15
X153 a_n5055_5809# control_logic_rw_0.delay_chain_0.pinv_11_24.Z a_n5108_5809# din0[1] sky130_fd_pr__nfet_01v8 ad=0.1638 pd=1.62 as=0.1596 ps=1.6 w=0.42 l=0.15
X154 din0[1] bank_0.replica_bitcell_array_0.replica_column_0.replica_cell_1rw_1.q din0[1] din0[1] sky130_fd_pr__pfet_01v8 ad=0.1925 pd=1.8 as=0 ps=0 w=0.55 l=0.15
X155 bank_0.replica_bitcell_array_0.bitcell_array_0.cell_1rw_20.q bank_0.replica_bitcell_array_0.bitcell_array_0.cell_1rw_20.qb din0[1] din0[1] sky130_fd_pr__pfet_01v8 ad=0.1925 pd=1.8 as=0.1925 ps=1.8 w=0.55 l=0.15
X156 a_n4113_9063# control_logic_rw_0.delay_chain_0.pinv_11_14.Z a_n4166_9063# din0[1] sky130_fd_pr__nfet_01v8 ad=0.1638 pd=1.62 as=0.1596 ps=1.6 w=0.42 l=0.15
X157 din0[1] bank_0.replica_bitcell_array_0.wl_0_11 bank_0.replica_bitcell_array_0.bitcell_array_0.cell_1rw_20.q din0[1] sky130_fd_pr__nfet_01v8 ad=0.1428 pd=1.52 as=0.3864 ps=2.1 w=0.42 l=0.15
X158 din0[1] bank_0.replica_bitcell_array_0.wl_0_7 bank_0.replica_bitcell_array_0.bitcell_array_0.cell_1rw_8.q din0[1] sky130_fd_pr__nfet_01v8 ad=0.1428 pd=1.52 as=0.3864 ps=2.1 w=0.42 l=0.15
X159 row_addr_dff_0.dff_0.net3 row_addr_dff_0.dff_0.net1 din0[1] din0[1] sky130_fd_pr__pfet_01v8 ad=0.3465 pd=2.36 as=0.22 ps=1.35 w=0.55 l=0.15
X160 bank_0.port_address_0.wordline_driver_array_0.wordline_driver_8.pnand2_0.nmos_m1_w0_840_sli_dactive_uq0 bank_0.port_address_0.wordline_driver_array_0.in_7 a_3370_7391# din0[1] sky130_fd_pr__nfet_01v8 ad=0.1848 pd=1.28 as=0.3276 ps=2.46 w=0.84 l=0.15
X161 a_n675_n919# control_logic_rw_0.pdriver_0_0.pinv_7_0.A a_n753_n919# din0[1] sky130_fd_pr__nfet_01v8 ad=0.1795 pd=1.2 as=0.1795 ps=1.2 w=0.57 l=0.15
X162 a_n1196_n513# control_logic_rw_0.dff_buf_array_0.dout_bar_0 a_n1274_n513# w_n2769_n767# sky130_fd_pr__pfet_01v8 ad=0.3528 pd=1.75 as=0.3528 ps=1.75 w=1.12 l=0.15
X163 a_4421_7397# bank_0.replica_bitcell_array_0.wl_0_7 bank_0.replica_bitcell_array_0.dummy_array_2_0.dummy_cell_1rw_9.q din0[1] sky130_fd_pr__nfet_01v8 ad=0.1428 pd=1.52 as=0.3864 ps=2.1 w=0.42 l=0.15
X164 bank_0.replica_bitcell_array_0.bitcell_array_0.cell_1rw_8.q bank_0.replica_bitcell_array_0.bitcell_array_0.cell_1rw_8.qb din0[1] din0[1] sky130_fd_pr__pfet_01v8 ad=0.1925 pd=1.8 as=0.1925 ps=1.8 w=0.55 l=0.15
X165 a_1822_6883# din0[1] a_1768_6883# w_1141_6733# sky130_fd_pr__pfet_01v8 ad=0.3192 pd=2.44 as=0.3276 ps=2.46 w=0.84 l=0.15
X166 a_n2461_1923# control_logic_rw_0.delay_chain_0.out a_n2515_1923# w_n2769_1669# sky130_fd_pr__pfet_01v8 ad=0.1848 pd=1.28 as=0.3276 ps=2.46 w=0.84 l=0.15
X167 bank_0.replica_bitcell_array_0.replica_column_0.replica_cell_1rw_2.q din0[1] din0[1] din0[1] sky130_fd_pr__nfet_01v8 ad=0.3864 pd=2.1 as=0.441 ps=3.22 w=1.26 l=0.15
X168 a_2789_4485# bank_0.port_address_0.hierarchical_decoder_0.predecode_4 bank_0.port_address_0.hierarchical_decoder_0.and2_dec_13.pnand2_0.nmos_m1_w0_840_sactive_dli_0.S din0[1] sky130_fd_pr__nfet_01v8 ad=0.3192 pd=2.44 as=0.1848 ps=1.28 w=0.84 l=0.15
X169 a_1508_4337# bank_0.port_address_0.hierarchical_decoder_0.hierarchical_predecode2x4_1.pinv_0.Z bank_0.port_address_0.hierarchical_decoder_0.hierarchical_predecode2x4_1.and2_dec_2.pnand2_0.nmos_m_uq0 din0[1] sky130_fd_pr__nfet_01v8 ad=0.3192 pd=2.44 as=0.1848 ps=1.28 w=0.84 l=0.15
X170 din0[1] bank_0.replica_bitcell_array_0.dummy_array_0_0.dummy_cell_1rw_1.q bank_0.replica_bitcell_array_0.dummy_array_0_0.dummy_cell_1rw_1.qb din0[1] sky130_fd_pr__nfet_01v8 ad=0.441 pd=3.22 as=0.3864 ps=2.1 w=1.26 l=0.15
X171 a_n2069_n661# control_logic_rw_0.pdriver_0_0.pinv_4_0.A a_n2147_n661# w_n2769_n767# sky130_fd_pr__pfet_01v8 ad=0.3192 pd=2.44 as=0.2646 ps=1.47 w=0.84 l=0.15
X172 bank_0.replica_bitcell_array_0.dummy_array_2_0.dummy_cell_1rw_9.q bank_0.replica_bitcell_array_0.dummy_array_2_0.dummy_cell_1rw_9.qb din0[1] din0[1] sky130_fd_pr__pfet_01v8 ad=0.1925 pd=1.8 as=0.1925 ps=1.8 w=0.55 l=0.15
X173 control_logic_rw_0.dff_buf_array_0.dff_buf_0_0.dff_0.net5 control_logic_rw_0.dff_buf_array_0.dff_buf_0_0.dff_0.clkb control_logic_rw_0.dff_buf_array_0.dff_buf_0_0.dff_0.net4 din0[1] sky130_fd_pr__nfet_01v8 ad=0.3318 pd=2.42 as=0.2226 ps=1.48 w=0.42 l=0.15
X174 bank_0.replica_bitcell_array_0.bitcell_array_0.cell_1rw_21.q bank_0.replica_bitcell_array_0.bitcell_array_0.cell_1rw_21.qb din0[1] din0[1] sky130_fd_pr__nfet_01v8 ad=0.3864 pd=2.1 as=0.441 ps=3.22 w=1.26 l=0.15
X175 bank_0.replica_bitcell_array_0.dummy_array_3_0.dummy_cell_1rw_5.q bank_0.replica_bitcell_array_0.dummy_array_3_0.dummy_cell_1rw_5.qb din0[1] din0[1] sky130_fd_pr__nfet_01v8 ad=0.3864 pd=2.1 as=0.441 ps=3.22 w=1.26 l=0.15
X176 bank_0.replica_bitcell_array_0.replica_column_0.replica_cell_1rw_4.q din0[1] din0[1] din0[1] sky130_fd_pr__nfet_01v8 ad=0.3864 pd=2.1 as=0.441 ps=3.22 w=1.26 l=0.15
X177 a_1508_7391# bank_0.port_address_0.hierarchical_decoder_0.hierarchical_predecode2x4_0.pinv_0.Z bank_0.port_address_0.hierarchical_decoder_0.hierarchical_predecode2x4_0.and2_dec_2.pnand2_0.nmos_m_uq0 din0[1] sky130_fd_pr__nfet_01v8 ad=0.3192 pd=2.44 as=0.1848 ps=1.28 w=0.84 l=0.15
X178 bank_0.replica_bitcell_array_0.dummy_array_3_0.dummy_cell_1rw_2.qb bank_0.replica_bitcell_array_0.wl_0_14 a_5530_10637# din0[1] sky130_fd_pr__nfet_01v8 ad=0.3864 pd=2.1 as=0.1428 ps=1.52 w=0.42 l=0.15
X179 a_2730_9065# bank_0.port_address_0.hierarchical_decoder_0.predecode_3 a_2676_9065# w_2422_8769# sky130_fd_pr__pfet_01v8 ad=0.1848 pd=1.28 as=0.3276 ps=2.46 w=0.84 l=0.15
X180 bank_0.port_address_0.hierarchical_decoder_0.and2_dec_7.pnand2_0.nmos_m1_w0_840_sactive_dli_0.S bank_0.port_address_0.hierarchical_decoder_0.predecode_0 a_2676_7539# din0[1] sky130_fd_pr__nfet_01v8 ad=0.1848 pd=1.28 as=0.3276 ps=2.46 w=0.84 l=0.15
X181 a_3483_6521# control_logic_rw_0.wl_en bank_0.port_address_0.wordline_driver_array_0.wordline_driver_9.pnand2_0.nmos_m1_w0_840_sli_dactive_uq0 din0[1] sky130_fd_pr__nfet_01v8 ad=0.3192 pd=2.44 as=0.1848 ps=1.28 w=0.84 l=0.15
X182 a_n4427_5703# control_logic_rw_0.delay_chain_0.pinv_11_29.Z a_n4480_5703# din0[1] sky130_fd_pr__nfet_01v8 ad=0.1638 pd=1.62 as=0.1596 ps=1.6 w=0.42 l=0.15
X183 a_2730_4847# bank_0.port_address_0.hierarchical_decoder_0.predecode_2 a_2676_4847# w_2422_4697# sky130_fd_pr__pfet_01v8 ad=0.1848 pd=1.28 as=0.3276 ps=2.46 w=0.84 l=0.15
X184 bank_0.port_address_0.hierarchical_decoder_0.hierarchical_predecode2x4_1.and2_dec_1.pnand2_0.nmos_m_uq0 bank_0.port_address_0.hierarchical_decoder_0.hierarchical_predecode2x4_1.pinv_1.Z a_1395_4485# din0[1] sky130_fd_pr__nfet_01v8 ad=0.1848 pd=1.28 as=0.3276 ps=2.46 w=0.84 l=0.15
X185 a_739_4379# row_addr_dff_0.dout_1 a_685_4379# din0[1] sky130_fd_pr__nfet_01v8 ad=0.1596 pd=1.6 as=0.1638 ps=1.62 w=0.42 l=0.15
X186 a_n1666_n107# control_logic_rw_0.dff_buf_array_0.dout_bar_0 a_n1744_n107# din0[1] sky130_fd_pr__nfet_01v8 ad=0.1764 pd=1.19 as=0.1764 ps=1.19 w=0.56 l=0.15
X187 din0[1] bank_0.replica_bitcell_array_0.dummy_array_3_0.dummy_cell_1rw_16.q bank_0.replica_bitcell_array_0.dummy_array_3_0.dummy_cell_1rw_16.qb din0[1] sky130_fd_pr__nfet_01v8 ad=0.441 pd=3.22 as=0.3864 ps=2.1 w=1.26 l=0.15
X188 bank_0.replica_bitcell_array_0.bitcell_array_0.cell_1rw_9.q bank_0.replica_bitcell_array_0.bitcell_array_0.cell_1rw_9.qb din0[1] din0[1] sky130_fd_pr__pfet_01v8 ad=0.1925 pd=1.8 as=0.1925 ps=1.8 w=0.55 l=0.15
X189 a_n4427_3289# control_logic_rw_0.delay_chain_0.pinv_11_39.Z a_n4480_3289# w_n5644_2820# sky130_fd_pr__pfet_01v8 ad=0.3276 pd=2.46 as=0.3192 ps=2.44 w=0.84 l=0.15
X190 bank_0.replica_bitcell_array_0.bitcell_array_0.cell_1rw_21.qb bank_0.replica_bitcell_array_0.wl_0_10 din0[1] din0[1] sky130_fd_pr__nfet_01v8 ad=0.3864 pd=2.1 as=0.1428 ps=1.52 w=0.42 l=0.15
X191 a_n1274_n227# control_logic_rw_0.dff_buf_array_0.dout_bar_0 a_n1352_n227# din0[1] sky130_fd_pr__nfet_01v8 ad=0.1764 pd=1.19 as=0.1764 ps=1.19 w=0.56 l=0.15
X192 a_n1978_123# control_logic_rw_0.dff_buf_array_0.dout_bar_0 a_n2056_123# w_n2769_44# sky130_fd_pr__pfet_01v8 ad=0.3528 pd=1.75 as=0.3528 ps=1.75 w=1.12 l=0.15
X193 control_logic_rw_0.dff_buf_array_0.dff_buf_0_0.dff_0.net1 din0[1] web0 din0[1] sky130_fd_pr__pfet_01v8 ad=0.2915 pd=1.61 as=0.253 ps=2.02 w=0.55 l=0.15
X194 a_4793_1928# control_logic_rw_0.p_en_bar a_4739_1928# w_4605_1519# sky130_fd_pr__pfet_01v8 ad=0.1848 pd=1.28 as=0.3276 ps=2.46 w=0.84 l=0.15
X195 bank_0.replica_bitcell_array_0.dummy_array_0_0.dummy_cell_1rw_1.q bank_0.replica_bitcell_array_0.dummy_array_0_0.dummy_cell_1rw_1.qb din0[1] din0[1] sky130_fd_pr__nfet_01v8 ad=0.3864 pd=2.1 as=0.441 ps=3.22 w=1.26 l=0.15
X196 din0[1] bank_0.replica_bitcell_array_0.replica_column_0.replica_cell_1rw_3.q din0[1] din0[1] sky130_fd_pr__nfet_01v8 ad=0.3864 pd=2.1 as=0 ps=0 w=1.26 l=0.15
X197 din0[1] bank_0.replica_bitcell_array_0.replica_column_0.replica_cell_1rw_8.q din0[1] din0[1] sky130_fd_pr__nfet_01v8 ad=0.3864 pd=2.1 as=0 ps=0 w=1.26 l=0.15
X198 bank_0.replica_bitcell_array_0.dummy_array_2_0.dummy_cell_1rw_10.q bank_0.replica_bitcell_array_0.dummy_array_2_0.dummy_cell_1rw_10.qb din0[1] din0[1] sky130_fd_pr__pfet_01v8 ad=0.1925 pd=1.8 as=0.1925 ps=1.8 w=0.55 l=0.15
X199 control_logic_rw_0.dff_buf_array_0.dff_buf_0_1.dff_0.net2 control_logic_rw_0.dff_buf_array_0.dff_buf_0_1.dff_0.clkb control_logic_rw_0.dff_buf_array_0.dff_buf_0_1.dff_0.net1 din0[1] sky130_fd_pr__pfet_01v8 ad=0.374 pd=2.46 as=0.2915 ps=1.61 w=0.55 l=0.15
X200 row_addr_dff_0.dff_1.net5 row_addr_dff_0.dff_1.clkb row_addr_dff_0.dff_1.net4 din0[1] sky130_fd_pr__nfet_01v8 ad=0.3318 pd=2.42 as=0.2226 ps=1.48 w=0.42 l=0.15
X201 data_dff_0.dff_0.net1 din0[1] din0[1] din0[1] sky130_fd_pr__pfet_01v8 ad=0.2915 pd=1.61 as=0.253 ps=2.02 w=0.55 l=0.15
X202 a_n1510_n107# control_logic_rw_0.dff_buf_array_0.dout_bar_0 a_n1588_n107# din0[1] sky130_fd_pr__nfet_01v8 ad=0.1764 pd=1.19 as=0.1764 ps=1.19 w=0.56 l=0.15
X203 a_3103_7433# din0[1] a_3049_7433# din0[1] sky130_fd_pr__nfet_01v8 ad=0.1596 pd=1.6 as=0.1638 ps=1.62 w=0.42 l=0.15
X204 a_5461_6379# bank_0.replica_bitcell_array_0.wl_0_5 bank_0.replica_bitcell_array_0.dummy_array_3_0.dummy_cell_1rw_11.q din0[1] sky130_fd_pr__nfet_01v8 ad=0.1428 pd=1.52 as=0.3864 ps=2.1 w=0.42 l=0.15
X205 row_addr_dff_0.dff_2.net3 row_addr_dff_0.dff_2.net1 din0[1] din0[1] sky130_fd_pr__pfet_01v8 ad=0.3465 pd=2.36 as=0.22 ps=1.35 w=0.55 l=0.15
X206 a_3424_10955# bank_0.port_address_0.wordline_driver_array_0.in_14 a_3370_10955# w_2422_10805# sky130_fd_pr__pfet_01v8 ad=0.1848 pd=1.28 as=0.3276 ps=2.46 w=0.84 l=0.15
X207 bank_0.replica_bitcell_array_0.dummy_array_3_0.dummy_cell_1rw_18.q bank_0.replica_bitcell_array_0.dummy_array_3_0.dummy_cell_1rw_18.qb din0[1] din0[1] sky130_fd_pr__nfet_01v8 ad=0.3864 pd=2.1 as=0.441 ps=3.22 w=1.26 l=0.15
X208 din0[1] bank_0.replica_bitcell_array_0.wl_0_5 bank_0.replica_bitcell_array_0.replica_column_0.replica_cell_1rw_10.q din0[1] sky130_fd_pr__nfet_01v8 ad=0.1428 pd=1.52 as=0.3864 ps=2.1 w=0.42 l=0.15
X209 a_5010_3325# bank_0.replica_bitcell_array_0.rbl_wl_0_0 bank_0.replica_bitcell_array_0.dummy_array_0.dummy_cell_1rw_1.qb din0[1] sky130_fd_pr__nfet_01v8 ad=0.1428 pd=1.52 as=0.3864 ps=2.1 w=0.42 l=0.15
X210 din0[1] bank_0.replica_bitcell_array_0.bitcell_array_0.cell_1rw_0.q bank_0.replica_bitcell_array_0.bitcell_array_0.cell_1rw_0.qb din0[1] sky130_fd_pr__nfet_01v8 ad=0.441 pd=3.22 as=0.3864 ps=2.1 w=1.26 l=0.15
X211 bank_0.replica_bitcell_array_0.bitcell_array_0.cell_1rw_4.q bank_0.replica_bitcell_array_0.bitcell_array_0.cell_1rw_4.qb din0[1] din0[1] sky130_fd_pr__pfet_01v8 ad=0.1925 pd=1.8 as=0.1925 ps=1.8 w=0.55 l=0.15
X212 a_n5369_4023# control_logic_rw_0.delay_chain_0.pinv_11_39.Z a_n5422_4023# din0[1] sky130_fd_pr__nfet_01v8 ad=0.1638 pd=1.62 as=0.1596 ps=1.6 w=0.42 l=0.15
X213 control_logic_rw_0.dff_buf_array_0.dff_buf_0_1.dff_0.net2 din0[1] control_logic_rw_0.dff_buf_array_0.dff_buf_0_1.dff_0.net1 din0[1] sky130_fd_pr__nfet_01v8 ad=0.2856 pd=2.2 as=0.2226 ps=1.48 w=0.42 l=0.15
X214 bank_0.replica_bitcell_array_0.dummy_array_2_0.dummy_cell_1rw_0.qb din0[1] a_4490_11655# din0[1] sky130_fd_pr__nfet_01v8 ad=0.3864 pd=2.1 as=0.1428 ps=1.52 w=0.42 l=0.15
X215 row_addr_dff_0.dff_3.net2 row_addr_dff_0.dff_3.clk row_addr_dff_0.dff_3.net1 din0[1] sky130_fd_pr__nfet_01v8 ad=0.2856 pd=2.2 as=0.2226 ps=1.48 w=0.42 l=0.15
X216 data_dff_0.dff_0.net1 data_dff_0.dff_0.clkb din0[1] din0[1] sky130_fd_pr__nfet_01v8 ad=0.2226 pd=1.48 as=0.1932 ps=1.76 w=0.42 l=0.15
X217 a_n1742_n513# control_logic_rw_0.dff_buf_array_0.dout_bar_0 a_n1796_n513# w_n2769_n767# sky130_fd_pr__pfet_01v8 ad=0.3528 pd=1.75 as=0.4368 ps=3.02 w=1.12 l=0.15
X218 bank_0.replica_bitcell_array_0.replica_column_0.dummy_cell_1rw_1.q bank_0.replica_bitcell_array_0.replica_column_0.dummy_cell_1rw_1.qb din0[1] din0[1] sky130_fd_pr__nfet_01v8 ad=0.3864 pd=2.1 as=0.441 ps=3.22 w=1.26 l=0.15
X219 a_3483_7029# control_logic_rw_0.wl_en a_3424_7029# w_2422_6733# sky130_fd_pr__pfet_01v8 ad=0.3192 pd=2.44 as=0.1848 ps=1.28 w=0.84 l=0.15
X220 a_3103_6011# din0[1] a_3049_6011# w_2422_5715# sky130_fd_pr__pfet_01v8 ad=0.3192 pd=2.44 as=0.3276 ps=2.46 w=0.84 l=0.15
X221 bank_0.replica_bitcell_array_0.dummy_array_2_0.dummy_cell_1rw_5.q bank_0.replica_bitcell_array_0.dummy_array_2_0.dummy_cell_1rw_5.qb din0[1] din0[1] sky130_fd_pr__pfet_01v8 ad=0.1925 pd=1.8 as=0.1925 ps=1.8 w=0.55 l=0.15
X222 a_5530_8415# bank_0.replica_bitcell_array_0.wl_0_9 bank_0.replica_bitcell_array_0.dummy_array_3_0.dummy_cell_1rw_7.qb din0[1] sky130_fd_pr__nfet_01v8 ad=0.1428 pd=1.52 as=0.3864 ps=2.1 w=0.42 l=0.15
X223 din0[1] row_addr_dff_0.dout_3 row_addr_dff_0.dff_0.net5 din0[1] sky130_fd_pr__pfet_01v8 ad=0.22 pd=1.35 as=0.308 ps=2.22 w=0.55 l=0.15
X224 a_n4113_4821# control_logic_rw_0.delay_chain_0.pinv_11_39.Z a_n4166_4821# w_n5644_4500# sky130_fd_pr__pfet_01v8 ad=0.3276 pd=2.46 as=0.3192 ps=2.44 w=0.84 l=0.15
X225 din0[1] din0[1] din0[1] din0[1] sky130_fd_pr__nfet_01v8 ad=0.21 pd=1.84 as=0 ps=0 w=0.42 l=0.15
X226 din0[1] bank_0.replica_bitcell_array_0.dummy_array_2_0.dummy_cell_1rw_0.q bank_0.replica_bitcell_array_0.dummy_array_2_0.dummy_cell_1rw_0.qb din0[1] sky130_fd_pr__nfet_01v8 ad=0.441 pd=3.22 as=0.3864 ps=2.1 w=1.26 l=0.15
X227 din0[1] bank_0.replica_bitcell_array_0.wl_0_9 din0[1] din0[1] sky130_fd_pr__nfet_01v8 ad=0.1428 pd=1.52 as=0 ps=0 w=0.42 l=0.15
X228 a_3797_2957# din0[1] a_3743_2957# w_3116_2703# sky130_fd_pr__pfet_01v8 ad=0.3192 pd=2.44 as=0.3276 ps=2.46 w=0.84 l=0.15
X229 din0[1] bank_0.replica_bitcell_array_0.bitcell_array_0.cell_1rw_12.q bank_0.replica_bitcell_array_0.bitcell_array_0.cell_1rw_12.qb din0[1] sky130_fd_pr__pfet_01v8 ad=0.1925 pd=1.8 as=0.1925 ps=1.8 w=0.55 l=0.15
X230 a_n1685_927# control_logic_rw_0.dff_buf_array_0.dout_bar_0 a_n1763_927# w_n2769_857# sky130_fd_pr__pfet_01v8 ad=0.378 pd=1.83 as=0.378 ps=1.83 w=1.2 l=0.15
X231 a_3483_10083# control_logic_rw_0.wl_en a_3424_10083# w_2422_9787# sky130_fd_pr__pfet_01v8 ad=0.3192 pd=2.44 as=0.1848 ps=1.28 w=0.84 l=0.15
X232 bank_0.replica_bitcell_array_0.dummy_array_3_0.dummy_cell_1rw_14.qb bank_0.replica_bitcell_array_0.wl_0_2 a_5530_4529# din0[1] sky130_fd_pr__nfet_01v8 ad=0.3864 pd=2.1 as=0.1428 ps=1.52 w=0.42 l=0.15
X233 a_3424_3975# bank_0.port_address_0.wordline_driver_array_0.in_1 a_3370_3975# w_2422_3679# sky130_fd_pr__pfet_01v8 ad=0.1848 pd=1.28 as=0.3276 ps=2.46 w=0.84 l=0.15
X234 din0[1] bank_0.replica_bitcell_array_0.dummy_array_3_0.dummy_cell_1rw_0.q bank_0.replica_bitcell_array_0.dummy_array_3_0.dummy_cell_1rw_0.qb din0[1] sky130_fd_pr__nfet_01v8 ad=0.441 pd=3.22 as=0.3864 ps=2.1 w=1.26 l=0.15
X235 bank_0.port_address_0.hierarchical_decoder_0.and2_dec_14.pnand2_0.nmos_m1_w0_840_sactive_dli_0.S bank_0.port_address_0.hierarchical_decoder_0.predecode_1 a_2676_4337# din0[1] sky130_fd_pr__nfet_01v8 ad=0.1848 pd=1.28 as=0.3276 ps=2.46 w=0.84 l=0.15
X236 din0[1] row_addr_dff_0.dff_1.net3 row_addr_dff_0.dff_1.net2 din0[1] sky130_fd_pr__nfet_01v8 ad=0.168 pd=1.22 as=0.2226 ps=1.9 w=0.42 l=0.15
X237 a_3483_8557# control_logic_rw_0.wl_en bank_0.port_address_0.wordline_driver_array_0.wordline_driver_5.pnand2_0.nmos_m1_w0_840_sli_dactive_uq0 din0[1] sky130_fd_pr__nfet_01v8 ad=0.3192 pd=2.44 as=0.1848 ps=1.28 w=0.84 l=0.15
X238 bank_0.replica_bitcell_array_0.bitcell_array_0.cell_1rw_5.q bank_0.replica_bitcell_array_0.bitcell_array_0.cell_1rw_5.qb din0[1] din0[1] sky130_fd_pr__nfet_01v8 ad=0.3864 pd=2.1 as=0.441 ps=3.22 w=1.26 l=0.15
X239 din0[1] bank_0.replica_bitcell_array_0.dummy_array_2_0.dummy_cell_1rw_13.q bank_0.replica_bitcell_array_0.dummy_array_2_0.dummy_cell_1rw_13.qb din0[1] sky130_fd_pr__pfet_01v8 ad=0.1925 pd=1.8 as=0.1925 ps=1.8 w=0.55 l=0.15
X240 din0[1] din0[1] din0[1] din0[1] sky130_fd_pr__pfet_01v8 ad=0.275 pd=2.1 as=0 ps=0 w=0.55 l=0.15
X241 a_3483_5865# control_logic_rw_0.wl_en a_3424_5865# w_2422_5715# sky130_fd_pr__pfet_01v8 ad=0.3192 pd=2.44 as=0.1848 ps=1.28 w=0.84 l=0.15
X242 row_addr_dff_0.dff_0.net2 row_addr_dff_0.dff_3.clk row_addr_dff_0.dff_0.net1 din0[1] sky130_fd_pr__nfet_01v8 ad=0.2856 pd=2.2 as=0.2226 ps=1.48 w=0.42 l=0.15
X243 bank_0.replica_bitcell_array_0.bitcell_array_0.cell_1rw_21.q bank_0.replica_bitcell_array_0.bitcell_array_0.cell_1rw_21.qb din0[1] din0[1] sky130_fd_pr__pfet_01v8 ad=0.1925 pd=1.8 as=0.1925 ps=1.8 w=0.55 l=0.15
X244 din0[1] bank_0.replica_bitcell_array_0.wl_0_2 din0[1] din0[1] sky130_fd_pr__nfet_01v8 ad=0.3864 pd=2.1 as=0 ps=0 w=0.42 l=0.15
X245 bank_0.replica_bitcell_array_0.dummy_array_2_0.dummy_cell_1rw_6.q bank_0.replica_bitcell_array_0.dummy_array_2_0.dummy_cell_1rw_6.qb din0[1] din0[1] sky130_fd_pr__nfet_01v8 ad=0.3864 pd=2.1 as=0.441 ps=3.22 w=1.26 l=0.15
X246 bank_0.replica_bitcell_array_0.bitcell_array_0.cell_1rw_7.qb bank_0.replica_bitcell_array_0.wl_0_8 din0[1] din0[1] sky130_fd_pr__nfet_01v8 ad=0.3864 pd=2.1 as=0.1428 ps=1.52 w=0.42 l=0.15
X247 din0[1] bank_0.replica_bitcell_array_0.replica_column_0.replica_cell_1rw_4.q din0[1] din0[1] sky130_fd_pr__nfet_01v8 ad=0.3864 pd=2.1 as=0 ps=0 w=1.26 l=0.15
X248 control_logic_rw_0.dff_buf_array_0.dff_buf_0_0.pinv_0_0.A control_logic_rw_0.dff_buf_array_0.dff_buf_0_0.dff_0.net4 din0[1] din0[1] sky130_fd_pr__pfet_01v8 ad=0.22 pd=1.9 as=0.22 ps=1.35 w=0.55 l=0.15
X249 row_addr_dff_0.dff_1.net1 row_addr_dff_0.dff_1.clkb addr0[2] din0[1] sky130_fd_pr__nfet_01v8 ad=0.2226 pd=1.48 as=0.1932 ps=1.76 w=0.42 l=0.15
X250 bank_0.replica_bitcell_array_0.dummy_array_2_0.dummy_cell_1rw_2.q bank_0.replica_bitcell_array_0.wl_0_14 a_4421_10637# din0[1] sky130_fd_pr__nfet_01v8 ad=0.3864 pd=2.1 as=0.1428 ps=1.52 w=0.42 l=0.15
X251 bank_0.replica_bitcell_array_0.dummy_array_2_0.dummy_cell_1rw_8.qb bank_0.replica_bitcell_array_0.wl_0_8 a_4490_7583# din0[1] sky130_fd_pr__nfet_01v8 ad=0.3864 pd=2.1 as=0.1428 ps=1.52 w=0.42 l=0.15
X252 row_addr_dff_0.dout_2 row_addr_dff_0.dff_1.net4 din0[1] din0[1] sky130_fd_pr__pfet_01v8 ad=0.22 pd=1.9 as=0.22 ps=1.35 w=0.55 l=0.15
X253 bank_0.port_address_0.hierarchical_decoder_0.and2_dec_8.pnand2_0.nmos_m1_w0_840_sactive_dli_0.S bank_0.port_address_0.hierarchical_decoder_0.predecode_3 a_2676_7391# din0[1] sky130_fd_pr__nfet_01v8 ad=0.1848 pd=1.28 as=0.3276 ps=2.46 w=0.84 l=0.15
X254 a_n5055_3141# control_logic_rw_0.delay_chain_0.pinv_11_44.Z a_n5108_3141# w_n5644_2820# sky130_fd_pr__pfet_01v8 ad=0.3276 pd=2.46 as=0.3192 ps=2.44 w=0.84 l=0.15
X255 bank_0.replica_bitcell_array_0.dummy_array_3_0.dummy_cell_1rw_2.q bank_0.replica_bitcell_array_0.wl_0_14 a_5461_10637# din0[1] sky130_fd_pr__nfet_01v8 ad=0.3864 pd=2.1 as=0.1428 ps=1.52 w=0.42 l=0.15
X256 a_n987_n691# control_logic_rw_0.pdriver_0_0.pinv_7_0.A a_n1065_n691# w_n2769_n767# sky130_fd_pr__pfet_01v8 ad=0.3622 pd=1.78 as=0.3622 ps=1.78 w=1.15 l=0.15
X257 a_3424_8919# bank_0.port_address_0.wordline_driver_array_0.in_10 a_3370_8919# w_2422_8769# sky130_fd_pr__pfet_01v8 ad=0.1848 pd=1.28 as=0.3276 ps=2.46 w=0.84 l=0.15
X258 din0[1] bank_0.replica_bitcell_array_0.bitcell_array_0.cell_1rw_23.q bank_0.replica_bitcell_array_0.bitcell_array_0.cell_1rw_23.qb din0[1] sky130_fd_pr__pfet_01v8 ad=0.1925 pd=1.8 as=0.1925 ps=1.8 w=0.55 l=0.15
X259 a_3103_9469# din0[1] a_3049_9469# din0[1] sky130_fd_pr__nfet_01v8 ad=0.1596 pd=1.6 as=0.1638 ps=1.62 w=0.42 l=0.15
X260 a_1508_3975# bank_0.port_address_0.hierarchical_decoder_0.hierarchical_predecode2x4_1.pinv_0.Z a_1449_3975# w_1141_3679# sky130_fd_pr__pfet_01v8 ad=0.3192 pd=2.44 as=0.1848 ps=1.28 w=0.84 l=0.15
X261 bank_0.port_address_0.wordline_driver_array_0.wordline_driver_2.pnand2_0.nmos_m1_w0_840_sli_dactive_uq0 bank_0.port_address_0.wordline_driver_array_0.in_13 a_3370_10445# din0[1] sky130_fd_pr__nfet_01v8 ad=0.1848 pd=1.28 as=0.3276 ps=2.46 w=0.84 l=0.15
X262 din0[1] bank_0.replica_bitcell_array_0.bitcell_array_0.cell_1rw_19.q bank_0.replica_bitcell_array_0.bitcell_array_0.cell_1rw_19.qb din0[1] sky130_fd_pr__nfet_01v8 ad=0.441 pd=3.22 as=0.3864 ps=2.1 w=1.26 l=0.15
X263 din0[1] bank_0.replica_bitcell_array_0.bitcell_array_0.cell_1rw_24.q bank_0.replica_bitcell_array_0.bitcell_array_0.cell_1rw_24.qb din0[1] sky130_fd_pr__nfet_01v8 ad=0.441 pd=3.22 as=0.3864 ps=2.1 w=1.26 l=0.15
X264 din0[1] bank_0.replica_bitcell_array_0.wl_0_3 bank_0.replica_bitcell_array_0.bitcell_array_0.cell_1rw_28.qb din0[1] sky130_fd_pr__nfet_01v8 ad=0.1428 pd=1.52 as=0.3864 ps=2.1 w=0.42 l=0.15
X265 bank_0.replica_bitcell_array_0.dummy_array_1_0.dummy_cell_1rw_0.q din0[1] a_5201_2493# din0[1] sky130_fd_pr__nfet_01v8 ad=0.3864 pd=2.1 as=0.1428 ps=1.52 w=0.42 l=0.15
X266 a_n5055_9861# control_logic_rw_0.delay_chain_0.out a_n5108_9861# w_n5644_9540# sky130_fd_pr__pfet_01v8 ad=0.3276 pd=2.46 as=0.3192 ps=2.44 w=0.84 l=0.15
X267 a_n2461_1517# control_logic_rw_0.delay_chain_0.out a_n2515_1517# din0[1] sky130_fd_pr__nfet_01v8 ad=0.1596 pd=1.6 as=0.1638 ps=1.62 w=0.42 l=0.15
X268 bank_0.replica_bitcell_array_0.dummy_array_0_0.dummy_cell_1rw_0.q din0[1] a_5201_11655# din0[1] sky130_fd_pr__nfet_01v8 ad=0.3864 pd=2.1 as=0.1428 ps=1.52 w=0.42 l=0.15
X269 a_3103_8047# din0[1] a_3049_8047# w_2422_7751# sky130_fd_pr__pfet_01v8 ad=0.3192 pd=2.44 as=0.3276 ps=2.46 w=0.84 l=0.15
X270 a_n363_n691# control_logic_rw_0.pdriver_0_0.pinv_7_0.A a_n441_n691# w_n2769_n767# sky130_fd_pr__pfet_01v8 ad=0.437 pd=3.06 as=0.3622 ps=1.78 w=1.15 l=0.15
X271 a_n2461_1111# control_logic_rw_0.pand2_0.Z a_n2515_1111# w_n2769_857# sky130_fd_pr__pfet_01v8 ad=0.133 pd=1.35 as=0.3276 ps=2.46 w=0.84 l=0.15
X272 a_3797_10083# din0[1] a_3743_10083# w_2422_9787# sky130_fd_pr__pfet_01v8 ad=0.3192 pd=2.44 as=0.3276 ps=2.46 w=0.84 l=0.15
X273 a_3103_3829# din0[1] a_3049_3829# w_2422_3679# sky130_fd_pr__pfet_01v8 ad=0.3192 pd=2.44 as=0.3276 ps=2.46 w=0.84 l=0.15
X274 bank_0.replica_bitcell_array_0.dummy_array_2_0.dummy_cell_1rw_18.q din0[1] a_4421_2493# din0[1] sky130_fd_pr__nfet_01v8 ad=0.3864 pd=2.1 as=0.1428 ps=1.52 w=0.42 l=0.15
X275 din0[1] row_addr_dff_0.dout_1 row_addr_dff_0.dff_2.net5 din0[1] sky130_fd_pr__pfet_01v8 ad=0.22 pd=1.35 as=0.308 ps=2.22 w=0.55 l=0.15
X276 a_3797_4379# din0[1] a_3743_4379# din0[1] sky130_fd_pr__nfet_01v8 ad=0.1596 pd=1.6 as=0.1638 ps=1.62 w=0.42 l=0.15
X277 din0[1] din0[1] din0[1] din0[1] sky130_fd_pr__nfet_01v8 ad=0.056 pd=0.77 as=0 ps=0 w=0.42 l=0.15
X278 a_n5055_2449# control_logic_rw_0.delay_chain_0.pinv_11_44.Z a_n5108_2449# din0[1] sky130_fd_pr__nfet_01v8 ad=0.1638 pd=1.62 as=0.1596 ps=1.6 w=0.42 l=0.15
X279 din0[1] bank_0.replica_bitcell_array_0.replica_column_0.replica_cell_1rw_0.q din0[1] din0[1] sky130_fd_pr__nfet_01v8 ad=0.3864 pd=2.1 as=0 ps=0 w=1.26 l=0.15
X280 bank_0.replica_bitcell_array_0.bitcell_array_0.cell_1rw_23.q bank_0.replica_bitcell_array_0.wl_0_8 din0[1] din0[1] sky130_fd_pr__nfet_01v8 ad=0.3864 pd=2.1 as=0.1428 ps=1.52 w=0.42 l=0.15
X281 bank_0.replica_bitcell_array_0.dummy_array_3_0.dummy_cell_1rw_18.q bank_0.replica_bitcell_array_0.dummy_array_3_0.dummy_cell_1rw_18.qb din0[1] din0[1] sky130_fd_pr__pfet_01v8 ad=0.1925 pd=1.8 as=0.1925 ps=1.8 w=0.55 l=0.15
X282 din0[1] bank_0.replica_bitcell_array_0.bitcell_array_0.cell_1rw_8.q bank_0.replica_bitcell_array_0.bitcell_array_0.cell_1rw_8.qb din0[1] sky130_fd_pr__pfet_01v8 ad=0.1925 pd=1.8 as=0.1925 ps=1.8 w=0.55 l=0.15
X283 bank_0.replica_bitcell_array_0.bitcell_array_0.cell_1rw_11.q bank_0.replica_bitcell_array_0.wl_0_4 din0[1] din0[1] sky130_fd_pr__nfet_01v8 ad=0.3864 pd=2.1 as=0.1428 ps=1.52 w=0.42 l=0.15
X284 a_n2402_206# control_logic_rw_0.pand2_0.pnand2_0_0.nmos_m1_w0_840_sactive_dli_0.G a_n2461_151# w_n2769_44# sky130_fd_pr__pfet_01v8 ad=0.2173 pd=2.6 as=0.133 ps=1.35 w=0.49 l=0.15
X285 din0[1] bank_0.replica_bitcell_array_0.replica_column_0.dummy_cell_1rw_1.q bank_0.replica_bitcell_array_0.replica_column_0.dummy_cell_1rw_1.qb din0[1] sky130_fd_pr__nfet_01v8 ad=0.441 pd=3.22 as=0.3864 ps=2.1 w=1.26 l=0.15
X286 a_2789_6521# bank_0.port_address_0.hierarchical_decoder_0.predecode_5 bank_0.port_address_0.hierarchical_decoder_0.and2_dec_9.pnand2_0.nmos_m1_w0_840_sactive_dli_0.S din0[1] sky130_fd_pr__nfet_01v8 ad=0.3192 pd=2.44 as=0.1848 ps=1.28 w=0.84 l=0.15
X287 control_logic_rw_0.pand3_0_0.pnand3_0_0.nmos_m1_w0_840_sactive_dactive_0.S control_logic_rw_0.delay_chain_0.out a_n2515_2181# din0[1] sky130_fd_pr__nfet_01v8 ad=0.1848 pd=1.28 as=0.3276 ps=2.46 w=0.84 l=0.15
X288 a_2789_10593# bank_0.port_address_0.hierarchical_decoder_0.predecode_7 bank_0.port_address_0.hierarchical_decoder_0.and2_dec_1.pnand2_0.nmos_m1_w0_840_sactive_dli_0.S din0[1] sky130_fd_pr__nfet_01v8 ad=0.3192 pd=2.44 as=0.1848 ps=1.28 w=0.84 l=0.15
X289 bank_0.replica_bitcell_array_0.dummy_array_3_0.dummy_cell_1rw_10.qb bank_0.replica_bitcell_array_0.wl_0_6 a_5530_6565# din0[1] sky130_fd_pr__nfet_01v8 ad=0.3864 pd=2.1 as=0.1428 ps=1.52 w=0.42 l=0.15
X290 a_n1997_2223# control_logic_rw_0.dff_buf_array_0.dout_1 a_n2051_2223# din0[1] sky130_fd_pr__nfet_01v8 ad=0.1323 pd=1.05 as=0.1638 ps=1.62 w=0.42 l=0.15
X291 bank_0.replica_bitcell_array_0.replica_column_0.dummy_cell_1rw_1.q bank_0.replica_bitcell_array_0.replica_column_0.dummy_cell_1rw_1.qb din0[1] din0[1] sky130_fd_pr__pfet_01v8 ad=0.1925 pd=1.8 as=0.1925 ps=1.8 w=0.55 l=0.15
X292 a_3103_9575# din0[1] a_3049_9575# din0[1] sky130_fd_pr__nfet_01v8 ad=0.1596 pd=1.6 as=0.1638 ps=1.62 w=0.42 l=0.15
X293 bank_0.replica_bitcell_array_0.bitcell_array_0.cell_1rw_22.q bank_0.replica_bitcell_array_0.bitcell_array_0.cell_1rw_22.qb din0[1] din0[1] sky130_fd_pr__nfet_01v8 ad=0.3864 pd=2.1 as=0.441 ps=3.22 w=1.26 l=0.15
X294 din0[1] bank_0.replica_bitcell_array_0.dummy_array_2_0.dummy_cell_1rw_9.q bank_0.replica_bitcell_array_0.dummy_array_2_0.dummy_cell_1rw_9.qb din0[1] sky130_fd_pr__pfet_01v8 ad=0.1925 pd=1.8 as=0.1925 ps=1.8 w=0.55 l=0.15
X295 bank_0.replica_bitcell_array_0.dummy_array_2_0.dummy_cell_1rw_12.q bank_0.replica_bitcell_array_0.wl_0_4 a_4421_5547# din0[1] sky130_fd_pr__nfet_01v8 ad=0.3864 pd=2.1 as=0.1428 ps=1.52 w=0.42 l=0.15
X296 a_3483_5355# control_logic_rw_0.wl_en bank_0.port_address_0.wordline_driver_array_0.wordline_driver_12.pnand2_0.nmos_m1_w0_840_sli_dactiv_uq0 din0[1] sky130_fd_pr__nfet_01v8 ad=0.3192 pd=2.44 as=0.1848 ps=1.28 w=0.84 l=0.15
X297 din0[1] bank_0.replica_bitcell_array_0.bitcell_array_0.cell_1rw_30.q bank_0.replica_bitcell_array_0.bitcell_array_0.cell_1rw_30.qb din0[1] sky130_fd_pr__pfet_01v8 ad=0.1925 pd=1.8 as=0.1925 ps=1.8 w=0.55 l=0.15
X298 a_3103_6883# din0[1] a_3049_6883# w_2422_6733# sky130_fd_pr__pfet_01v8 ad=0.3192 pd=2.44 as=0.3276 ps=2.46 w=0.84 l=0.15
X299 row_addr_dff_0.dff_2.net2 row_addr_dff_0.dff_3.clk row_addr_dff_0.dff_2.net1 din0[1] sky130_fd_pr__nfet_01v8 ad=0.2856 pd=2.2 as=0.2226 ps=1.48 w=0.42 l=0.15
X300 din0[1] bank_0.replica_bitcell_array_0.wl_0_6 din0[1] din0[1] sky130_fd_pr__nfet_01v8 ad=0.3864 pd=2.1 as=0 ps=0 w=0.42 l=0.15
X301 din0[1] bank_0.replica_bitcell_array_0.bitcell_array_0.cell_1rw_9.q bank_0.replica_bitcell_array_0.bitcell_array_0.cell_1rw_9.qb din0[1] sky130_fd_pr__pfet_01v8 ad=0.1925 pd=1.8 as=0.1925 ps=1.8 w=0.55 l=0.15
X302 bank_0.replica_bitcell_array_0.dummy_array_3_0.dummy_cell_1rw_12.q bank_0.replica_bitcell_array_0.dummy_array_3_0.dummy_cell_1rw_12.qb din0[1] din0[1] sky130_fd_pr__pfet_01v8 ad=0.1925 pd=1.8 as=0.1925 ps=1.8 w=0.55 l=0.15
X303 bank_0.replica_bitcell_array_0.bitcell_array_0.cell_1rw_30.q bank_0.replica_bitcell_array_0.bitcell_array_0.cell_1rw_30.qb din0[1] din0[1] sky130_fd_pr__pfet_01v8 ad=0.1925 pd=1.8 as=0.1925 ps=1.8 w=0.55 l=0.15
X304 din0[1] bank_0.replica_bitcell_array_0.dummy_array_3_0.dummy_cell_1rw_16.q bank_0.replica_bitcell_array_0.dummy_array_3_0.dummy_cell_1rw_16.qb din0[1] sky130_fd_pr__pfet_01v8 ad=0.1925 pd=1.8 as=0.1925 ps=1.8 w=0.55 l=0.15
X305 din0[1] bank_0.replica_bitcell_array_0.bitcell_array_0.cell_1rw_5.q bank_0.replica_bitcell_array_0.bitcell_array_0.cell_1rw_5.qb din0[1] sky130_fd_pr__nfet_01v8 ad=0.441 pd=3.22 as=0.3864 ps=2.1 w=1.26 l=0.15
X306 bank_0.port_address_0.hierarchical_decoder_0.hierarchical_predecode2x4_0.and2_dec_3.pnand2_0.nmos_m_uq0 bank_0.port_address_0.hierarchical_decoder_0.hierarchical_predecode2x4_0.pinv_1.Z a_1395_6521# din0[1] sky130_fd_pr__nfet_01v8 ad=0.1848 pd=1.28 as=0.3276 ps=2.46 w=0.84 l=0.15
X307 bank_0.replica_bitcell_array_0.replica_column_0.replica_cell_1rw_11.q din0[1] din0[1] din0[1] sky130_fd_pr__pfet_01v8 ad=0.1925 pd=1.8 as=0.1925 ps=1.8 w=0.55 l=0.15
X308 din0[1] bank_0.replica_bitcell_array_0.dummy_array_3_0.dummy_cell_1rw_12.q bank_0.replica_bitcell_array_0.dummy_array_3_0.dummy_cell_1rw_12.qb din0[1] sky130_fd_pr__nfet_01v8 ad=0.441 pd=3.22 as=0.3864 ps=2.1 w=1.26 l=0.15
X309 bank_0.replica_bitcell_array_0.dummy_array_3_0.dummy_cell_1rw_13.q bank_0.replica_bitcell_array_0.dummy_array_3_0.dummy_cell_1rw_13.qb din0[1] din0[1] sky130_fd_pr__pfet_01v8 ad=0.1925 pd=1.8 as=0.1925 ps=1.8 w=0.55 l=0.15
X310 a_3797_4485# din0[1] a_3743_4485# din0[1] sky130_fd_pr__nfet_01v8 ad=0.1596 pd=1.6 as=0.1638 ps=1.62 w=0.42 l=0.15
X311 a_n4113_4129# control_logic_rw_0.delay_chain_0.pinv_11_39.Z a_n4166_4129# din0[1] sky130_fd_pr__nfet_01v8 ad=0.1638 pd=1.62 as=0.1596 ps=1.6 w=0.42 l=0.15
X312 din0[1] bank_0.replica_bitcell_array_0.dummy_array_3_0.dummy_cell_1rw_17.q bank_0.replica_bitcell_array_0.dummy_array_3_0.dummy_cell_1rw_17.qb din0[1] sky130_fd_pr__nfet_01v8 ad=0.441 pd=3.22 as=0.3864 ps=2.1 w=1.26 l=0.15
X313 din0[1] row_addr_dff_0.dff_3.net4 din0[1] din0[1] sky130_fd_pr__pfet_01v8 ad=0.22 pd=1.35 as=0 ps=0 w=0.55 l=0.15
X314 bank_0.replica_bitcell_array_0.bitcell_array_0.cell_1rw_5.q bank_0.replica_bitcell_array_0.bitcell_array_0.cell_1rw_5.qb din0[1] din0[1] sky130_fd_pr__pfet_01v8 ad=0.1925 pd=1.8 as=0.1925 ps=1.8 w=0.55 l=0.15
X315 bank_0.port_address_0.wordline_driver_array_0.wordline_driver_6.pnand2_0.nmos_m1_w0_840_sli_dactive_uq0 bank_0.port_address_0.wordline_driver_array_0.in_9 a_3370_8409# din0[1] sky130_fd_pr__nfet_01v8 ad=0.1848 pd=1.28 as=0.3276 ps=2.46 w=0.84 l=0.15
X316 din0[1] bank_0.replica_bitcell_array_0.dummy_array_2_0.dummy_cell_1rw_10.q bank_0.replica_bitcell_array_0.dummy_array_2_0.dummy_cell_1rw_10.qb din0[1] sky130_fd_pr__pfet_01v8 ad=0.1925 pd=1.8 as=0.1925 ps=1.8 w=0.55 l=0.15
X317 a_n2343_705# control_logic_rw_0.pand3_0.pnand3_0_0.nmos_m1_w0_840_sactive_dli_0.G control_logic_rw_0.pand3_0.pnand3_0_0.nmos_m1_w0_840_sactive_dactive_0.D din0[1] sky130_fd_pr__nfet_01v8 ad=0.3192 pd=2.44 as=0.1848 ps=1.28 w=0.84 l=0.15
X318 din0[1] bank_0.replica_bitcell_array_0.bitcell_array_0.cell_1rw_19.q bank_0.replica_bitcell_array_0.bitcell_array_0.cell_1rw_19.qb din0[1] sky130_fd_pr__pfet_01v8 ad=0.1925 pd=1.8 as=0.1925 ps=1.8 w=0.55 l=0.15
X319 din0[1] bank_0.replica_bitcell_array_0.replica_column_0.replica_cell_1rw_15.q din0[1] din0[1] sky130_fd_pr__pfet_01v8 ad=0.1925 pd=1.8 as=0 ps=0 w=0.55 l=0.15
X320 data_dff_0.dff_0.net3 data_dff_0.dff_0.net1 din0[1] din0[1] sky130_fd_pr__pfet_01v8 ad=0.3465 pd=2.36 as=0.22 ps=1.35 w=0.55 l=0.15
X321 a_n1118_n513# control_logic_rw_0.dff_buf_array_0.dout_bar_0 a_n1196_n513# w_n2769_n767# sky130_fd_pr__pfet_01v8 ad=0.4256 pd=3 as=0.3528 ps=1.75 w=1.12 l=0.15
X322 row_addr_dff_0.dff_1.clkb row_addr_dff_0.dff_3.clk din0[1] din0[1] sky130_fd_pr__pfet_01v8 ad=0.253 pd=2.02 as=0.253 ps=2.02 w=0.55 l=0.15
X323 row_addr_dff_0.dff_3.net5 row_addr_dff_0.dff_3.clkb row_addr_dff_0.dff_3.net4 din0[1] sky130_fd_pr__nfet_01v8 ad=0.3318 pd=2.42 as=0.2226 ps=1.48 w=0.42 l=0.15
X324 din0[1] bank_0.replica_bitcell_array_0.dummy_array_2_0.dummy_cell_1rw_6.q bank_0.replica_bitcell_array_0.dummy_array_2_0.dummy_cell_1rw_6.qb din0[1] sky130_fd_pr__nfet_01v8 ad=0.441 pd=3.22 as=0.3864 ps=2.1 w=1.26 l=0.15
X325 din0[1] bank_0.replica_bitcell_array_0.bitcell_array_0.cell_1rw_20.q bank_0.replica_bitcell_array_0.bitcell_array_0.cell_1rw_20.qb din0[1] sky130_fd_pr__nfet_01v8 ad=0.441 pd=3.22 as=0.3864 ps=2.1 w=1.26 l=0.15
X326 bank_0.replica_bitcell_array_0.replica_column_0.replica_cell_1rw_12.q din0[1] din0[1] din0[1] sky130_fd_pr__pfet_01v8 ad=0.1925 pd=1.8 as=0.1925 ps=1.8 w=0.55 l=0.15
X327 bank_0.replica_bitcell_array_0.bitcell_array_0.cell_1rw_17.q bank_0.replica_bitcell_array_0.wl_0_14 din0[1] din0[1] sky130_fd_pr__nfet_01v8 ad=0.3864 pd=2.1 as=0.1428 ps=1.52 w=0.42 l=0.15
X328 bank_0.replica_bitcell_array_0.dummy_array_2_0.dummy_cell_1rw_6.q bank_0.replica_bitcell_array_0.dummy_array_2_0.dummy_cell_1rw_6.qb din0[1] din0[1] sky130_fd_pr__pfet_01v8 ad=0.1925 pd=1.8 as=0.1925 ps=1.8 w=0.55 l=0.15
X329 a_2789_7029# bank_0.port_address_0.hierarchical_decoder_0.predecode_5 a_2730_7029# w_2422_6733# sky130_fd_pr__pfet_01v8 ad=0.3192 pd=2.44 as=0.1848 ps=1.28 w=0.84 l=0.15
X330 din0[1] bank_0.replica_bitcell_array_0.wl_0_1 bank_0.replica_bitcell_array_0.bitcell_array_0.cell_1rw_14.qb din0[1] sky130_fd_pr__nfet_01v8 ad=0.1428 pd=1.52 as=0.3864 ps=2.1 w=0.42 l=0.15
X331 a_n597_n919# control_logic_rw_0.pdriver_0_0.pinv_7_0.A a_n675_n919# din0[1] sky130_fd_pr__nfet_01v8 ad=0.1795 pd=1.2 as=0.1795 ps=1.2 w=0.57 l=0.15
X332 din0[1] din0[1] din0[1] din0[1] sky130_fd_pr__pfet_01v8 ad=0.45 pd=2.9 as=0 ps=0 w=0.59 l=0.15
X333 a_5461_8415# bank_0.replica_bitcell_array_0.wl_0_9 bank_0.replica_bitcell_array_0.dummy_array_3_0.dummy_cell_1rw_7.q din0[1] sky130_fd_pr__nfet_01v8 ad=0.1428 pd=1.52 as=0.3864 ps=2.1 w=0.42 l=0.15
X334 bank_0.replica_bitcell_array_0.dummy_array_3_0.dummy_cell_1rw_7.q bank_0.replica_bitcell_array_0.dummy_array_3_0.dummy_cell_1rw_7.qb din0[1] din0[1] sky130_fd_pr__pfet_01v8 ad=0.1925 pd=1.8 as=0.1925 ps=1.8 w=0.55 l=0.15
X335 a_4490_4343# bank_0.replica_bitcell_array_0.wl_0_1 bank_0.replica_bitcell_array_0.dummy_array_2_0.dummy_cell_1rw_15.qb din0[1] sky130_fd_pr__nfet_01v8 ad=0.1428 pd=1.52 as=0.3864 ps=2.1 w=0.42 l=0.15
X336 data_dff_0.dff_0.net3 data_dff_0.dff_0.net1 din0[1] din0[1] sky130_fd_pr__nfet_01v8 ad=0.2604 pd=2.08 as=0.168 ps=1.22 w=0.42 l=0.15
X337 a_n4741_9063# control_logic_rw_0.delay_chain_0.pinv_11_9.Z a_n4794_9063# din0[1] sky130_fd_pr__nfet_01v8 ad=0.1638 pd=1.62 as=0.1596 ps=1.6 w=0.42 l=0.15
X338 bank_0.replica_bitcell_array_0.replica_column_0.replica_cell_1rw_6.q din0[1] din0[1] din0[1] sky130_fd_pr__pfet_01v8 ad=0.1925 pd=1.8 as=0.1925 ps=1.8 w=0.55 l=0.15
X339 a_n5055_6649# control_logic_rw_0.delay_chain_0.pinv_11_19.Z a_n5108_6649# w_n5644_6180# sky130_fd_pr__pfet_01v8 ad=0.3276 pd=2.46 as=0.3192 ps=2.44 w=0.84 l=0.15
X340 bank_0.replica_bitcell_array_0.dummy_array_3_0.dummy_cell_1rw_14.q bank_0.replica_bitcell_array_0.dummy_array_3_0.dummy_cell_1rw_14.qb din0[1] din0[1] sky130_fd_pr__nfet_01v8 ad=0.3864 pd=2.1 as=0.441 ps=3.22 w=1.26 l=0.15
X341 din0[1] bank_0.replica_bitcell_array_0.wl_0_9 bank_0.replica_bitcell_array_0.replica_column_0.replica_cell_1rw_6.q din0[1] sky130_fd_pr__nfet_01v8 ad=0.1428 pd=1.52 as=0.3864 ps=2.1 w=0.42 l=0.15
X342 a_2730_3975# bank_0.port_address_0.hierarchical_decoder_0.predecode_1 a_2676_3975# w_2422_3679# sky130_fd_pr__pfet_01v8 ad=0.1848 pd=1.28 as=0.3276 ps=2.46 w=0.84 l=0.15
X343 a_739_6521# row_addr_dff_0.dout_2 a_685_6521# din0[1] sky130_fd_pr__nfet_01v8 ad=0.1596 pd=1.6 as=0.1638 ps=1.62 w=0.42 l=0.15
X344 row_addr_dff_0.dff_0.net5 row_addr_dff_0.dff_0.clkb row_addr_dff_0.dff_0.net4 din0[1] sky130_fd_pr__nfet_01v8 ad=0.3318 pd=2.42 as=0.2226 ps=1.48 w=0.42 l=0.15
X345 a_2789_8557# bank_0.port_address_0.hierarchical_decoder_0.predecode_6 bank_0.port_address_0.hierarchical_decoder_0.and2_dec_5.pnand2_0.nmos_m1_w0_840_sactive_dli_0.S din0[1] sky130_fd_pr__nfet_01v8 ad=0.3192 pd=2.44 as=0.1848 ps=1.28 w=0.84 l=0.15
X346 a_1508_8409# row_addr_dff_0.dout_3 bank_0.port_address_0.hierarchical_decoder_0.hierarchical_predecode2x4_0.and2_dec_0.pnand2_0.nmos_m_uq0 din0[1] sky130_fd_pr__nfet_01v8 ad=0.3192 pd=2.44 as=0.1848 ps=1.28 w=0.84 l=0.15
X347 a_1449_7029# row_addr_dff_0.dout_2 a_1395_7029# w_1141_6733# sky130_fd_pr__pfet_01v8 ad=0.1848 pd=1.28 as=0.3276 ps=2.46 w=0.84 l=0.15
X348 din0[1] bank_0.replica_bitcell_array_0.wl_0_7 bank_0.replica_bitcell_array_0.bitcell_array_0.cell_1rw_8.qb din0[1] sky130_fd_pr__nfet_01v8 ad=0.1428 pd=1.52 as=0.3864 ps=2.1 w=0.42 l=0.15
X349 din0[1] bank_0.replica_bitcell_array_0.dummy_array_3_0.dummy_cell_1rw_11.q bank_0.replica_bitcell_array_0.dummy_array_3_0.dummy_cell_1rw_11.qb din0[1] sky130_fd_pr__pfet_01v8 ad=0.1925 pd=1.8 as=0.1925 ps=1.8 w=0.55 l=0.15
X350 bank_0.replica_bitcell_array_0.replica_column_0.replica_cell_1rw_13.q din0[1] din0[1] din0[1] sky130_fd_pr__nfet_01v8 ad=0.3864 pd=2.1 as=0.441 ps=3.22 w=1.26 l=0.15
X351 bank_0.replica_bitcell_array_0.dummy_array_3_0.dummy_cell_1rw_14.q bank_0.replica_bitcell_array_0.wl_0_2 a_5461_4529# din0[1] sky130_fd_pr__nfet_01v8 ad=0.3864 pd=2.1 as=0.1428 ps=1.52 w=0.42 l=0.15
X352 a_1822_4379# din0[1] a_1768_4379# din0[1] sky130_fd_pr__nfet_01v8 ad=0.1596 pd=1.6 as=0.1638 ps=1.62 w=0.42 l=0.15
X353 a_2789_5865# bank_0.port_address_0.hierarchical_decoder_0.predecode_5 a_2730_5865# w_2422_5715# sky130_fd_pr__pfet_01v8 ad=0.3192 pd=2.44 as=0.1848 ps=1.28 w=0.84 l=0.15
X354 a_n3447_n689# control_logic_rw_0.dff_buf_array_0.dout_bar_0 a_n3525_n689# w_n4225_n767# sky130_fd_pr__pfet_01v8 ad=0.3528 pd=1.75 as=0.3528 ps=1.75 w=1.12 l=0.15
X355 a_4490_7397# bank_0.replica_bitcell_array_0.wl_0_7 bank_0.replica_bitcell_array_0.dummy_array_2_0.dummy_cell_1rw_9.qb din0[1] sky130_fd_pr__nfet_01v8 ad=0.1428 pd=1.52 as=0.3864 ps=2.1 w=0.42 l=0.15
X356 a_n909_n691# control_logic_rw_0.pdriver_0_0.pinv_7_0.A a_n987_n691# w_n2769_n767# sky130_fd_pr__pfet_01v8 ad=0.3622 pd=1.78 as=0.3622 ps=1.78 w=1.15 l=0.15
X357 din0[1] bank_0.replica_bitcell_array_0.replica_column_0.replica_cell_1rw_10.q din0[1] din0[1] sky130_fd_pr__pfet_01v8 ad=0.1925 pd=1.8 as=0 ps=0 w=0.55 l=0.15
X358 bank_0.replica_bitcell_array_0.replica_column_0.replica_cell_1rw_13.q bank_0.replica_bitcell_array_0.wl_0_2 din0[1] din0[1] sky130_fd_pr__nfet_01v8 ad=0.3864 pd=2.1 as=0.1428 ps=1.52 w=0.42 l=0.15
X359 din0[1] row_addr_dff_0.dff_3.net3 row_addr_dff_0.dff_3.net2 din0[1] sky130_fd_pr__nfet_01v8 ad=0.168 pd=1.22 as=0.2226 ps=1.9 w=0.42 l=0.15
X360 a_n5055_9169# control_logic_rw_0.delay_chain_0.out a_n5108_9169# din0[1] sky130_fd_pr__nfet_01v8 ad=0.1638 pd=1.62 as=0.1596 ps=1.6 w=0.42 l=0.15
X361 din0[1] bank_0.replica_bitcell_array_0.dummy_array_1_0.dummy_cell_1rw_1.q bank_0.replica_bitcell_array_0.dummy_array_1_0.dummy_cell_1rw_1.qb din0[1] sky130_fd_pr__nfet_01v8 ad=0.441 pd=3.22 as=0.3864 ps=2.1 w=1.26 l=0.15
X362 a_n1196_n227# control_logic_rw_0.dff_buf_array_0.dout_bar_0 a_n1274_n227# din0[1] sky130_fd_pr__nfet_01v8 ad=0.1764 pd=1.19 as=0.1764 ps=1.19 w=0.56 l=0.15
X363 din0[1] bank_0.replica_bitcell_array_0.dummy_array_3_0.dummy_cell_1rw_5.q bank_0.replica_bitcell_array_0.dummy_array_3_0.dummy_cell_1rw_5.qb din0[1] sky130_fd_pr__pfet_01v8 ad=0.1925 pd=1.8 as=0.1925 ps=1.8 w=0.55 l=0.15
X364 din0[1] bank_0.replica_bitcell_array_0.dummy_array_3_0.dummy_cell_1rw_12.q bank_0.replica_bitcell_array_0.dummy_array_3_0.dummy_cell_1rw_12.qb din0[1] sky130_fd_pr__pfet_01v8 ad=0.1925 pd=1.8 as=0.1925 ps=1.8 w=0.55 l=0.15
X365 a_2730_8919# bank_0.port_address_0.hierarchical_decoder_0.predecode_2 a_2676_8919# w_2422_8769# sky130_fd_pr__pfet_01v8 ad=0.1848 pd=1.28 as=0.3276 ps=2.46 w=0.84 l=0.15
X366 a_n4113_8329# control_logic_rw_0.delay_chain_0.pinv_11_14.Z a_n4166_8329# w_n5644_7860# sky130_fd_pr__pfet_01v8 ad=0.3276 pd=2.46 as=0.3192 ps=2.44 w=0.84 l=0.15
X367 bank_0.replica_bitcell_array_0.bitcell_array_0.cell_1rw_6.q bank_0.replica_bitcell_array_0.bitcell_array_0.cell_1rw_6.qb din0[1] din0[1] sky130_fd_pr__nfet_01v8 ad=0.3864 pd=2.1 as=0.441 ps=3.22 w=1.26 l=0.15
X368 a_3483_7901# control_logic_rw_0.wl_en a_3424_7901# w_2422_7751# sky130_fd_pr__pfet_01v8 ad=0.3192 pd=2.44 as=0.1848 ps=1.28 w=0.84 l=0.15
X369 din0[1] bank_0.replica_bitcell_array_0.dummy_array_3_0.dummy_cell_1rw_8.q bank_0.replica_bitcell_array_0.dummy_array_3_0.dummy_cell_1rw_8.qb din0[1] sky130_fd_pr__nfet_01v8 ad=0.441 pd=3.22 as=0.3864 ps=2.1 w=1.26 l=0.15
X370 din0[1] bank_0.replica_bitcell_array_0.dummy_array_3_0.dummy_cell_1rw_13.q bank_0.replica_bitcell_array_0.dummy_array_3_0.dummy_cell_1rw_13.qb din0[1] sky130_fd_pr__nfet_01v8 ad=0.441 pd=3.22 as=0.3864 ps=2.1 w=1.26 l=0.15
X371 din0[1] bank_0.replica_bitcell_array_0.wl_0_1 bank_0.replica_bitcell_array_0.bitcell_array_0.cell_1rw_30.q din0[1] sky130_fd_pr__nfet_01v8 ad=0.1428 pd=1.52 as=0.3864 ps=2.1 w=0.42 l=0.15
X372 a_n1432_n107# control_logic_rw_0.dff_buf_array_0.dout_bar_0 a_n1510_n107# din0[1] sky130_fd_pr__nfet_01v8 ad=0.2128 pd=1.88 as=0.1764 ps=1.19 w=0.56 l=0.15
X373 a_n1607_705# control_logic_rw_0.dff_buf_array_0.dout_bar_0 a_n1685_705# din0[1] sky130_fd_pr__nfet_01v8 ad=0.189 pd=1.23 as=0.189 ps=1.23 w=0.6 l=0.15
X374 row_addr_dff_0.dff_3.net1 row_addr_dff_0.dff_3.clkb addr0[0] din0[1] sky130_fd_pr__nfet_01v8 ad=0.2226 pd=1.48 as=0.1932 ps=1.76 w=0.42 l=0.15
X375 row_addr_dff_0.dff_1.net4 row_addr_dff_0.dff_1.clkb row_addr_dff_0.dff_1.net3 din0[1] sky130_fd_pr__pfet_01v8 ad=0.2915 pd=1.61 as=0.352 ps=2.38 w=0.55 l=0.15
X376 din0[1] bank_0.replica_bitcell_array_0.wl_0_15 bank_0.replica_bitcell_array_0.bitcell_array_0.cell_1rw_16.qb din0[1] sky130_fd_pr__nfet_01v8 ad=0.1428 pd=1.52 as=0.3864 ps=2.1 w=0.42 l=0.15
X377 din0[1] bank_0.replica_bitcell_array_0.replica_column_0.replica_cell_1rw_4.q din0[1] din0[1] sky130_fd_pr__pfet_01v8 ad=0.1925 pd=1.8 as=0 ps=0 w=0.55 l=0.15
X378 a_n5369_7383# control_logic_rw_0.delay_chain_0.pinv_11_19.Z a_n5422_7383# din0[1] sky130_fd_pr__nfet_01v8 ad=0.1638 pd=1.62 as=0.1596 ps=1.6 w=0.42 l=0.15
X379 a_n5369_6501# control_logic_rw_0.delay_chain_0.pinv_11_24.Z a_n5422_6501# w_n5644_6180# sky130_fd_pr__pfet_01v8 ad=0.3276 pd=2.46 as=0.3192 ps=2.44 w=0.84 l=0.15
X380 din0[1] bank_0.replica_bitcell_array_0.replica_column_0.replica_cell_1rw_11.q din0[1] din0[1] sky130_fd_pr__pfet_01v8 ad=0.1925 pd=1.8 as=0 ps=0 w=0.55 l=0.15
X381 a_n2461_599# control_logic_rw_0.dff_buf_array_0.dout_bar_0 a_n2515_599# din0[1] sky130_fd_pr__nfet_01v8 ad=0.1596 pd=1.6 as=0.1638 ps=1.62 w=0.42 l=0.15
X382 bank_0.replica_bitcell_array_0.dummy_array_2_0.dummy_cell_1rw_7.q bank_0.replica_bitcell_array_0.dummy_array_2_0.dummy_cell_1rw_7.qb din0[1] din0[1] sky130_fd_pr__nfet_01v8 ad=0.3864 pd=2.1 as=0.441 ps=3.22 w=1.26 l=0.15
X383 bank_0.replica_bitcell_array_0.bitcell_array_0.cell_1rw_14.q bank_0.replica_bitcell_array_0.bitcell_array_0.cell_1rw_14.qb din0[1] din0[1] sky130_fd_pr__pfet_01v8 ad=0.1925 pd=1.8 as=0.1925 ps=1.8 w=0.55 l=0.15
X384 data_dff_0.dff_0.net4 data_dff_0.dff_0.clkb data_dff_0.dff_0.net3 din0[1] sky130_fd_pr__pfet_01v8 ad=0.2915 pd=1.61 as=0.352 ps=2.38 w=0.55 l=0.15
X385 row_addr_dff_0.dff_3.clkb row_addr_dff_0.dff_3.clk din0[1] din0[1] sky130_fd_pr__pfet_01v8 ad=0.253 pd=2.02 as=0.253 ps=2.02 w=0.55 l=0.15
X386 a_739_7029# row_addr_dff_0.dout_3 a_685_7029# w_431_6733# sky130_fd_pr__pfet_01v8 ad=0.3192 pd=2.44 as=0.3276 ps=2.46 w=0.84 l=0.15
X387 a_1822_4485# din0[1] a_1768_4485# din0[1] sky130_fd_pr__nfet_01v8 ad=0.1596 pd=1.6 as=0.1638 ps=1.62 w=0.42 l=0.15
X388 a_n3525_n919# control_logic_rw_0.dff_buf_array_0.dout_bar_0 a_n3579_n919# din0[1] sky130_fd_pr__nfet_01v8 ad=0.1764 pd=1.19 as=0.2184 ps=1.9 w=0.56 l=0.15
X389 a_n1664_n513# control_logic_rw_0.dff_buf_array_0.dout_bar_0 a_n1742_n513# w_n2769_n767# sky130_fd_pr__pfet_01v8 ad=0.3528 pd=1.75 as=0.3528 ps=1.75 w=1.12 l=0.15
X390 din0[1] din0[1] din0[1] din0[1] sky130_fd_pr__nfet_01v8 ad=0.056 pd=0.77 as=0 ps=0 w=0.19 l=10m
X391 din0[1] row_addr_dff_0.dff_0.net3 row_addr_dff_0.dff_0.net2 din0[1] sky130_fd_pr__nfet_01v8 ad=0.168 pd=1.22 as=0.2226 ps=1.9 w=0.42 l=0.15
X392 din0[1] bank_0.replica_bitcell_array_0.wl_0_7 bank_0.replica_bitcell_array_0.bitcell_array_0.cell_1rw_24.q din0[1] sky130_fd_pr__nfet_01v8 ad=0.1428 pd=1.52 as=0.3864 ps=2.1 w=0.42 l=0.15
X393 bank_0.replica_bitcell_array_0.dummy_array_2_0.dummy_cell_1rw_15.q bank_0.replica_bitcell_array_0.dummy_array_2_0.dummy_cell_1rw_15.qb din0[1] din0[1] sky130_fd_pr__pfet_01v8 ad=0.1925 pd=1.8 as=0.1925 ps=1.8 w=0.55 l=0.15
X394 a_n3525_n513# control_logic_rw_0.dff_buf_array_0.dout_bar_0 a_n3579_n513# w_n4225_n767# sky130_fd_pr__pfet_01v8 ad=0.3528 pd=1.75 as=0.4368 ps=3.02 w=1.12 l=0.15
X395 control_logic_rw_0.dff_buf_array_0.dff_buf_0_0.dff_0.clkb din0[1] din0[1] din0[1] sky130_fd_pr__nfet_01v8 ad=0.1932 pd=1.76 as=0.1932 ps=1.76 w=0.42 l=0.15
X396 din0[1] bank_0.replica_bitcell_array_0.bitcell_array_0.cell_1rw_18.q bank_0.replica_bitcell_array_0.bitcell_array_0.cell_1rw_18.qb din0[1] sky130_fd_pr__pfet_01v8 ad=0.1925 pd=1.8 as=0.1925 ps=1.8 w=0.55 l=0.15
X397 data_dff_0.dff_0.net4 din0[1] data_dff_0.dff_0.net3 din0[1] sky130_fd_pr__nfet_01v8 ad=0.2226 pd=1.48 as=0.273 ps=2.14 w=0.42 l=0.15
X398 bank_0.replica_bitcell_array_0.bitcell_array_0.cell_1rw_31.q bank_0.replica_bitcell_array_0.bitcell_array_0.cell_1rw_31.qb din0[1] din0[1] sky130_fd_pr__nfet_01v8 ad=0.3864 pd=2.1 as=0.441 ps=3.22 w=1.26 l=0.15
X399 bank_0.replica_bitcell_array_0.dummy_array_3_0.dummy_cell_1rw_10.q bank_0.replica_bitcell_array_0.dummy_array_3_0.dummy_cell_1rw_10.qb din0[1] din0[1] sky130_fd_pr__nfet_01v8 ad=0.3864 pd=2.1 as=0.441 ps=3.22 w=1.26 l=0.15
X400 bank_0.replica_bitcell_array_0.dummy_array_3_0.dummy_cell_1rw_15.q bank_0.replica_bitcell_array_0.dummy_array_3_0.dummy_cell_1rw_15.qb din0[1] din0[1] sky130_fd_pr__nfet_01v8 ad=0.3864 pd=2.1 as=0.441 ps=3.22 w=1.26 l=0.15
X401 row_addr_dff_0.dff_0.net1 row_addr_dff_0.dff_0.clkb addr0[3] din0[1] sky130_fd_pr__nfet_01v8 ad=0.2226 pd=1.48 as=0.1932 ps=1.76 w=0.42 l=0.15
X402 a_n5369_5809# control_logic_rw_0.delay_chain_0.pinv_11_24.Z a_n5422_5809# din0[1] sky130_fd_pr__nfet_01v8 ad=0.1638 pd=1.62 as=0.1596 ps=1.6 w=0.42 l=0.15
X403 a_3483_4993# control_logic_rw_0.wl_en a_3424_4993# w_2422_4697# sky130_fd_pr__pfet_01v8 ad=0.3192 pd=2.44 as=0.1848 ps=1.28 w=0.84 l=0.15
X404 a_2789_11101# bank_0.port_address_0.hierarchical_decoder_0.predecode_7 a_2730_11101# w_2422_10805# sky130_fd_pr__pfet_01v8 ad=0.3192 pd=2.44 as=0.1848 ps=1.28 w=0.84 l=0.15
X405 row_addr_dff_0.dff_2.net5 row_addr_dff_0.dff_2.clkb row_addr_dff_0.dff_2.net4 din0[1] sky130_fd_pr__nfet_01v8 ad=0.3318 pd=2.42 as=0.2226 ps=1.48 w=0.42 l=0.15
X406 a_n4427_9063# control_logic_rw_0.delay_chain_0.pinv_11_9.Z a_n4480_9063# din0[1] sky130_fd_pr__nfet_01v8 ad=0.1638 pd=1.62 as=0.1596 ps=1.6 w=0.42 l=0.15
X407 bank_0.replica_bitcell_array_0.replica_column_0.replica_cell_1rw_9.q din0[1] din0[1] din0[1] sky130_fd_pr__nfet_01v8 ad=0.3864 pd=2.1 as=0.441 ps=3.22 w=1.26 l=0.15
X408 a_2789_5355# bank_0.port_address_0.hierarchical_decoder_0.predecode_4 bank_0.port_address_0.hierarchical_decoder_0.and2_dec_12.pnand2_0.nmos_m1_w0_840_sactive_dli_0.S din0[1] sky130_fd_pr__nfet_01v8 ad=0.3192 pd=2.44 as=0.1848 ps=1.28 w=0.84 l=0.15
X409 bank_0.replica_bitcell_array_0.replica_column_0.replica_cell_1rw_14.q din0[1] din0[1] din0[1] sky130_fd_pr__nfet_01v8 ad=0.3864 pd=2.1 as=0.441 ps=3.22 w=1.26 l=0.15
X410 din0[1] din0[1] din0[1] din0[1] sky130_fd_pr__pfet_01v8 ad=0.0696 pd=0.9 as=0 ps=0 w=0.55 l=0.15
X411 bank_0.replica_bitcell_array_0.dummy_array_3_0.dummy_cell_1rw_10.q bank_0.replica_bitcell_array_0.wl_0_6 a_5461_6565# din0[1] sky130_fd_pr__nfet_01v8 ad=0.3864 pd=2.1 as=0.1428 ps=1.52 w=0.42 l=0.15
X412 a_n1299_589# control_logic_rw_0.pdriver_1_0.pinv_6_0.A a_n1377_589# din0[1] sky130_fd_pr__nfet_01v8 ad=0.1638 pd=1.15 as=0.1638 ps=1.15 w=0.52 l=0.15
X413 a_3797_6415# din0[1] a_3743_6415# din0[1] sky130_fd_pr__nfet_01v8 ad=0.1596 pd=1.6 as=0.1638 ps=1.62 w=0.42 l=0.15
X414 bank_0.replica_bitcell_array_0.bitcell_array_0.cell_1rw_1.q bank_0.replica_bitcell_array_0.bitcell_array_0.cell_1rw_1.qb din0[1] din0[1] sky130_fd_pr__pfet_01v8 ad=0.1925 pd=1.8 as=0.1925 ps=1.8 w=0.55 l=0.15
X415 bank_0.replica_bitcell_array_0.replica_column_0.replica_cell_1rw_9.q bank_0.replica_bitcell_array_0.wl_0_6 din0[1] din0[1] sky130_fd_pr__nfet_01v8 ad=0.3864 pd=2.1 as=0.1428 ps=1.52 w=0.42 l=0.15
X416 control_logic_rw_0.dff_buf_array_0.dff_buf_0_1.dff_0.net4 control_logic_rw_0.dff_buf_array_0.dff_buf_0_1.dff_0.clkb control_logic_rw_0.dff_buf_array_0.dff_buf_0_1.dff_0.net3 din0[1] sky130_fd_pr__pfet_01v8 ad=0.2915 pd=1.61 as=0.352 ps=2.38 w=0.55 l=0.15
X417 bank_0.replica_bitcell_array_0.bitcell_array_0.cell_1rw_31.qb bank_0.replica_bitcell_array_0.wl_0_0 din0[1] din0[1] sky130_fd_pr__nfet_01v8 ad=0.3864 pd=2.1 as=0.1428 ps=1.52 w=0.42 l=0.15
X418 din0[1] bank_0.replica_bitcell_array_0.replica_column_0.replica_cell_1rw_13.q din0[1] din0[1] sky130_fd_pr__nfet_01v8 ad=0.3864 pd=2.1 as=0 ps=0 w=1.26 l=0.15
X419 bank_0.replica_bitcell_array_0.bitcell_array_0.cell_1rw_2.q bank_0.replica_bitcell_array_0.bitcell_array_0.cell_1rw_2.qb din0[1] din0[1] sky130_fd_pr__pfet_01v8 ad=0.1925 pd=1.8 as=0.1925 ps=1.8 w=0.55 l=0.15
X420 a_n4741_4821# control_logic_rw_0.delay_chain_0.pinv_11_34.Z a_n4794_4821# w_n5644_4500# sky130_fd_pr__pfet_01v8 ad=0.3276 pd=2.46 as=0.3192 ps=2.44 w=0.84 l=0.15
X421 din0[1] din0[1] data_dff_0.dff_0.net5 din0[1] sky130_fd_pr__pfet_01v8 ad=0.22 pd=1.35 as=0.308 ps=2.22 w=0.55 l=0.15
X422 bank_0.replica_bitcell_array_0.dummy_array_3_0.dummy_cell_1rw_6.qb bank_0.replica_bitcell_array_0.wl_0_10 a_5530_8601# din0[1] sky130_fd_pr__nfet_01v8 ad=0.3864 pd=2.1 as=0.1428 ps=1.52 w=0.42 l=0.15
X423 bank_0.port_address_0.hierarchical_decoder_0.and2_dec_6.pnand2_0.nmos_m1_w0_840_sactive_dli_0.S bank_0.port_address_0.hierarchical_decoder_0.predecode_1 a_2676_8409# din0[1] sky130_fd_pr__nfet_01v8 ad=0.1848 pd=1.28 as=0.3276 ps=2.46 w=0.84 l=0.15
X424 din0[1] din0[1] din0[1] din0[1] sky130_fd_pr__nfet_01v8 ad=0.1485 pd=1.34 as=0 ps=0 w=0.57 l=0.15
X425 a_3424_6011# bank_0.port_address_0.wordline_driver_array_0.in_5 a_3370_6011# w_2422_5715# sky130_fd_pr__pfet_01v8 ad=0.1848 pd=1.28 as=0.3276 ps=2.46 w=0.84 l=0.15
X426 bank_0.port_address_0.hierarchical_decoder_0.hierarchical_predecode2x4_1.and2_dec_0.pnand2_0.nmos_m_uq0 din0[1] a_1395_5355# din0[1] sky130_fd_pr__nfet_01v8 ad=0.1848 pd=1.28 as=0.3276 ps=2.46 w=0.84 l=0.15
X427 din0[1] control_logic_rw_0.dff_buf_array_0.dff_buf_0_0.pinv_0_0.A control_logic_rw_0.dff_buf_array_0.dff_buf_0_0.dff_0.net5 din0[1] sky130_fd_pr__nfet_01v8 ad=0.168 pd=1.22 as=0.2352 ps=1.96 w=0.42 l=0.15
X428 a_4490_10451# bank_0.replica_bitcell_array_0.wl_0_13 bank_0.replica_bitcell_array_0.dummy_array_2_0.dummy_cell_1rw_3.qb din0[1] sky130_fd_pr__nfet_01v8 ad=0.1428 pd=1.52 as=0.3864 ps=2.1 w=0.42 l=0.15
X429 a_3483_9937# control_logic_rw_0.wl_en a_3424_9937# w_2422_9787# sky130_fd_pr__pfet_01v8 ad=0.3192 pd=2.44 as=0.1848 ps=1.28 w=0.84 l=0.15
X430 din0[1] bank_0.replica_bitcell_array_0.wl_0_10 din0[1] din0[1] sky130_fd_pr__nfet_01v8 ad=0.3864 pd=2.1 as=0 ps=0 w=0.42 l=0.15
X431 control_logic_rw_0.dff_buf_array_0.dff_buf_0_1.dff_0.net4 din0[1] control_logic_rw_0.dff_buf_array_0.dff_buf_0_1.dff_0.net3 din0[1] sky130_fd_pr__nfet_01v8 ad=0.2226 pd=1.48 as=0.273 ps=2.14 w=0.42 l=0.15
X432 a_n1742_n227# control_logic_rw_0.dff_buf_array_0.dout_bar_0 a_n1796_n227# din0[1] sky130_fd_pr__nfet_01v8 ad=0.1764 pd=1.19 as=0.2184 ps=1.9 w=0.56 l=0.15
X433 row_addr_dff_0.dff_3.net4 row_addr_dff_0.dff_3.clkb row_addr_dff_0.dff_3.net3 din0[1] sky130_fd_pr__pfet_01v8 ad=0.2915 pd=1.61 as=0.352 ps=2.38 w=0.55 l=0.15
X434 a_3424_10083# bank_0.port_address_0.wordline_driver_array_0.in_13 a_3370_10083# w_2422_9787# sky130_fd_pr__pfet_01v8 ad=0.1848 pd=1.28 as=0.3276 ps=2.46 w=0.84 l=0.15
X435 din0[1] bank_0.replica_bitcell_array_0.bitcell_array_0.cell_1rw_5.q bank_0.replica_bitcell_array_0.bitcell_array_0.cell_1rw_5.qb din0[1] sky130_fd_pr__pfet_01v8 ad=0.1925 pd=1.8 as=0.1925 ps=1.8 w=0.55 l=0.15
X436 din0[1] din0[1] data_dff_0.dff_0.net5 din0[1] sky130_fd_pr__nfet_01v8 ad=0.168 pd=1.22 as=0.2352 ps=1.96 w=0.42 l=0.15
X437 a_n1588_123# control_logic_rw_0.dff_buf_array_0.dout_bar_0 a_n1666_123# w_n2769_44# sky130_fd_pr__pfet_01v8 ad=0.3528 pd=1.75 as=0.3528 ps=1.75 w=1.12 l=0.15
X438 din0[1] bank_0.replica_bitcell_array_0.bitcell_array_0.cell_1rw_6.q bank_0.replica_bitcell_array_0.bitcell_array_0.cell_1rw_6.qb din0[1] sky130_fd_pr__nfet_01v8 ad=0.441 pd=3.22 as=0.3864 ps=2.1 w=1.26 l=0.15
X439 a_3797_6521# din0[1] a_3743_6521# din0[1] sky130_fd_pr__nfet_01v8 ad=0.1596 pd=1.6 as=0.1638 ps=1.62 w=0.42 l=0.15
X440 din0[1] row_addr_dff_0.dff_2.net3 row_addr_dff_0.dff_2.net2 din0[1] sky130_fd_pr__nfet_01v8 ad=0.168 pd=1.22 as=0.2226 ps=1.9 w=0.42 l=0.15
X441 din0[1] bank_0.replica_bitcell_array_0.dummy_array_2_0.dummy_cell_1rw_6.q bank_0.replica_bitcell_array_0.dummy_array_2_0.dummy_cell_1rw_6.qb din0[1] sky130_fd_pr__pfet_01v8 ad=0.1925 pd=1.8 as=0.1925 ps=1.8 w=0.55 l=0.15
X442 a_n4113_8181# control_logic_rw_0.delay_chain_0.pinv_11_19.Z a_n4166_8181# w_n5644_7860# sky130_fd_pr__pfet_01v8 ad=0.3276 pd=2.46 as=0.3192 ps=2.44 w=0.84 l=0.15
X443 a_5530_11469# bank_0.replica_bitcell_array_0.wl_0_15 bank_0.replica_bitcell_array_0.dummy_array_3_0.dummy_cell_1rw_1.qb din0[1] sky130_fd_pr__nfet_01v8 ad=0.1428 pd=1.52 as=0.3864 ps=2.1 w=0.42 l=0.15
X444 din0[1] bank_0.replica_bitcell_array_0.dummy_array_2_0.dummy_cell_1rw_7.q bank_0.replica_bitcell_array_0.dummy_array_2_0.dummy_cell_1rw_7.qb din0[1] sky130_fd_pr__nfet_01v8 ad=0.441 pd=3.22 as=0.3864 ps=2.1 w=1.26 l=0.15
X445 a_n1997_927# control_logic_rw_0.dff_buf_array_0.dout_bar_0 a_n2051_927# w_n2769_857# sky130_fd_pr__pfet_01v8 ad=0.378 pd=1.83 as=0.468 ps=3.18 w=1.2 l=0.15
X446 a_5530_3325# bank_0.replica_bitcell_array_0.rbl_wl_0_0 bank_0.replica_bitcell_array_0.dummy_array_3_0.dummy_cell_1rw_17.qb din0[1] sky130_fd_pr__nfet_01v8 ad=0.1428 pd=1.52 as=0.3864 ps=2.1 w=0.42 l=0.15
X447 a_n4113_4969# control_logic_rw_0.delay_chain_0.pinv_11_34.Z a_n4166_4969# w_n5644_4500# sky130_fd_pr__pfet_01v8 ad=0.3276 pd=2.46 as=0.3192 ps=2.44 w=0.84 l=0.15
X448 bank_0.replica_bitcell_array_0.dummy_array_2_0.dummy_cell_1rw_1.q bank_0.replica_bitcell_array_0.dummy_array_2_0.dummy_cell_1rw_1.qb din0[1] din0[1] sky130_fd_pr__pfet_01v8 ad=0.1925 pd=1.8 as=0.1925 ps=1.8 w=0.55 l=0.15
X449 din0[1] bank_0.replica_bitcell_array_0.dummy_array_2_0.dummy_cell_1rw_3.q bank_0.replica_bitcell_array_0.dummy_array_2_0.dummy_cell_1rw_3.qb din0[1] sky130_fd_pr__pfet_01v8 ad=0.1925 pd=1.8 as=0.1925 ps=1.8 w=0.55 l=0.15
X450 din0[1] bank_0.replica_bitcell_array_0.wl_0_11 bank_0.replica_bitcell_array_0.bitcell_array_0.cell_1rw_20.qb din0[1] sky130_fd_pr__nfet_01v8 ad=0.1428 pd=1.52 as=0.3864 ps=2.1 w=0.42 l=0.15
X451 a_4852_1928# control_logic_rw_0.p_en_bar a_4793_1928# w_4605_1519# sky130_fd_pr__pfet_01v8 ad=0.3192 pd=2.44 as=0.1848 ps=1.28 w=0.84 l=0.15
X452 din0[1] bank_0.replica_bitcell_array_0.rbl_wl_0_0 din0[1] din0[1] sky130_fd_pr__nfet_01v8 ad=0.1428 pd=1.52 as=0 ps=0 w=0.42 l=0.15
X453 row_addr_dff_0.dff_2.net1 row_addr_dff_0.dff_2.clkb addr0[1] din0[1] sky130_fd_pr__nfet_01v8 ad=0.2226 pd=1.48 as=0.1932 ps=1.76 w=0.42 l=0.15
X454 data_dff_0.dff_0.clkb din0[1] din0[1] din0[1] sky130_fd_pr__pfet_01v8 ad=0.253 pd=2.02 as=0.044 ps=0.71 w=0.55 l=0.15
X455 din0[1] bank_0.replica_bitcell_array_0.dummy_array_3_0.dummy_cell_1rw_3.q bank_0.replica_bitcell_array_0.dummy_array_3_0.dummy_cell_1rw_3.qb din0[1] sky130_fd_pr__pfet_01v8 ad=0.1925 pd=1.8 as=0.1925 ps=1.8 w=0.55 l=0.15
X456 din0[1] din0[1] din0[1] din0[1] sky130_fd_pr__nfet_01v8 ad=0.45 pd=2.9 as=0 ps=0 w=1 l=0.15
X457 din0[1] bank_0.replica_bitcell_array_0.dummy_array_0_0.dummy_cell_1rw_1.q bank_0.replica_bitcell_array_0.dummy_array_0_0.dummy_cell_1rw_1.qb din0[1] sky130_fd_pr__pfet_01v8 ad=0.1925 pd=1.8 as=0.1925 ps=1.8 w=0.55 l=0.15
X458 din0[1] data_dff_0.dff_0.net4 din0[1] din0[1] sky130_fd_pr__pfet_01v8 ad=0.22 pd=1.35 as=0 ps=0 w=0.55 l=0.15
X459 bank_0.replica_bitcell_array_0.bitcell_array_0.cell_1rw_15.q bank_0.replica_bitcell_array_0.bitcell_array_0.cell_1rw_15.qb din0[1] din0[1] sky130_fd_pr__nfet_01v8 ad=0.3864 pd=2.1 as=0.441 ps=3.22 w=1.26 l=0.15
X460 a_3483_3467# control_logic_rw_0.wl_en bank_0.port_address_0.wordline_driver_array_0.wordline_driver_15.pnand2_0.nmos_m1_w0_840_sli_dactiv_uq0 din0[1] sky130_fd_pr__nfet_01v8 ad=0.3192 pd=2.44 as=0.1848 ps=1.28 w=0.84 l=0.15
X461 a_n1143_n919# control_logic_rw_0.pdriver_0_0.pinv_7_0.A a_n1197_n919# din0[1] sky130_fd_pr__nfet_01v8 ad=0.1795 pd=1.2 as=0.2223 ps=1.92 w=0.57 l=0.15
X462 a_n4113_7489# control_logic_rw_0.delay_chain_0.pinv_11_19.Z a_n4166_7489# din0[1] sky130_fd_pr__nfet_01v8 ad=0.1638 pd=1.62 as=0.1596 ps=1.6 w=0.42 l=0.15
X463 bank_0.replica_bitcell_array_0.bitcell_array_0.cell_1rw_31.q bank_0.replica_bitcell_array_0.bitcell_array_0.cell_1rw_31.qb din0[1] din0[1] sky130_fd_pr__pfet_01v8 ad=0.1925 pd=1.8 as=0.1925 ps=1.8 w=0.55 l=0.15
X464 bank_0.replica_bitcell_array_0.dummy_array_1_0.dummy_cell_1rw_0.qb din0[1] a_5270_2493# din0[1] sky130_fd_pr__nfet_01v8 ad=0.3864 pd=2.1 as=0.1428 ps=1.52 w=0.42 l=0.15
X465 bank_0.replica_bitcell_array_0.dummy_array_2_0.dummy_cell_1rw_16.q bank_0.replica_bitcell_array_0.dummy_array_2_0.dummy_cell_1rw_16.qb din0[1] din0[1] sky130_fd_pr__nfet_01v8 ad=0.3864 pd=2.1 as=0.441 ps=3.22 w=1.26 l=0.15
X466 bank_0.replica_bitcell_array_0.bitcell_array_0.cell_1rw_3.q bank_0.replica_bitcell_array_0.wl_0_12 din0[1] din0[1] sky130_fd_pr__nfet_01v8 ad=0.3864 pd=2.1 as=0.1428 ps=1.52 w=0.42 l=0.15
X467 din0[1] bank_0.replica_bitcell_array_0.replica_column_0.replica_cell_1rw_9.q din0[1] din0[1] sky130_fd_pr__nfet_01v8 ad=0.3864 pd=2.1 as=0 ps=0 w=1.26 l=0.15
X468 din0[1] bank_0.replica_bitcell_array_0.replica_column_0.replica_cell_1rw_14.q din0[1] din0[1] sky130_fd_pr__nfet_01v8 ad=0.3864 pd=2.1 as=0 ps=0 w=1.26 l=0.15
X469 a_n1723_n681# control_logic_rw_0.pdriver_0_0.pinv_6_0.A a_n1777_n681# w_n2769_n767# sky130_fd_pr__pfet_01v8 ad=0.3307 pd=1.68 as=0.4095 ps=2.88 w=1.05 l=0.15
X470 a_n3917_n919# control_logic_rw_0.dff_buf_array_0.dff_buf_0_1.pinv_0_0.A a_n3971_n919# din0[1] sky130_fd_pr__nfet_01v8 ad=0.1323 pd=1.05 as=0.1638 ps=1.62 w=0.42 l=0.15
X471 data_dff_0.dff_0.clkb din0[1] din0[1] din0[1] sky130_fd_pr__nfet_01v8 ad=0.1932 pd=1.76 as=0.0336 ps=0.58 w=0.42 l=0.15
X472 din0[1] bank_0.replica_bitcell_array_0.bitcell_array_0.cell_1rw_0.q bank_0.replica_bitcell_array_0.bitcell_array_0.cell_1rw_0.qb din0[1] sky130_fd_pr__pfet_01v8 ad=0.1925 pd=1.8 as=0.1925 ps=1.8 w=0.55 l=0.15
X473 bank_0.replica_bitcell_array_0.replica_column_0.replica_cell_1rw_1.q din0[1] din0[1] din0[1] sky130_fd_pr__pfet_01v8 ad=0.1925 pd=1.8 as=0.1925 ps=1.8 w=0.55 l=0.15
X474 bank_0.replica_bitcell_array_0.dummy_array_2_0.dummy_cell_1rw_2.q bank_0.replica_bitcell_array_0.dummy_array_2_0.dummy_cell_1rw_2.qb din0[1] din0[1] sky130_fd_pr__nfet_01v8 ad=0.3864 pd=2.1 as=0.441 ps=3.22 w=1.26 l=0.15
X475 a_3103_10487# din0[1] a_3049_10487# din0[1] sky130_fd_pr__nfet_01v8 ad=0.1596 pd=1.6 as=0.1638 ps=1.62 w=0.42 l=0.15
X476 a_2789_7901# bank_0.port_address_0.hierarchical_decoder_0.predecode_6 a_2730_7901# w_2422_7751# sky130_fd_pr__pfet_01v8 ad=0.3192 pd=2.44 as=0.1848 ps=1.28 w=0.84 l=0.15
X477 a_3797_7029# din0[1] a_3743_7029# w_2422_6733# sky130_fd_pr__pfet_01v8 ad=0.3192 pd=2.44 as=0.3276 ps=2.46 w=0.84 l=0.15
X478 a_n5055_5703# control_logic_rw_0.delay_chain_0.pinv_11_29.Z a_n5108_5703# din0[1] sky130_fd_pr__nfet_01v8 ad=0.1638 pd=1.62 as=0.1596 ps=1.6 w=0.42 l=0.15
X479 a_n3917_n513# control_logic_rw_0.dff_buf_array_0.dff_buf_0_0.pinv_0_0.A a_n3971_n513# w_n4225_n767# sky130_fd_pr__pfet_01v8 ad=0.2646 pd=1.47 as=0.3276 ps=2.46 w=0.84 l=0.15
X480 bank_0.replica_bitcell_array_0.dummy_array_2_0.dummy_cell_1rw_18.qb din0[1] a_4490_2493# din0[1] sky130_fd_pr__nfet_01v8 ad=0.3864 pd=2.1 as=0.1428 ps=1.52 w=0.42 l=0.15
X481 a_3483_9427# control_logic_rw_0.wl_en bank_0.port_address_0.wordline_driver_array_0.wordline_driver_4.pnand2_0.nmos_m1_w0_840_sli_dactive_uq0 din0[1] sky130_fd_pr__nfet_01v8 ad=0.3192 pd=2.44 as=0.1848 ps=1.28 w=0.84 l=0.15
X482 a_n5055_3289# control_logic_rw_0.delay_chain_0.pinv_11_39.Z a_n5108_3289# w_n5644_2820# sky130_fd_pr__pfet_01v8 ad=0.3276 pd=2.46 as=0.3192 ps=2.44 w=0.84 l=0.15
X483 bank_0.replica_bitcell_array_0.dummy_array_2_0.dummy_cell_1rw_4.q bank_0.replica_bitcell_array_0.wl_0_12 a_4421_9619# din0[1] sky130_fd_pr__nfet_01v8 ad=0.3864 pd=2.1 as=0.1428 ps=1.52 w=0.42 l=0.15
X484 a_3424_8047# bank_0.port_address_0.wordline_driver_array_0.in_9 a_3370_8047# w_2422_7751# sky130_fd_pr__pfet_01v8 ad=0.1848 pd=1.28 as=0.3276 ps=2.46 w=0.84 l=0.15
X485 a_n4427_4821# control_logic_rw_0.delay_chain_0.pinv_11_34.Z a_n4480_4821# w_n5644_4500# sky130_fd_pr__pfet_01v8 ad=0.3276 pd=2.46 as=0.3192 ps=2.44 w=0.84 l=0.15
X486 din0[1] data_dff_0.dff_0.net4 din0[1] din0[1] sky130_fd_pr__nfet_01v8 ad=0.168 pd=1.22 as=0 ps=0 w=0.42 l=0.15
X487 din0[1] bank_0.replica_bitcell_array_0.wl_0_13 bank_0.replica_bitcell_array_0.bitcell_array_0.cell_1rw_2.q din0[1] sky130_fd_pr__nfet_01v8 ad=0.1428 pd=1.52 as=0.3864 ps=2.1 w=0.42 l=0.15
X488 a_3424_3829# bank_0.port_address_0.wordline_driver_array_0.in_0 a_3370_3829# w_2422_3679# sky130_fd_pr__pfet_01v8 ad=0.1848 pd=1.28 as=0.3276 ps=2.46 w=0.84 l=0.15
X489 din0[1] bank_0.replica_bitcell_array_0.dummy_array_1_0.dummy_cell_1rw_1.q bank_0.replica_bitcell_array_0.dummy_array_1_0.dummy_cell_1rw_1.qb din0[1] sky130_fd_pr__pfet_01v8 ad=0.1925 pd=1.8 as=0.1925 ps=1.8 w=0.55 l=0.15
X490 bank_0.replica_bitcell_array_0.replica_column_0.replica_cell_1rw_2.q din0[1] din0[1] din0[1] sky130_fd_pr__pfet_01v8 ad=0.1925 pd=1.8 as=0.1925 ps=1.8 w=0.55 l=0.15
X491 a_3103_4379# din0[1] a_3049_4379# din0[1] sky130_fd_pr__nfet_01v8 ad=0.1596 pd=1.6 as=0.1638 ps=1.62 w=0.42 l=0.15
X492 bank_0.port_address_0.hierarchical_decoder_0.and2_dec_1.pnand2_0.nmos_m1_w0_840_sactive_dli_0.S bank_0.port_address_0.hierarchical_decoder_0.predecode_2 a_2676_10593# din0[1] sky130_fd_pr__nfet_01v8 ad=0.1848 pd=1.28 as=0.3276 ps=2.46 w=0.84 l=0.15
X493 bank_0.replica_bitcell_array_0.dummy_array_3_0.dummy_cell_1rw_4.q bank_0.replica_bitcell_array_0.dummy_array_3_0.dummy_cell_1rw_4.qb din0[1] din0[1] sky130_fd_pr__pfet_01v8 ad=0.1925 pd=1.8 as=0.1925 ps=1.8 w=0.55 l=0.15
X494 bank_0.replica_bitcell_array_0.bitcell_array_0.cell_1rw_11.qb bank_0.replica_bitcell_array_0.wl_0_4 din0[1] din0[1] sky130_fd_pr__nfet_01v8 ad=0.3864 pd=2.1 as=0.1428 ps=1.52 w=0.42 l=0.15
X495 din0[1] bank_0.replica_bitcell_array_0.bitcell_array_0.cell_1rw_29.q bank_0.replica_bitcell_array_0.bitcell_array_0.cell_1rw_29.qb din0[1] sky130_fd_pr__nfet_01v8 ad=0.441 pd=3.22 as=0.3864 ps=2.1 w=1.26 l=0.15
X496 din0[1] bank_0.replica_bitcell_array_0.dummy_array_3_0.dummy_cell_1rw_8.q bank_0.replica_bitcell_array_0.dummy_array_3_0.dummy_cell_1rw_8.qb din0[1] sky130_fd_pr__pfet_01v8 ad=0.1925 pd=1.8 as=0.1925 ps=1.8 w=0.55 l=0.15
X497 a_n519_n919# control_logic_rw_0.pdriver_0_0.pinv_7_0.A a_n597_n919# din0[1] sky130_fd_pr__nfet_01v8 ad=0.1795 pd=1.2 as=0.1795 ps=1.2 w=0.57 l=0.15
X498 bank_0.replica_bitcell_array_0.dummy_array_3_0.dummy_cell_1rw_17.q bank_0.replica_bitcell_array_0.dummy_array_3_0.dummy_cell_1rw_17.qb din0[1] din0[1] sky130_fd_pr__pfet_01v8 ad=0.1925 pd=1.8 as=0.1925 ps=1.8 w=0.55 l=0.15
X499 bank_0.replica_bitcell_array_0.bitcell_array_0.cell_1rw_26.q bank_0.replica_bitcell_array_0.bitcell_array_0.cell_1rw_26.qb din0[1] din0[1] sky130_fd_pr__pfet_01v8 ad=0.1925 pd=1.8 as=0.1925 ps=1.8 w=0.55 l=0.15
X500 din0[1] bank_0.replica_bitcell_array_0.bitcell_array_0.cell_1rw_1.q bank_0.replica_bitcell_array_0.bitcell_array_0.cell_1rw_1.qb din0[1] sky130_fd_pr__pfet_01v8 ad=0.1925 pd=1.8 as=0.1925 ps=1.8 w=0.55 l=0.15
X501 bank_0.replica_bitcell_array_0.replica_column_0.replica_cell_1rw_3.q din0[1] din0[1] din0[1] sky130_fd_pr__pfet_01v8 ad=0.1925 pd=1.8 as=0.1925 ps=1.8 w=0.55 l=0.15
X502 din0[1] bank_0.replica_bitcell_array_0.dummy_array_3_0.dummy_cell_1rw_4.q bank_0.replica_bitcell_array_0.dummy_array_3_0.dummy_cell_1rw_4.qb din0[1] sky130_fd_pr__nfet_01v8 ad=0.441 pd=3.22 as=0.3864 ps=2.1 w=1.26 l=0.15
X503 a_3797_8557# din0[1] a_3743_8557# din0[1] sky130_fd_pr__nfet_01v8 ad=0.1596 pd=1.6 as=0.1638 ps=1.62 w=0.42 l=0.15
X504 a_1449_7901# bank_0.port_address_0.hierarchical_decoder_0.hierarchical_predecode2x4_0.pinv_1.Z a_1395_7901# w_1141_7751# sky130_fd_pr__pfet_01v8 ad=0.1848 pd=1.28 as=0.3276 ps=2.46 w=0.84 l=0.15
X505 din0[1] bank_0.replica_bitcell_array_0.dummy_array_3_0.dummy_cell_1rw_9.q bank_0.replica_bitcell_array_0.dummy_array_3_0.dummy_cell_1rw_9.qb din0[1] sky130_fd_pr__nfet_01v8 ad=0.441 pd=3.22 as=0.3864 ps=2.1 w=1.26 l=0.15
X506 bank_0.replica_bitcell_array_0.dummy_array_2_0.dummy_cell_1rw_12.qb bank_0.replica_bitcell_array_0.wl_0_4 a_4490_5547# din0[1] sky130_fd_pr__nfet_01v8 ad=0.3864 pd=2.1 as=0.1428 ps=1.52 w=0.42 l=0.15
X507 a_3797_5865# din0[1] a_3743_5865# w_2422_5715# sky130_fd_pr__pfet_01v8 ad=0.3192 pd=2.44 as=0.3276 ps=2.46 w=0.84 l=0.15
X508 bank_0.replica_bitcell_array_0.dummy_array_3_0.dummy_cell_1rw_0.q bank_0.replica_bitcell_array_0.dummy_array_3_0.dummy_cell_1rw_0.qb din0[1] din0[1] sky130_fd_pr__pfet_01v8 ad=0.1925 pd=1.8 as=0.1925 ps=1.8 w=0.55 l=0.15
X509 bank_0.replica_bitcell_array_0.dummy_array_0_0.dummy_cell_1rw_0.q bank_0.replica_bitcell_array_0.dummy_array_0_0.dummy_cell_1rw_0.qb din0[1] din0[1] sky130_fd_pr__nfet_01v8 ad=0.3864 pd=2.1 as=0.441 ps=3.22 w=1.26 l=0.15
X510 bank_0.port_address_0.wordline_driver_array_0.wordline_driver_3.pnand2_0.nmos_m1_w0_840_sli_dactive_uq0 bank_0.port_address_0.wordline_driver_array_0.in_12 a_3370_9575# din0[1] sky130_fd_pr__nfet_01v8 ad=0.1848 pd=1.28 as=0.3276 ps=2.46 w=0.84 l=0.15
X511 din0[1] bank_0.replica_bitcell_array_0.replica_column_0.replica_cell_1rw_7.q din0[1] din0[1] sky130_fd_pr__pfet_01v8 ad=0.1925 pd=1.8 as=0 ps=0 w=0.55 l=0.15
X512 a_5530_5361# bank_0.replica_bitcell_array_0.wl_0_3 bank_0.replica_bitcell_array_0.dummy_array_3_0.dummy_cell_1rw_13.qb din0[1] sky130_fd_pr__nfet_01v8 ad=0.1428 pd=1.52 as=0.3864 ps=2.1 w=0.42 l=0.15
X513 bank_0.replica_bitcell_array_0.replica_column_0.replica_cell_1rw_16.q din0[1] din0[1] din0[1] sky130_fd_pr__pfet_01v8 ad=0.1925 pd=1.8 as=0.1925 ps=1.8 w=0.55 l=0.15
X514 a_3424_6883# bank_0.port_address_0.wordline_driver_array_0.in_6 a_3370_6883# w_2422_6733# sky130_fd_pr__pfet_01v8 ad=0.1848 pd=1.28 as=0.3276 ps=2.46 w=0.84 l=0.15
X515 a_1822_6521# din0[1] a_1768_6521# din0[1] sky130_fd_pr__nfet_01v8 ad=0.1596 pd=1.6 as=0.1638 ps=1.62 w=0.42 l=0.15
X516 a_2789_4993# bank_0.port_address_0.hierarchical_decoder_0.predecode_4 a_2730_4993# w_2422_4697# sky130_fd_pr__pfet_01v8 ad=0.3192 pd=2.44 as=0.1848 ps=1.28 w=0.84 l=0.15
X517 a_n4741_4129# control_logic_rw_0.delay_chain_0.pinv_11_34.Z a_n4794_4129# din0[1] sky130_fd_pr__nfet_01v8 ad=0.1638 pd=1.62 as=0.1596 ps=1.6 w=0.42 l=0.15
X518 din0[1] bank_0.replica_bitcell_array_0.wl_0_3 din0[1] din0[1] sky130_fd_pr__nfet_01v8 ad=0.1428 pd=1.52 as=0 ps=0 w=0.42 l=0.15
X519 bank_0.replica_bitcell_array_0.dummy_array_1_0.dummy_cell_1rw_1.q din0[1] a_4941_2493# din0[1] sky130_fd_pr__nfet_01v8 ad=0.3864 pd=2.1 as=0.1428 ps=1.52 w=0.42 l=0.15
X520 row_addr_dff_0.dff_0.net2 row_addr_dff_0.dff_0.clkb row_addr_dff_0.dff_0.net1 din0[1] sky130_fd_pr__pfet_01v8 ad=0.374 pd=2.46 as=0.2915 ps=1.61 w=0.55 l=0.15
X521 a_3103_10593# din0[1] a_3049_10593# din0[1] sky130_fd_pr__nfet_01v8 ad=0.1596 pd=1.6 as=0.1638 ps=1.62 w=0.42 l=0.15
X522 a_1508_8047# row_addr_dff_0.dout_3 a_1449_8047# w_1141_7751# sky130_fd_pr__pfet_01v8 ad=0.3192 pd=2.44 as=0.1848 ps=1.28 w=0.84 l=0.15
X523 a_1508_3829# bank_0.port_address_0.hierarchical_decoder_0.hierarchical_predecode2x4_1.pinv_0.Z a_1449_3829# w_1141_3679# sky130_fd_pr__pfet_01v8 ad=0.3192 pd=2.44 as=0.1848 ps=1.28 w=0.84 l=0.15
X524 a_n1299_298# control_logic_rw_0.pdriver_1_0.pinv_6_0.A a_n1377_298# w_n2769_44# sky130_fd_pr__pfet_01v8 ad=0.3307 pd=1.68 as=0.3307 ps=1.68 w=1.05 l=0.15
X525 a_n5369_3141# control_logic_rw_0.delay_chain_0.pinv_11_44.Z a_n5422_3141# w_n5644_2820# sky130_fd_pr__pfet_01v8 ad=0.3276 pd=2.46 as=0.3192 ps=2.44 w=0.84 l=0.15
X526 a_n3369_n689# control_logic_rw_0.dff_buf_array_0.dout_bar_0 a_n3447_n689# w_n4225_n767# sky130_fd_pr__pfet_01v8 ad=0.4256 pd=3 as=0.3528 ps=1.75 w=1.12 l=0.15
X527 a_4421_11469# bank_0.replica_bitcell_array_0.wl_0_15 bank_0.replica_bitcell_array_0.dummy_array_2_0.dummy_cell_1rw_1.q din0[1] sky130_fd_pr__nfet_01v8 ad=0.1428 pd=1.52 as=0.3864 ps=2.1 w=0.42 l=0.15
X528 bank_0.replica_bitcell_array_0.bitcell_array_0.cell_1rw_27.q bank_0.replica_bitcell_array_0.bitcell_array_0.cell_1rw_27.qb din0[1] din0[1] sky130_fd_pr__nfet_01v8 ad=0.3864 pd=2.1 as=0.441 ps=3.22 w=1.26 l=0.15
X529 a_3103_4485# din0[1] a_3049_4485# din0[1] sky130_fd_pr__nfet_01v8 ad=0.1596 pd=1.6 as=0.1638 ps=1.62 w=0.42 l=0.15
X530 a_n831_n691# control_logic_rw_0.pdriver_0_0.pinv_7_0.A a_n909_n691# w_n2769_n767# sky130_fd_pr__pfet_01v8 ad=0.3622 pd=1.78 as=0.3622 ps=1.78 w=1.15 l=0.15
X531 bank_0.replica_bitcell_array_0.dummy_array_0.dummy_cell_1rw_1.q bank_0.replica_bitcell_array_0.dummy_array_0.dummy_cell_1rw_1.qb din0[1] din0[1] sky130_fd_pr__nfet_01v8 ad=0.3864 pd=2.1 as=0.441 ps=3.22 w=1.26 l=0.15
X532 a_5461_11469# bank_0.replica_bitcell_array_0.wl_0_15 bank_0.replica_bitcell_array_0.dummy_array_3_0.dummy_cell_1rw_1.q din0[1] sky130_fd_pr__nfet_01v8 ad=0.1428 pd=1.52 as=0.3864 ps=2.1 w=0.42 l=0.15
X533 bank_0.replica_bitcell_array_0.dummy_array_3_0.dummy_cell_1rw_11.q bank_0.replica_bitcell_array_0.dummy_array_3_0.dummy_cell_1rw_11.qb din0[1] din0[1] sky130_fd_pr__nfet_01v8 ad=0.3864 pd=2.1 as=0.441 ps=3.22 w=1.26 l=0.15
X534 a_5112_1928# control_logic_rw_0.p_en_bar a_5053_1928# w_4605_1519# sky130_fd_pr__pfet_01v8 ad=0.3192 pd=2.44 as=0.1848 ps=1.28 w=0.84 l=0.15
X535 din0[1] bank_0.replica_bitcell_array_0.dummy_array_3_0.dummy_cell_1rw_15.q bank_0.replica_bitcell_array_0.dummy_array_3_0.dummy_cell_1rw_15.qb din0[1] sky130_fd_pr__pfet_01v8 ad=0.1925 pd=1.8 as=0.1925 ps=1.8 w=0.55 l=0.15
X536 control_logic_rw_0.dff_buf_array_0.dff_buf_0_0.dff_0.net3 control_logic_rw_0.dff_buf_array_0.dff_buf_0_0.dff_0.net1 din0[1] din0[1] sky130_fd_pr__nfet_01v8 ad=0.2604 pd=2.08 as=0.168 ps=1.22 w=0.42 l=0.15
X537 din0[1] bank_0.replica_bitcell_array_0.dummy_array_2_0.dummy_cell_1rw_0.q bank_0.replica_bitcell_array_0.dummy_array_2_0.dummy_cell_1rw_0.qb din0[1] sky130_fd_pr__pfet_01v8 ad=0.1925 pd=1.8 as=0.1925 ps=1.8 w=0.55 l=0.15
X538 bank_0.replica_bitcell_array_0.bitcell_array_0.cell_1rw_27.q bank_0.replica_bitcell_array_0.wl_0_4 din0[1] din0[1] sky130_fd_pr__nfet_01v8 ad=0.3864 pd=2.1 as=0.1428 ps=1.52 w=0.42 l=0.15
X539 a_1449_4993# din0[1] a_1395_4993# w_1141_4697# sky130_fd_pr__pfet_01v8 ad=0.1848 pd=1.28 as=0.3276 ps=2.46 w=0.84 l=0.15
X540 a_n1118_n227# control_logic_rw_0.dff_buf_array_0.dout_bar_0 a_n1196_n227# din0[1] sky130_fd_pr__nfet_01v8 ad=0.2128 pd=1.88 as=0.1764 ps=1.19 w=0.56 l=0.15
X541 a_n5369_9861# control_logic_rw_0.delay_chain_0.out a_n5422_9861# w_n5644_9540# sky130_fd_pr__pfet_01v8 ad=0.3276 pd=2.46 as=0.3192 ps=2.44 w=0.84 l=0.15
X542 bank_0.replica_bitcell_array_0.dummy_array_3_0.dummy_cell_1rw_6.q bank_0.replica_bitcell_array_0.wl_0_10 a_5461_8601# din0[1] sky130_fd_pr__nfet_01v8 ad=0.3864 pd=2.1 as=0.1428 ps=1.52 w=0.42 l=0.15
X543 bank_0.replica_bitcell_array_0.replica_column_0.replica_cell_1rw_10.q din0[1] din0[1] din0[1] sky130_fd_pr__nfet_01v8 ad=0.3864 pd=2.1 as=0.441 ps=3.22 w=1.26 l=0.15
X544 control_logic_rw_0.dff_buf_array_0.dff_buf_0_1.dff_0.net5 din0[1] control_logic_rw_0.dff_buf_array_0.dff_buf_0_1.dff_0.net4 din0[1] sky130_fd_pr__pfet_01v8 ad=0.4345 pd=2.68 as=0.2915 ps=1.61 w=0.55 l=0.15
X545 a_2789_11463# bank_0.port_address_0.hierarchical_decoder_0.predecode_7 bank_0.port_address_0.hierarchical_decoder_0.and2_dec_0.pnand2_0.nmos_m1_w0_840_sactive_dli_0.S din0[1] sky130_fd_pr__nfet_01v8 ad=0.3192 pd=2.44 as=0.1848 ps=1.28 w=0.84 l=0.15
X546 a_2789_9937# bank_0.port_address_0.hierarchical_decoder_0.predecode_7 a_2730_9937# w_2422_9787# sky130_fd_pr__pfet_01v8 ad=0.3192 pd=2.44 as=0.1848 ps=1.28 w=0.84 l=0.15
X547 a_1508_6883# bank_0.port_address_0.hierarchical_decoder_0.hierarchical_predecode2x4_0.pinv_0.Z a_1449_6883# w_1141_6733# sky130_fd_pr__pfet_01v8 ad=0.3192 pd=2.44 as=0.1848 ps=1.28 w=0.84 l=0.15
X548 a_2730_6011# bank_0.port_address_0.hierarchical_decoder_0.predecode_1 a_2676_6011# w_2422_5715# sky130_fd_pr__pfet_01v8 ad=0.1848 pd=1.28 as=0.3276 ps=2.46 w=0.84 l=0.15
X549 din0[1] bank_0.replica_bitcell_array_0.bitcell_array_0.cell_1rw_15.q bank_0.replica_bitcell_array_0.bitcell_array_0.cell_1rw_15.qb din0[1] sky130_fd_pr__nfet_01v8 ad=0.441 pd=3.22 as=0.3864 ps=2.1 w=1.26 l=0.15
X550 din0[1] bank_0.replica_bitcell_array_0.dummy_array_3_0.dummy_cell_1rw_0.q bank_0.replica_bitcell_array_0.dummy_array_3_0.dummy_cell_1rw_0.qb din0[1] sky130_fd_pr__pfet_01v8 ad=0.1925 pd=1.8 as=0.1925 ps=1.8 w=0.55 l=0.15
X551 bank_0.replica_bitcell_array_0.dummy_array_2_0.dummy_cell_1rw_3.q bank_0.replica_bitcell_array_0.dummy_array_2_0.dummy_cell_1rw_3.qb din0[1] din0[1] sky130_fd_pr__nfet_01v8 ad=0.3864 pd=2.1 as=0.441 ps=3.22 w=1.26 l=0.15
X552 din0[1] bank_0.replica_bitcell_array_0.replica_column_0.replica_cell_1rw_14.q din0[1] din0[1] sky130_fd_pr__pfet_01v8 ad=0.1925 pd=1.8 as=0 ps=0 w=0.55 l=0.15
X553 bank_0.replica_bitcell_array_0.bitcell_array_0.cell_1rw_15.q bank_0.replica_bitcell_array_0.bitcell_array_0.cell_1rw_15.qb din0[1] din0[1] sky130_fd_pr__pfet_01v8 ad=0.1925 pd=1.8 as=0.1925 ps=1.8 w=0.55 l=0.15
X554 a_n5369_2449# control_logic_rw_0.delay_chain_0.pinv_11_44.Z a_n5422_2449# din0[1] sky130_fd_pr__nfet_01v8 ad=0.1638 pd=1.62 as=0.1596 ps=1.6 w=0.42 l=0.15
X555 bank_0.port_address_0.and2_dec_0_0.pnand2_0.nmos_m1_w0_840_sactive_dli_0.S control_logic_rw_0.wl_en a_3370_3319# din0[1] sky130_fd_pr__nfet_01v8 ad=0.1848 pd=1.28 as=0.3276 ps=2.46 w=0.84 l=0.15
X556 bank_0.replica_bitcell_array_0.replica_column_0.replica_cell_1rw_5.q bank_0.replica_bitcell_array_0.wl_0_10 din0[1] din0[1] sky130_fd_pr__nfet_01v8 ad=0.3864 pd=2.1 as=0.1428 ps=1.52 w=0.42 l=0.15
X557 din0[1] bank_0.replica_bitcell_array_0.bitcell_array_0.cell_1rw_22.q bank_0.replica_bitcell_array_0.bitcell_array_0.cell_1rw_22.qb din0[1] sky130_fd_pr__pfet_01v8 ad=0.1925 pd=1.8 as=0.1925 ps=1.8 w=0.55 l=0.15
X558 din0[1] bank_0.replica_bitcell_array_0.bitcell_array_0.cell_1rw_29.q bank_0.replica_bitcell_array_0.bitcell_array_0.cell_1rw_29.qb din0[1] sky130_fd_pr__pfet_01v8 ad=0.1925 pd=1.8 as=0.1925 ps=1.8 w=0.55 l=0.15
X559 a_1822_7029# din0[1] a_1768_7029# w_1141_6733# sky130_fd_pr__pfet_01v8 ad=0.3192 pd=2.44 as=0.3276 ps=2.46 w=0.84 l=0.15
X560 din0[1] bank_0.replica_bitcell_array_0.dummy_array_2_0.dummy_cell_1rw_16.q bank_0.replica_bitcell_array_0.dummy_array_2_0.dummy_cell_1rw_16.qb din0[1] sky130_fd_pr__nfet_01v8 ad=0.441 pd=3.22 as=0.3864 ps=2.1 w=1.26 l=0.15
X561 din0[1] bank_0.replica_bitcell_array_0.bitcell_array_0.cell_1rw_25.q bank_0.replica_bitcell_array_0.bitcell_array_0.cell_1rw_25.qb din0[1] sky130_fd_pr__nfet_01v8 ad=0.441 pd=3.22 as=0.3864 ps=2.1 w=1.26 l=0.15
X562 din0[1] bank_0.replica_bitcell_array_0.bitcell_array_0.cell_1rw_30.q bank_0.replica_bitcell_array_0.bitcell_array_0.cell_1rw_30.qb din0[1] sky130_fd_pr__nfet_01v8 ad=0.441 pd=3.22 as=0.3864 ps=2.1 w=1.26 l=0.15
X563 bank_0.replica_bitcell_array_0.dummy_array_2_0.dummy_cell_1rw_16.q bank_0.replica_bitcell_array_0.dummy_array_2_0.dummy_cell_1rw_16.qb din0[1] din0[1] sky130_fd_pr__pfet_01v8 ad=0.1925 pd=1.8 as=0.1925 ps=1.8 w=0.55 l=0.15
X564 a_n1529_705# control_logic_rw_0.dff_buf_array_0.dout_bar_0 a_n1607_705# din0[1] sky130_fd_pr__nfet_01v8 ad=0.228 pd=1.96 as=0.189 ps=1.23 w=0.6 l=0.15
X565 din0[1] bank_0.replica_bitcell_array_0.dummy_array_3_0.dummy_cell_1rw_4.q bank_0.replica_bitcell_array_0.dummy_array_3_0.dummy_cell_1rw_4.qb din0[1] sky130_fd_pr__pfet_01v8 ad=0.1925 pd=1.8 as=0.1925 ps=1.8 w=0.55 l=0.15
X566 control_logic_rw_0.dff_buf_array_0.dff_buf_0_1.dff_0.net5 control_logic_rw_0.dff_buf_array_0.dff_buf_0_1.dff_0.clkb control_logic_rw_0.dff_buf_array_0.dff_buf_0_1.dff_0.net4 din0[1] sky130_fd_pr__nfet_01v8 ad=0.3318 pd=2.42 as=0.2226 ps=1.48 w=0.42 l=0.15
X567 bank_0.port_data_0.write_driver_array_0.write_driver_0.net5 din0[1] din0[1] din0[1] sky130_fd_pr__pfet_01v8 ad=0.275 pd=2.1 as=0.2722 ps=1.54 w=0.55 l=0.15
X568 bank_0.replica_bitcell_array_0.dummy_array_3_0.dummy_cell_1rw_1.q bank_0.replica_bitcell_array_0.dummy_array_3_0.dummy_cell_1rw_1.qb din0[1] din0[1] sky130_fd_pr__nfet_01v8 ad=0.3864 pd=2.1 as=0.441 ps=3.22 w=1.26 l=0.15
X569 bank_0.replica_bitcell_array_0.bitcell_array_0.cell_1rw_1.qb bank_0.replica_bitcell_array_0.wl_0_14 din0[1] din0[1] sky130_fd_pr__nfet_01v8 ad=0.3864 pd=2.1 as=0.1428 ps=1.52 w=0.42 l=0.15
X570 din0[1] bank_0.replica_bitcell_array_0.dummy_array_3_0.dummy_cell_1rw_5.q bank_0.replica_bitcell_array_0.dummy_array_3_0.dummy_cell_1rw_5.qb din0[1] sky130_fd_pr__nfet_01v8 ad=0.441 pd=3.22 as=0.3864 ps=2.1 w=1.26 l=0.15
X571 din0[1] bank_0.replica_bitcell_array_0.wl_0_5 bank_0.replica_bitcell_array_0.bitcell_array_0.cell_1rw_10.q din0[1] sky130_fd_pr__nfet_01v8 ad=0.1428 pd=1.52 as=0.3864 ps=2.1 w=0.42 l=0.15
X572 a_5461_3325# bank_0.replica_bitcell_array_0.rbl_wl_0_0 bank_0.replica_bitcell_array_0.dummy_array_3_0.dummy_cell_1rw_17.q din0[1] sky130_fd_pr__nfet_01v8 ad=0.1428 pd=1.52 as=0.3864 ps=2.1 w=0.42 l=0.15
X573 din0[1] bank_0.replica_bitcell_array_0.replica_column_0.replica_cell_1rw_3.q din0[1] din0[1] sky130_fd_pr__pfet_01v8 ad=0.1925 pd=1.8 as=0 ps=0 w=0.55 l=0.15
X574 bank_0.port_address_0.wordline_driver_array_0.wordline_driver_10.pnand2_0.nmos_m1_w0_840_sli_dactiv_uq0 bank_0.port_address_0.wordline_driver_array_0.in_5 a_3370_6373# din0[1] sky130_fd_pr__nfet_01v8 ad=0.1848 pd=1.28 as=0.3276 ps=2.46 w=0.84 l=0.15
X575 a_n1586_n513# control_logic_rw_0.dff_buf_array_0.dout_bar_0 a_n1664_n513# w_n2769_n767# sky130_fd_pr__pfet_01v8 ad=0.3528 pd=1.75 as=0.3528 ps=1.75 w=1.12 l=0.15
X576 din0[1] din0[1] bank_0.port_data_0.write_driver_array_0.write_driver_0.net5 din0[1] sky130_fd_pr__pfet_01v8 ad=0.165 pd=1.15 as=0.275 ps=2.1 w=0.55 l=0.15
X577 a_n4741_8329# control_logic_rw_0.delay_chain_0.pinv_11_9.Z a_n4794_8329# w_n5644_7860# sky130_fd_pr__pfet_01v8 ad=0.3276 pd=2.46 as=0.3192 ps=2.44 w=0.84 l=0.15
X578 a_4421_6379# bank_0.replica_bitcell_array_0.wl_0_5 bank_0.replica_bitcell_array_0.dummy_array_2_0.dummy_cell_1rw_11.q din0[1] sky130_fd_pr__nfet_01v8 ad=0.1428 pd=1.52 as=0.3864 ps=2.1 w=0.42 l=0.15
X579 din0[1] bank_0.replica_bitcell_array_0.rbl_wl_0_0 bank_0.replica_bitcell_array_0.replica_column_0.replica_cell_1rw_16.q din0[1] sky130_fd_pr__nfet_01v8 ad=0.1428 pd=1.52 as=0.3864 ps=2.1 w=0.42 l=0.15
X580 din0[1] bank_0.replica_bitcell_array_0.bitcell_array_0.cell_1rw_1.q bank_0.replica_bitcell_array_0.bitcell_array_0.cell_1rw_1.qb din0[1] sky130_fd_pr__nfet_01v8 ad=0.441 pd=3.22 as=0.3864 ps=2.1 w=1.26 l=0.15
X581 bank_0.replica_bitcell_array_0.bitcell_array_0.cell_1rw_10.q bank_0.replica_bitcell_array_0.bitcell_array_0.cell_1rw_10.qb din0[1] din0[1] sky130_fd_pr__pfet_01v8 ad=0.1925 pd=1.8 as=0.1925 ps=1.8 w=0.55 l=0.15
X582 a_n2330_1957# control_logic_rw_0.pand3_0_0.pnand3_0_0.nmos_m1_w0_840_sactive_dli_0.G a_n2402_1923# w_n2769_1669# sky130_fd_pr__pfet_01v8 ad=0.0544 pd=0.98 as=0.1848 ps=1.28 w=0.38 l=0.28
X583 bank_0.replica_bitcell_array_0.dummy_array_0_0.dummy_cell_1rw_1.q bank_0.replica_bitcell_array_0.dummy_array_0_0.dummy_cell_1rw_1.qb din0[1] din0[1] sky130_fd_pr__pfet_01v8 ad=0.1925 pd=1.8 as=0.1925 ps=1.8 w=0.55 l=0.15
X584 bank_0.replica_bitcell_array_0.replica_column_0.dummy_cell_1rw_0.q bank_0.replica_bitcell_array_0.replica_column_0.dummy_cell_1rw_0.qb din0[1] din0[1] sky130_fd_pr__nfet_01v8 ad=0.3864 pd=2.1 as=0.441 ps=3.22 w=1.26 l=0.15
X585 row_addr_dff_0.dff_2.net2 row_addr_dff_0.dff_2.clkb row_addr_dff_0.dff_2.net1 din0[1] sky130_fd_pr__pfet_01v8 ad=0.374 pd=2.46 as=0.2915 ps=1.61 w=0.55 l=0.15
X586 a_n4427_4129# control_logic_rw_0.delay_chain_0.pinv_11_34.Z a_n4480_4129# din0[1] sky130_fd_pr__nfet_01v8 ad=0.1638 pd=1.62 as=0.1596 ps=1.6 w=0.42 l=0.15
X587 a_2789_3467# bank_0.port_address_0.hierarchical_decoder_0.predecode_4 bank_0.port_address_0.hierarchical_decoder_0.and2_dec_15.pnand2_0.nmos_m1_w0_840_sactive_dli_0.S din0[1] sky130_fd_pr__nfet_01v8 ad=0.3192 pd=2.44 as=0.1848 ps=1.28 w=0.84 l=0.15
X588 din0[1] control_logic_rw_0.dff_buf_array_0.dff_buf_0_0.dff_0.net3 control_logic_rw_0.dff_buf_array_0.dff_buf_0_0.dff_0.net2 din0[1] sky130_fd_pr__nfet_01v8 ad=0.168 pd=1.22 as=0.2226 ps=1.9 w=0.42 l=0.15
X589 bank_0.replica_bitcell_array_0.dummy_array_0_0.dummy_cell_1rw_1.qb din0[1] a_5010_11655# din0[1] sky130_fd_pr__nfet_01v8 ad=0.3864 pd=2.1 as=0.1428 ps=1.52 w=0.42 l=0.15
X590 bank_0.replica_bitcell_array_0.dummy_array_2_0.dummy_cell_1rw_11.q bank_0.replica_bitcell_array_0.dummy_array_2_0.dummy_cell_1rw_11.qb din0[1] din0[1] sky130_fd_pr__pfet_01v8 ad=0.1925 pd=1.8 as=0.1925 ps=1.8 w=0.55 l=0.15
X591 row_addr_dff_0.dff_1.net3 row_addr_dff_0.dff_1.net1 din0[1] din0[1] sky130_fd_pr__pfet_01v8 ad=0.3465 pd=2.36 as=0.22 ps=1.35 w=0.55 l=0.15
X592 bank_0.replica_bitcell_array_0.bitcell_array_0.cell_1rw_23.q bank_0.replica_bitcell_array_0.bitcell_array_0.cell_1rw_23.qb din0[1] din0[1] sky130_fd_pr__nfet_01v8 ad=0.3864 pd=2.1 as=0.441 ps=3.22 w=1.26 l=0.15
X593 bank_0.replica_bitcell_array_0.bitcell_array_0.cell_1rw_28.q bank_0.replica_bitcell_array_0.bitcell_array_0.cell_1rw_28.qb din0[1] din0[1] sky130_fd_pr__nfet_01v8 ad=0.3864 pd=2.1 as=0.441 ps=3.22 w=1.26 l=0.15
X594 a_n2461_n919# clk0 a_n2515_n919# din0[1] sky130_fd_pr__nfet_01v8 ad=0.1596 pd=1.6 as=0.1638 ps=1.62 w=0.42 l=0.15
X595 a_n2402_963# control_logic_rw_0.pand3_0.B a_n2461_963# w_n2769_857# sky130_fd_pr__pfet_01v8 ad=0.1848 pd=1.28 as=0.1848 ps=1.28 w=0.84 l=0.15
X596 a_n2461_n513# din0[1] a_n2515_n513# w_n2769_n767# sky130_fd_pr__pfet_01v8 ad=0.3192 pd=2.44 as=0.3276 ps=2.46 w=0.84 l=0.15
X597 a_2789_9427# bank_0.port_address_0.hierarchical_decoder_0.predecode_6 bank_0.port_address_0.hierarchical_decoder_0.and2_dec_4.pnand2_0.nmos_m1_w0_840_sactive_dli_0.S din0[1] sky130_fd_pr__nfet_01v8 ad=0.3192 pd=2.44 as=0.1848 ps=1.28 w=0.84 l=0.15
X598 data_dff_0.dff_1.net2 data_dff_0.dff_1.clkb data_dff_0.dff_1.net1 din0[1] sky130_fd_pr__pfet_01v8 ad=0.374 pd=2.46 as=0.2915 ps=1.61 w=0.55 l=0.15
X599 a_n2147_299# control_logic_rw_0.pdriver_1_0.pinv_8_0.A a_n2201_299# w_n2769_44# sky130_fd_pr__pfet_01v8 ad=0.3192 pd=2.44 as=0.3276 ps=2.46 w=0.84 l=0.15
X600 a_n1221_589# control_logic_rw_0.pdriver_1_0.pinv_6_0.A a_n1299_589# din0[1] sky130_fd_pr__nfet_01v8 ad=0.1638 pd=1.15 as=0.1638 ps=1.15 w=0.52 l=0.15
X601 din0[1] bank_0.replica_bitcell_array_0.bitcell_array_0.cell_1rw_16.q bank_0.replica_bitcell_array_0.bitcell_array_0.cell_1rw_16.qb din0[1] sky130_fd_pr__nfet_01v8 ad=0.441 pd=3.22 as=0.3864 ps=2.1 w=1.26 l=0.15
X602 a_2730_8047# bank_0.port_address_0.hierarchical_decoder_0.predecode_1 a_2676_8047# w_2422_7751# sky130_fd_pr__pfet_01v8 ad=0.1848 pd=1.28 as=0.3276 ps=2.46 w=0.84 l=0.15
X603 din0[1] bank_0.replica_bitcell_array_0.wl_0_15 bank_0.replica_bitcell_array_0.bitcell_array_0.cell_1rw_16.q din0[1] sky130_fd_pr__nfet_01v8 ad=0.1428 pd=1.52 as=0.3864 ps=2.1 w=0.42 l=0.15
X604 a_3483_5503# control_logic_rw_0.wl_en bank_0.port_address_0.wordline_driver_array_0.wordline_driver_11.pnand2_0.nmos_m1_w0_840_sli_dactiv_uq0 din0[1] sky130_fd_pr__nfet_01v8 ad=0.3192 pd=2.44 as=0.1848 ps=1.28 w=0.84 l=0.15
X605 bank_0.replica_bitcell_array_0.bitcell_array_0.cell_1rw_11.q bank_0.replica_bitcell_array_0.bitcell_array_0.cell_1rw_11.qb din0[1] din0[1] sky130_fd_pr__nfet_01v8 ad=0.3864 pd=2.1 as=0.441 ps=3.22 w=1.26 l=0.15
X606 a_2730_3829# bank_0.port_address_0.hierarchical_decoder_0.predecode_0 a_2676_3829# w_2422_3679# sky130_fd_pr__pfet_01v8 ad=0.1848 pd=1.28 as=0.3276 ps=2.46 w=0.84 l=0.15
X607 bank_0.port_address_0.hierarchical_decoder_0.hierarchical_predecode2x4_1.and2_dec_3.pnand2_0.nmos_m_uq0 bank_0.port_address_0.hierarchical_decoder_0.hierarchical_predecode2x4_1.pinv_1.Z a_1395_3467# din0[1] sky130_fd_pr__nfet_01v8 ad=0.1848 pd=1.28 as=0.3276 ps=2.46 w=0.84 l=0.15
X608 din0[1] bank_0.replica_bitcell_array_0.dummy_array_3_0.dummy_cell_1rw_18.q bank_0.replica_bitcell_array_0.dummy_array_3_0.dummy_cell_1rw_18.qb din0[1] sky130_fd_pr__nfet_01v8 ad=0.441 pd=3.22 as=0.3864 ps=2.1 w=1.26 l=0.15
X609 bank_0.replica_bitcell_array_0.dummy_array_0.dummy_cell_1rw_0.q bank_0.replica_bitcell_array_0.dummy_array_0.dummy_cell_1rw_0.qb din0[1] din0[1] sky130_fd_pr__nfet_01v8 ad=0.3864 pd=2.1 as=0.441 ps=3.22 w=1.26 l=0.15
X610 a_n1664_n227# control_logic_rw_0.dff_buf_array_0.dout_bar_0 a_n1742_n227# din0[1] sky130_fd_pr__nfet_01v8 ad=0.1764 pd=1.19 as=0.1764 ps=1.19 w=0.56 l=0.15
X611 bank_0.replica_bitcell_array_0.bitcell_array_0.cell_1rw_23.qb bank_0.replica_bitcell_array_0.wl_0_8 din0[1] din0[1] sky130_fd_pr__nfet_01v8 ad=0.3864 pd=2.1 as=0.1428 ps=1.52 w=0.42 l=0.15
X612 a_n5369_6649# control_logic_rw_0.delay_chain_0.pinv_11_19.Z a_n5422_6649# w_n5644_6180# sky130_fd_pr__pfet_01v8 ad=0.3276 pd=2.46 as=0.3192 ps=2.44 w=0.84 l=0.15
X613 din0[1] data_dff_0.dff_0.net3 data_dff_0.dff_0.net2 din0[1] sky130_fd_pr__pfet_01v8 ad=0.22 pd=1.35 as=0.2915 ps=2.16 w=0.55 l=0.15
X614 a_n3525_n227# control_logic_rw_0.dff_buf_array_0.dout_bar_0 a_n3579_n227# din0[1] sky130_fd_pr__nfet_01v8 ad=0.1764 pd=1.19 as=0.2184 ps=1.9 w=0.56 l=0.15
X615 a_2730_11101# bank_0.port_address_0.hierarchical_decoder_0.predecode_3 a_2676_11101# w_2422_10805# sky130_fd_pr__pfet_01v8 ad=0.1848 pd=1.28 as=0.3276 ps=2.46 w=0.84 l=0.15
X616 bank_0.replica_bitcell_array_0.dummy_array_2_0.dummy_cell_1rw_12.q bank_0.replica_bitcell_array_0.dummy_array_2_0.dummy_cell_1rw_12.qb din0[1] din0[1] sky130_fd_pr__nfet_01v8 ad=0.3864 pd=2.1 as=0.441 ps=3.22 w=1.26 l=0.15
X617 bank_0.replica_bitcell_array_0.dummy_array_2_0.dummy_cell_1rw_17.q bank_0.replica_bitcell_array_0.dummy_array_2_0.dummy_cell_1rw_17.qb din0[1] din0[1] sky130_fd_pr__nfet_01v8 ad=0.3864 pd=2.1 as=0.441 ps=3.22 w=1.26 l=0.15
X618 din0[1] bank_0.replica_bitcell_array_0.replica_column_0.replica_cell_1rw_10.q din0[1] din0[1] sky130_fd_pr__nfet_01v8 ad=0.3864 pd=2.1 as=0 ps=0 w=1.26 l=0.15
X619 data_dff_0.dff_1.net2 din0[1] data_dff_0.dff_1.net1 din0[1] sky130_fd_pr__nfet_01v8 ad=0.2856 pd=2.2 as=0.2226 ps=1.48 w=0.42 l=0.15
X620 bank_0.port_address_0.hierarchical_decoder_0.and2_dec_3.pnand2_0.nmos_m1_w0_840_sactive_dli_0.S bank_0.port_address_0.hierarchical_decoder_0.predecode_0 a_2676_9575# din0[1] sky130_fd_pr__nfet_01v8 ad=0.1848 pd=1.28 as=0.3276 ps=2.46 w=0.84 l=0.15
X621 a_n1900_n107# control_logic_rw_0.dff_buf_array_0.dout_bar_0 a_n1978_n107# din0[1] sky130_fd_pr__nfet_01v8 ad=0.1764 pd=1.19 as=0.1764 ps=1.19 w=0.56 l=0.15
X622 a_2730_6883# bank_0.port_address_0.hierarchical_decoder_0.predecode_2 a_2676_6883# w_2422_6733# sky130_fd_pr__pfet_01v8 ad=0.1848 pd=1.28 as=0.3276 ps=2.46 w=0.84 l=0.15
X623 row_addr_dff_0.dff_0.net5 row_addr_dff_0.dff_3.clk row_addr_dff_0.dff_0.net4 din0[1] sky130_fd_pr__pfet_01v8 ad=0.4345 pd=2.68 as=0.2915 ps=1.61 w=0.55 l=0.15
X624 a_3103_6415# din0[1] a_3049_6415# din0[1] sky130_fd_pr__nfet_01v8 ad=0.1596 pd=1.6 as=0.1638 ps=1.62 w=0.42 l=0.15
X625 a_5461_5361# bank_0.replica_bitcell_array_0.wl_0_3 bank_0.replica_bitcell_array_0.dummy_array_3_0.dummy_cell_1rw_13.q din0[1] sky130_fd_pr__nfet_01v8 ad=0.1428 pd=1.52 as=0.3864 ps=2.1 w=0.42 l=0.15
X626 din0[1] data_dff_0.dff_0.net3 data_dff_0.dff_0.net2 din0[1] sky130_fd_pr__nfet_01v8 ad=0.168 pd=1.22 as=0.2226 ps=1.9 w=0.42 l=0.15
X627 a_n1510_123# control_logic_rw_0.dff_buf_array_0.dout_bar_0 a_n1588_123# w_n2769_44# sky130_fd_pr__pfet_01v8 ad=0.3528 pd=1.75 as=0.3528 ps=1.75 w=1.12 l=0.15
X628 a_3103_11101# din0[1] a_3049_11101# w_2422_10805# sky130_fd_pr__pfet_01v8 ad=0.3192 pd=2.44 as=0.3276 ps=2.46 w=0.84 l=0.15
X629 a_n5369_9169# control_logic_rw_0.delay_chain_0.out a_n5422_9169# din0[1] sky130_fd_pr__nfet_01v8 ad=0.1638 pd=1.62 as=0.1596 ps=1.6 w=0.42 l=0.15
X630 bank_0.replica_bitcell_array_0.bitcell_array_0.cell_1rw_16.q bank_0.replica_bitcell_array_0.bitcell_array_0.cell_1rw_16.qb din0[1] din0[1] sky130_fd_pr__nfet_01v8 ad=0.3864 pd=2.1 as=0.441 ps=3.22 w=1.26 l=0.15
X631 din0[1] bank_0.replica_bitcell_array_0.wl_0_14 din0[1] din0[1] sky130_fd_pr__nfet_01v8 ad=0.3864 pd=2.1 as=0 ps=0 w=0.42 l=0.15
X632 din0[1] bank_0.replica_bitcell_array_0.wl_0_3 bank_0.replica_bitcell_array_0.replica_column_0.replica_cell_1rw_12.q din0[1] sky130_fd_pr__nfet_01v8 ad=0.1428 pd=1.52 as=0.3864 ps=2.1 w=0.42 l=0.15
X633 a_n1919_705# control_logic_rw_0.dff_buf_array_0.dout_bar_0 a_n1997_705# din0[1] sky130_fd_pr__nfet_01v8 ad=0.189 pd=1.23 as=0.189 ps=1.23 w=0.6 l=0.15
X634 control_logic_rw_0.dff_buf_array_0.dff_buf_0_0.dff_0.net2 control_logic_rw_0.dff_buf_array_0.dff_buf_0_0.dff_0.clkb control_logic_rw_0.dff_buf_array_0.dff_buf_0_0.dff_0.net1 din0[1] sky130_fd_pr__pfet_01v8 ad=0.374 pd=2.46 as=0.2915 ps=1.61 w=0.55 l=0.15
X635 din0[1] bank_0.replica_bitcell_array_0.bitcell_array_0.cell_1rw_2.q bank_0.replica_bitcell_array_0.bitcell_array_0.cell_1rw_2.qb din0[1] sky130_fd_pr__nfet_01v8 ad=0.441 pd=3.22 as=0.3864 ps=2.1 w=1.26 l=0.15
X636 a_739_3467# din0[1] a_685_3467# din0[1] sky130_fd_pr__nfet_01v8 ad=0.1596 pd=1.6 as=0.1638 ps=1.62 w=0.42 l=0.15
X637 a_n3917_n213# control_logic_rw_0.dff_buf_array_0.dff_buf_0_0.pinv_0_0.A a_n3971_n213# din0[1] sky130_fd_pr__nfet_01v8 ad=0.1323 pd=1.05 as=0.1638 ps=1.62 w=0.42 l=0.15
X638 din0[1] din0[1] din0[1] din0[1] sky130_fd_pr__nfet_01v8 ad=0.1678 pd=1.48 as=0 ps=0 w=1 l=0.15
X639 a_n4427_8329# control_logic_rw_0.delay_chain_0.pinv_11_9.Z a_n4480_8329# w_n5644_7860# sky130_fd_pr__pfet_01v8 ad=0.3276 pd=2.46 as=0.3192 ps=2.44 w=0.84 l=0.15
X640 a_3797_7901# din0[1] a_3743_7901# w_2422_7751# sky130_fd_pr__pfet_01v8 ad=0.3192 pd=2.44 as=0.3276 ps=2.46 w=0.84 l=0.15
X641 din0[1] din0[1] din0[1] din0[1] sky130_fd_pr__nfet_01v8 ad=0.2604 pd=1.58 as=0 ps=0 w=0.84 l=0.15
X642 a_n1065_n919# control_logic_rw_0.pdriver_0_0.pinv_7_0.A a_n1143_n919# din0[1] sky130_fd_pr__nfet_01v8 ad=0.1795 pd=1.2 as=0.1795 ps=1.2 w=0.57 l=0.15
X643 din0[1] bank_0.replica_bitcell_array_0.replica_column_0.replica_cell_1rw_1.q din0[1] din0[1] sky130_fd_pr__nfet_01v8 ad=0.3864 pd=2.1 as=0 ps=0 w=1.26 l=0.15
X644 row_addr_dff_0.dff_3.net3 row_addr_dff_0.dff_3.net1 din0[1] din0[1] sky130_fd_pr__pfet_01v8 ad=0.3465 pd=2.36 as=0.22 ps=1.35 w=0.55 l=0.15
X645 din0[1] din0[1] din0[1] din0[1] sky130_fd_pr__pfet_01v8 ad=0.165 pd=1.15 as=0 ps=0 w=0.55 l=0.15
X646 a_n4741_8181# control_logic_rw_0.delay_chain_0.pinv_11_14.Z a_n4794_8181# w_n5644_7860# sky130_fd_pr__pfet_01v8 ad=0.3276 pd=2.46 as=0.3192 ps=2.44 w=0.84 l=0.15
X647 a_n1645_n681# control_logic_rw_0.pdriver_0_0.pinv_6_0.A a_n1723_n681# w_n2769_n767# sky130_fd_pr__pfet_01v8 ad=0.3307 pd=1.68 as=0.3307 ps=1.68 w=1.05 l=0.15
X648 a_n3839_n919# control_logic_rw_0.dff_buf_array_0.dff_buf_0_1.pinv_0_0.A a_n3917_n919# din0[1] sky130_fd_pr__nfet_01v8 ad=0.1596 pd=1.6 as=0.1323 ps=1.05 w=0.42 l=0.15
X649 a_n1723_n919# control_logic_rw_0.pdriver_0_0.pinv_6_0.A a_n1777_n919# din0[1] sky130_fd_pr__nfet_01v8 ad=0.1638 pd=1.15 as=0.2028 ps=1.82 w=0.52 l=0.15
X650 a_n4741_4969# control_logic_rw_0.delay_chain_0.pinv_11_29.Z a_n4794_4969# w_n5644_4500# sky130_fd_pr__pfet_01v8 ad=0.3276 pd=2.46 as=0.3192 ps=2.44 w=0.84 l=0.15
X651 a_n3839_n513# control_logic_rw_0.dff_buf_array_0.dff_buf_0_0.pinv_0_0.A a_n3917_n513# w_n4225_n767# sky130_fd_pr__pfet_01v8 ad=0.3192 pd=2.44 as=0.2646 ps=1.47 w=0.84 l=0.15
X652 control_logic_rw_0.dff_buf_array_0.dff_buf_0_0.dff_0.net1 control_logic_rw_0.dff_buf_array_0.dff_buf_0_0.dff_0.clkb web0 din0[1] sky130_fd_pr__nfet_01v8 ad=0.2226 pd=1.48 as=0.1932 ps=1.76 w=0.42 l=0.15
X653 a_n1774_1111# control_logic_rw_0.pdriver_4_0.pinv_8_0.A a_n1828_1111# w_n2769_857# sky130_fd_pr__pfet_01v8 ad=0.3192 pd=2.44 as=0.3276 ps=2.46 w=0.84 l=0.15
X654 a_3424_2957# control_logic_rw_0.wl_en a_3370_2957# w_3116_2703# sky130_fd_pr__pfet_01v8 ad=0.1848 pd=1.28 as=0.3276 ps=2.46 w=0.84 l=0.15
X655 bank_0.replica_bitcell_array_0.dummy_array_3_0.dummy_cell_1rw_0.qb din0[1] a_5530_11655# din0[1] sky130_fd_pr__nfet_01v8 ad=0.3864 pd=2.1 as=0.1428 ps=1.52 w=0.42 l=0.15
X656 a_n2147_n919# control_logic_rw_0.pdriver_0_0.pinv_4_0.A a_n2201_n919# din0[1] sky130_fd_pr__nfet_01v8 ad=0.1323 pd=1.05 as=0.1638 ps=1.62 w=0.42 l=0.15
X657 bank_0.replica_bitcell_array_0.dummy_array_3_0.dummy_cell_1rw_16.qb bank_0.replica_bitcell_array_0.wl_0_0 a_5530_3511# din0[1] sky130_fd_pr__nfet_01v8 ad=0.3864 pd=2.1 as=0.1428 ps=1.52 w=0.42 l=0.15
X658 a_3483_9065# control_logic_rw_0.wl_en a_3424_9065# w_2422_8769# sky130_fd_pr__pfet_01v8 ad=0.3192 pd=2.44 as=0.1848 ps=1.28 w=0.84 l=0.15
X659 a_3483_7539# control_logic_rw_0.wl_en bank_0.port_address_0.wordline_driver_array_0.wordline_driver_7.pnand2_0.nmos_m1_w0_840_sli_dactive_uq0 din0[1] sky130_fd_pr__nfet_01v8 ad=0.3192 pd=2.44 as=0.1848 ps=1.28 w=0.84 l=0.15
X660 bank_0.replica_bitcell_array_0.bitcell_array_0.cell_1rw_7.q bank_0.replica_bitcell_array_0.bitcell_array_0.cell_1rw_7.qb din0[1] din0[1] sky130_fd_pr__nfet_01v8 ad=0.3864 pd=2.1 as=0.441 ps=3.22 w=1.26 l=0.15
X661 a_3103_6521# din0[1] a_3049_6521# din0[1] sky130_fd_pr__nfet_01v8 ad=0.1596 pd=1.6 as=0.1638 ps=1.62 w=0.42 l=0.15
X662 bank_0.replica_bitcell_array_0.bitcell_array_0.cell_1rw_12.q bank_0.replica_bitcell_array_0.bitcell_array_0.cell_1rw_12.qb din0[1] din0[1] sky130_fd_pr__nfet_01v8 ad=0.3864 pd=2.1 as=0.441 ps=3.22 w=1.26 l=0.15
X663 a_n2147_n513# control_logic_rw_0.pinv_3_1.Z a_n2201_n513# w_n2769_n767# sky130_fd_pr__pfet_01v8 ad=0.133 pd=1.35 as=0.3276 ps=2.46 w=0.84 l=0.15
X664 a_n2402_1369# control_logic_rw_0.pnand2_1_0.nmos_m1_w0_840_sactive_dli_0.G control_logic_rw_0.pnand2_1_0.nmos_m1_w0_840_sactive_dli_0.S din0[1] sky130_fd_pr__nfet_01v8 ad=0.3192 pd=2.44 as=0.1848 ps=1.28 w=0.84 l=0.15
X665 din0[1] row_addr_dff_0.dout_2 row_addr_dff_0.dff_1.net5 din0[1] sky130_fd_pr__pfet_01v8 ad=0.22 pd=1.35 as=0.308 ps=2.22 w=0.55 l=0.15
X666 a_3483_4847# control_logic_rw_0.wl_en a_3424_4847# w_2422_4697# sky130_fd_pr__pfet_01v8 ad=0.3192 pd=2.44 as=0.1848 ps=1.28 w=0.84 l=0.15
X667 a_n4113_4023# control_logic_rw_0.delay_chain_0.pinv_11_44.Z a_n4166_4023# din0[1] sky130_fd_pr__nfet_01v8 ad=0.1638 pd=1.62 as=0.1596 ps=1.6 w=0.42 l=0.15
X668 din0[1] din0[1] din0[1] din0[1] sky130_fd_pr__pfet_01v8 ad=0.2302 pd=1.47 as=0 ps=0 w=0.25 l=0.03
X669 din0[1] row_addr_dff_0.dff_0.net3 row_addr_dff_0.dff_0.net2 din0[1] sky130_fd_pr__pfet_01v8 ad=0.22 pd=1.35 as=0.2915 ps=2.16 w=0.55 l=0.15
X670 bank_0.replica_bitcell_array_0.bitcell_array_0.cell_1rw_23.q bank_0.replica_bitcell_array_0.bitcell_array_0.cell_1rw_23.qb din0[1] din0[1] sky130_fd_pr__pfet_01v8 ad=0.1925 pd=1.8 as=0.1925 ps=1.8 w=0.55 l=0.15
X671 din0[1] bank_0.replica_bitcell_array_0.wl_0_0 din0[1] din0[1] sky130_fd_pr__nfet_01v8 ad=0.3864 pd=2.1 as=0 ps=0 w=0.42 l=0.15
X672 din0[1] bank_0.replica_bitcell_array_0.dummy_array_2_0.dummy_cell_1rw_1.q bank_0.replica_bitcell_array_0.dummy_array_2_0.dummy_cell_1rw_1.qb din0[1] sky130_fd_pr__nfet_01v8 ad=0.441 pd=3.22 as=0.3864 ps=2.1 w=1.26 l=0.15
X673 bank_0.replica_bitcell_array_0.dummy_array_2_0.dummy_cell_1rw_8.q bank_0.replica_bitcell_array_0.dummy_array_2_0.dummy_cell_1rw_8.qb din0[1] din0[1] sky130_fd_pr__nfet_01v8 ad=0.3864 pd=2.1 as=0.441 ps=3.22 w=1.26 l=0.15
X674 bank_0.replica_bitcell_array_0.dummy_array_2_0.dummy_cell_1rw_13.q bank_0.replica_bitcell_array_0.dummy_array_2_0.dummy_cell_1rw_13.qb din0[1] din0[1] sky130_fd_pr__nfet_01v8 ad=0.3864 pd=2.1 as=0.441 ps=3.22 w=1.26 l=0.15
X675 a_3797_4993# din0[1] a_3743_4993# w_2422_4697# sky130_fd_pr__pfet_01v8 ad=0.3192 pd=2.44 as=0.3276 ps=2.46 w=0.84 l=0.15
X676 din0[1] bank_0.replica_bitcell_array_0.bitcell_array_0.cell_1rw_15.q bank_0.replica_bitcell_array_0.bitcell_array_0.cell_1rw_15.qb din0[1] sky130_fd_pr__pfet_01v8 ad=0.1925 pd=1.8 as=0.1925 ps=1.8 w=0.55 l=0.15
X677 a_n441_n919# control_logic_rw_0.pdriver_0_0.pinv_7_0.A a_n519_n919# din0[1] sky130_fd_pr__nfet_01v8 ad=0.1795 pd=1.2 as=0.1795 ps=1.2 w=0.57 l=0.15
X678 row_addr_dff_0.dout_2 row_addr_dff_0.dff_1.net4 din0[1] din0[1] sky130_fd_pr__nfet_01v8 ad=0.168 pd=1.64 as=0.168 ps=1.22 w=0.42 l=0.15
X679 a_3483_10593# control_logic_rw_0.wl_en bank_0.port_address_0.wordline_driver_array_0.wordline_driver_1.pnand2_0.nmos_m1_w0_840_sli_dactive_uq0 din0[1] sky130_fd_pr__nfet_01v8 ad=0.3192 pd=2.44 as=0.1848 ps=1.28 w=0.84 l=0.15
X680 a_n4741_7489# control_logic_rw_0.delay_chain_0.pinv_11_14.Z a_n4794_7489# din0[1] sky130_fd_pr__nfet_01v8 ad=0.1638 pd=1.62 as=0.1596 ps=1.6 w=0.42 l=0.15
X681 din0[1] bank_0.replica_bitcell_array_0.bitcell_array_0.cell_1rw_11.q bank_0.replica_bitcell_array_0.bitcell_array_0.cell_1rw_11.qb din0[1] sky130_fd_pr__nfet_01v8 ad=0.441 pd=3.22 as=0.3864 ps=2.1 w=1.26 l=0.15
X682 din0[1] bank_0.replica_bitcell_array_0.dummy_array_0.dummy_cell_1rw_0.q bank_0.replica_bitcell_array_0.dummy_array_0.dummy_cell_1rw_0.qb din0[1] sky130_fd_pr__nfet_01v8 ad=0.441 pd=3.22 as=0.3864 ps=2.1 w=1.26 l=0.15
X683 din0[1] bank_0.replica_bitcell_array_0.dummy_array_3_0.dummy_cell_1rw_1.q bank_0.replica_bitcell_array_0.dummy_array_3_0.dummy_cell_1rw_1.qb din0[1] sky130_fd_pr__nfet_01v8 ad=0.441 pd=3.22 as=0.3864 ps=2.1 w=1.26 l=0.15
X684 bank_0.port_address_0.hierarchical_decoder_0.and2_dec_10.pnand2_0.nmos_m1_w0_840_sactive_dli_0.S bank_0.port_address_0.hierarchical_decoder_0.predecode_1 a_2676_6373# din0[1] sky130_fd_pr__nfet_01v8 ad=0.1848 pd=1.28 as=0.3276 ps=2.46 w=0.84 l=0.15
X685 din0[1] din0[1] din0[1] din0[1] sky130_fd_pr__nfet_01v8 ad=0.1678 pd=1.48 as=0 ps=0 w=0.6 l=0.12
X686 row_addr_dff_0.dff_0.net1 row_addr_dff_0.dff_3.clk addr0[3] din0[1] sky130_fd_pr__pfet_01v8 ad=0.2915 pd=1.61 as=0.253 ps=2.02 w=0.55 l=0.15
X687 din0[1] bank_0.replica_bitcell_array_0.dummy_array_2_0.dummy_cell_1rw_16.q bank_0.replica_bitcell_array_0.dummy_array_2_0.dummy_cell_1rw_16.qb din0[1] sky130_fd_pr__pfet_01v8 ad=0.1925 pd=1.8 as=0.1925 ps=1.8 w=0.55 l=0.15
X688 din0[1] din0[1] din0[1] din0[1] sky130_fd_pr__nfet_01v8 ad=0.1782 pd=1.34 as=0 ps=0 w=0.23 l=0.03
X689 din0[1] bank_0.replica_bitcell_array_0.dummy_array_2_0.dummy_cell_1rw_12.q bank_0.replica_bitcell_array_0.dummy_array_2_0.dummy_cell_1rw_12.qb din0[1] sky130_fd_pr__nfet_01v8 ad=0.441 pd=3.22 as=0.3864 ps=2.1 w=1.26 l=0.15
X690 din0[1] bank_0.replica_bitcell_array_0.dummy_array_2_0.dummy_cell_1rw_17.q bank_0.replica_bitcell_array_0.dummy_array_2_0.dummy_cell_1rw_17.qb din0[1] sky130_fd_pr__nfet_01v8 ad=0.441 pd=3.22 as=0.3864 ps=2.1 w=1.26 l=0.15
X691 row_addr_dff_0.dff_2.net5 row_addr_dff_0.dff_3.clk row_addr_dff_0.dff_2.net4 din0[1] sky130_fd_pr__pfet_01v8 ad=0.4345 pd=2.68 as=0.2915 ps=1.61 w=0.55 l=0.15
X692 a_3797_10487# din0[1] a_3743_10487# din0[1] sky130_fd_pr__nfet_01v8 ad=0.1596 pd=1.6 as=0.1638 ps=1.62 w=0.42 l=0.15
X693 bank_0.replica_bitcell_array_0.bitcell_array_0.cell_1rw_3.qb bank_0.replica_bitcell_array_0.wl_0_12 din0[1] din0[1] sky130_fd_pr__nfet_01v8 ad=0.3864 pd=2.1 as=0.1428 ps=1.52 w=0.42 l=0.15
X694 din0[1] bank_0.replica_bitcell_array_0.bitcell_array_0.cell_1rw_26.q bank_0.replica_bitcell_array_0.bitcell_array_0.cell_1rw_26.qb din0[1] sky130_fd_pr__nfet_01v8 ad=0.441 pd=3.22 as=0.3864 ps=2.1 w=1.26 l=0.15
X695 din0[1] bank_0.replica_bitcell_array_0.wl_0_1 bank_0.replica_bitcell_array_0.bitcell_array_0.cell_1rw_30.qb din0[1] sky130_fd_pr__nfet_01v8 ad=0.1428 pd=1.52 as=0.3864 ps=2.1 w=0.42 l=0.15
X696 bank_0.replica_bitcell_array_0.dummy_array_2_0.dummy_cell_1rw_4.qb bank_0.replica_bitcell_array_0.wl_0_12 a_4490_9619# din0[1] sky130_fd_pr__nfet_01v8 ad=0.3864 pd=2.1 as=0.1428 ps=1.52 w=0.42 l=0.15
X697 din0[1] bank_0.replica_bitcell_array_0.wl_0_9 bank_0.replica_bitcell_array_0.bitcell_array_0.cell_1rw_6.q din0[1] sky130_fd_pr__nfet_01v8 ad=0.1428 pd=1.52 as=0.3864 ps=2.1 w=0.42 l=0.15
X698 a_3797_9937# din0[1] a_3743_9937# w_2422_9787# sky130_fd_pr__pfet_01v8 ad=0.3192 pd=2.44 as=0.3276 ps=2.46 w=0.84 l=0.15
X699 a_3103_7029# din0[1] a_3049_7029# w_2422_6733# sky130_fd_pr__pfet_01v8 ad=0.3192 pd=2.44 as=0.3276 ps=2.46 w=0.84 l=0.15
X700 a_n753_n691# control_logic_rw_0.pdriver_0_0.pinv_7_0.A a_n831_n691# w_n2769_n767# sky130_fd_pr__pfet_01v8 ad=0.3622 pd=1.78 as=0.3622 ps=1.78 w=1.15 l=0.15
X701 a_n1607_927# control_logic_rw_0.dff_buf_array_0.dout_bar_0 a_n1685_927# w_n2769_857# sky130_fd_pr__pfet_01v8 ad=0.378 pd=1.83 as=0.378 ps=1.83 w=1.2 l=0.15
X702 a_5530_9433# bank_0.replica_bitcell_array_0.wl_0_11 bank_0.replica_bitcell_array_0.dummy_array_3_0.dummy_cell_1rw_5.qb din0[1] sky130_fd_pr__nfet_01v8 ad=0.1428 pd=1.52 as=0.3864 ps=2.1 w=0.42 l=0.15
X703 data_dff_0.dff_0.net5 din0[1] data_dff_0.dff_0.net4 din0[1] sky130_fd_pr__pfet_01v8 ad=0.4345 pd=2.68 as=0.2915 ps=1.61 w=0.55 l=0.15
X704 a_n1900_123# control_logic_rw_0.dff_buf_array_0.dout_bar_0 a_n1978_123# w_n2769_44# sky130_fd_pr__pfet_01v8 ad=0.3528 pd=1.75 as=0.3528 ps=1.75 w=1.12 l=0.15
X705 din0[1] bank_0.replica_bitcell_array_0.replica_column_0.replica_cell_1rw_2.q din0[1] din0[1] sky130_fd_pr__nfet_01v8 ad=0.3864 pd=2.1 as=0 ps=0 w=1.26 l=0.15
X706 a_4421_8415# bank_0.replica_bitcell_array_0.wl_0_9 bank_0.replica_bitcell_array_0.dummy_array_2_0.dummy_cell_1rw_7.q din0[1] sky130_fd_pr__nfet_01v8 ad=0.1428 pd=1.52 as=0.3864 ps=2.1 w=0.42 l=0.15
X707 din0[1] din0[1] din0[1] din0[1] sky130_fd_pr__nfet_01v8 ad=0.1597 pd=1.34 as=0 ps=0 w=0.84 l=0.15
X708 a_n1221_298# control_logic_rw_0.pdriver_1_0.pinv_6_0.A a_n1299_298# w_n2769_44# sky130_fd_pr__pfet_01v8 ad=0.3307 pd=1.68 as=0.3307 ps=1.68 w=1.05 l=0.15
X709 din0[1] bank_0.replica_bitcell_array_0.wl_0_11 din0[1] din0[1] sky130_fd_pr__nfet_01v8 ad=0.1428 pd=1.52 as=0 ps=0 w=0.42 l=0.15
X710 a_1822_7901# din0[1] a_1768_7901# w_1141_7751# sky130_fd_pr__pfet_01v8 ad=0.3192 pd=2.44 as=0.3276 ps=2.46 w=0.84 l=0.15
X711 a_n5055_9063# control_logic_rw_0.delay_chain_0.pinv_11_9.Z a_n5108_9063# din0[1] sky130_fd_pr__nfet_01v8 ad=0.1638 pd=1.62 as=0.1596 ps=1.6 w=0.42 l=0.15
X712 din0[1] bank_0.replica_bitcell_array_0.wl_0_7 bank_0.replica_bitcell_array_0.bitcell_array_0.cell_1rw_24.qb din0[1] sky130_fd_pr__nfet_01v8 ad=0.1428 pd=1.52 as=0.3864 ps=2.1 w=0.42 l=0.15
X713 din0[1] bank_0.replica_bitcell_array_0.bitcell_array_0.cell_1rw_10.q bank_0.replica_bitcell_array_0.bitcell_array_0.cell_1rw_10.qb din0[1] sky130_fd_pr__pfet_01v8 ad=0.1925 pd=1.8 as=0.1925 ps=1.8 w=0.55 l=0.15
X714 bank_0.replica_bitcell_array_0.bitcell_array_0.cell_1rw_13.q bank_0.replica_bitcell_array_0.wl_0_2 din0[1] din0[1] sky130_fd_pr__nfet_01v8 ad=0.3864 pd=2.1 as=0.1428 ps=1.52 w=0.42 l=0.15
X715 bank_0.replica_bitcell_array_0.replica_column_0.replica_cell_1rw_1.q bank_0.replica_bitcell_array_0.wl_0_14 din0[1] din0[1] sky130_fd_pr__nfet_01v8 ad=0.3864 pd=2.1 as=0.1428 ps=1.52 w=0.42 l=0.15
X716 a_2789_5503# bank_0.port_address_0.hierarchical_decoder_0.predecode_5 bank_0.port_address_0.hierarchical_decoder_0.and2_dec_11.pnand2_0.nmos_m1_w0_840_sactive_dli_0.S din0[1] sky130_fd_pr__nfet_01v8 ad=0.3192 pd=2.44 as=0.1848 ps=1.28 w=0.84 l=0.15
X717 a_n2343_2181# control_logic_rw_0.pand3_0_0.pnand3_0_0.nmos_m1_w0_840_sactive_dli_0.G control_logic_rw_0.pand3_0_0.pnand3_0_0.nmos_m1_w0_840_sactive_dactive_0.D din0[1] sky130_fd_pr__nfet_01v8 ad=0.3192 pd=2.44 as=0.1848 ps=1.28 w=0.84 l=0.15
X718 a_n4427_8181# control_logic_rw_0.delay_chain_0.pinv_11_14.Z a_n4480_8181# w_n5644_7860# sky130_fd_pr__pfet_01v8 ad=0.3276 pd=2.46 as=0.3192 ps=2.44 w=0.84 l=0.15
X719 control_logic_rw_0.pand2_0.pnand2_0_0.nmos_m1_w0_840_sactive_dli_0.S din0[1] a_n2515_n107# din0[1] sky130_fd_pr__nfet_01v8 ad=0.1848 pd=1.28 as=0.3276 ps=2.46 w=0.84 l=0.15
X720 bank_0.replica_bitcell_array_0.bitcell_array_0.cell_1rw_19.q bank_0.replica_bitcell_array_0.bitcell_array_0.cell_1rw_19.qb din0[1] din0[1] sky130_fd_pr__nfet_01v8 ad=0.3864 pd=2.1 as=0.441 ps=3.22 w=1.26 l=0.15
X721 a_3103_8557# din0[1] a_3049_8557# din0[1] sky130_fd_pr__nfet_01v8 ad=0.1596 pd=1.6 as=0.1638 ps=1.62 w=0.42 l=0.15
X722 a_3483_4337# control_logic_rw_0.wl_en bank_0.port_address_0.wordline_driver_array_0.wordline_driver_14.pnand2_0.nmos_m1_w0_840_sli_dactiv_uq0 din0[1] sky130_fd_pr__nfet_01v8 ad=0.3192 pd=2.44 as=0.1848 ps=1.28 w=0.84 l=0.15
X723 data_dff_0.dff_0.net5 data_dff_0.dff_0.clkb data_dff_0.dff_0.net4 din0[1] sky130_fd_pr__nfet_01v8 ad=0.3318 pd=2.42 as=0.2226 ps=1.48 w=0.42 l=0.15
X724 control_logic_rw_0.dff_buf_array_0.dff_buf_0_0.pinv_0_0.A control_logic_rw_0.dff_buf_array_0.dff_buf_0_0.dff_0.net4 din0[1] din0[1] sky130_fd_pr__nfet_01v8 ad=0.168 pd=1.64 as=0.168 ps=1.22 w=0.42 l=0.15
X725 din0[1] bank_0.replica_bitcell_array_0.dummy_array_0.dummy_cell_1rw_1.q bank_0.replica_bitcell_array_0.dummy_array_0.dummy_cell_1rw_1.qb din0[1] sky130_fd_pr__pfet_01v8 ad=0.1925 pd=1.8 as=0.1925 ps=1.8 w=0.55 l=0.15
X726 bank_0.replica_bitcell_array_0.bitcell_array_0.cell_1rw_24.q bank_0.replica_bitcell_array_0.bitcell_array_0.cell_1rw_24.qb din0[1] din0[1] sky130_fd_pr__nfet_01v8 ad=0.3864 pd=2.1 as=0.441 ps=3.22 w=1.26 l=0.15
X727 din0[1] bank_0.replica_bitcell_array_0.dummy_array_2_0.dummy_cell_1rw_11.q bank_0.replica_bitcell_array_0.dummy_array_2_0.dummy_cell_1rw_11.qb din0[1] sky130_fd_pr__pfet_01v8 ad=0.1925 pd=1.8 as=0.1925 ps=1.8 w=0.55 l=0.15
X728 a_3103_5865# din0[1] a_3049_5865# w_2422_5715# sky130_fd_pr__pfet_01v8 ad=0.3192 pd=2.44 as=0.3276 ps=2.46 w=0.84 l=0.15
X729 a_n4427_4969# control_logic_rw_0.delay_chain_0.pinv_11_29.Z a_n4480_4969# w_n5644_4500# sky130_fd_pr__pfet_01v8 ad=0.3276 pd=2.46 as=0.3192 ps=2.44 w=0.84 l=0.15
X730 bank_0.replica_bitcell_array_0.dummy_array_2_0.dummy_cell_1rw_14.q bank_0.replica_bitcell_array_0.wl_0_2 a_4421_4529# din0[1] sky130_fd_pr__nfet_01v8 ad=0.3864 pd=2.1 as=0.1428 ps=1.52 w=0.42 l=0.15
X731 a_5313_1712# control_logic_rw_0.p_en_bar a_5259_1712# w_4605_1519# sky130_fd_pr__pfet_01v8 ad=0.3192 pd=2.44 as=0.3276 ps=2.46 w=0.84 l=0.15
X732 a_3797_10593# din0[1] a_3743_10593# din0[1] sky130_fd_pr__nfet_01v8 ad=0.1596 pd=1.6 as=0.1638 ps=1.62 w=0.42 l=0.15
X733 din0[1] din0[1] row_addr_dff_0.dff_3.net5 din0[1] sky130_fd_pr__pfet_01v8 ad=0.22 pd=1.35 as=0.308 ps=2.22 w=0.55 l=0.15
X734 data_dff_0.dff_1.net1 din0[1] din0[0] din0[1] sky130_fd_pr__pfet_01v8 ad=0.2915 pd=1.61 as=0.253 ps=2.02 w=0.55 l=0.15
X735 din0[1] row_addr_dff_0.dff_2.net3 row_addr_dff_0.dff_2.net2 din0[1] sky130_fd_pr__pfet_01v8 ad=0.22 pd=1.35 as=0.2915 ps=2.16 w=0.55 l=0.15
X736 bank_0.replica_bitcell_array_0.bitcell_array_0.cell_1rw_19.q bank_0.replica_bitcell_array_0.wl_0_12 din0[1] din0[1] sky130_fd_pr__nfet_01v8 ad=0.3864 pd=2.1 as=0.1428 ps=1.52 w=0.42 l=0.15
X737 bank_0.replica_bitcell_array_0.dummy_array_3_0.dummy_cell_1rw_14.q bank_0.replica_bitcell_array_0.dummy_array_3_0.dummy_cell_1rw_14.qb din0[1] din0[1] sky130_fd_pr__pfet_01v8 ad=0.1925 pd=1.8 as=0.1925 ps=1.8 w=0.55 l=0.15
X738 din0[1] bank_0.replica_bitcell_array_0.bitcell_array_0.cell_1rw_4.q bank_0.replica_bitcell_array_0.bitcell_array_0.cell_1rw_4.qb din0[1] sky130_fd_pr__pfet_01v8 ad=0.1925 pd=1.8 as=0.1925 ps=1.8 w=0.55 l=0.15
X739 din0[1] bank_0.replica_bitcell_array_0.bitcell_array_0.cell_1rw_11.q bank_0.replica_bitcell_array_0.bitcell_array_0.cell_1rw_11.qb din0[1] sky130_fd_pr__pfet_01v8 ad=0.1925 pd=1.8 as=0.1925 ps=1.8 w=0.55 l=0.15
X740 din0[1] bank_0.replica_bitcell_array_0.dummy_array_3_0.dummy_cell_1rw_18.q bank_0.replica_bitcell_array_0.dummy_array_3_0.dummy_cell_1rw_18.qb din0[1] sky130_fd_pr__pfet_01v8 ad=0.1925 pd=1.8 as=0.1925 ps=1.8 w=0.55 l=0.15
X741 bank_0.replica_bitcell_array_0.dummy_array_2_0.dummy_cell_1rw_0.q din0[1] a_4421_11655# din0[1] sky130_fd_pr__nfet_01v8 ad=0.3864 pd=2.1 as=0.1428 ps=1.52 w=0.42 l=0.15
X742 din0[1] bank_0.replica_bitcell_array_0.bitcell_array_0.cell_1rw_7.q bank_0.replica_bitcell_array_0.bitcell_array_0.cell_1rw_7.qb din0[1] sky130_fd_pr__nfet_01v8 ad=0.441 pd=3.22 as=0.3864 ps=2.1 w=1.26 l=0.15
X743 din0[1] bank_0.replica_bitcell_array_0.bitcell_array_0.cell_1rw_12.q bank_0.replica_bitcell_array_0.bitcell_array_0.cell_1rw_12.qb din0[1] sky130_fd_pr__nfet_01v8 ad=0.441 pd=3.22 as=0.3864 ps=2.1 w=1.26 l=0.15
X744 din0[1] din0[1] din0[1] din0[1] sky130_fd_pr__pfet_01v8 ad=0.275 pd=2.1 as=0 ps=0 w=0.55 l=0.15
X745 din0[1] din0[1] din0[1] din0[1] sky130_fd_pr__nfet_01v8 ad=0.1823 pd=1.93 as=0 ps=0 w=0.18 l=0.03
X746 bank_0.replica_bitcell_array_0.replica_column_0.replica_cell_1rw_13.q din0[1] din0[1] din0[1] sky130_fd_pr__pfet_01v8 ad=0.1925 pd=1.8 as=0.1925 ps=1.8 w=0.55 l=0.15
X747 din0[1] bank_0.replica_bitcell_array_0.dummy_array_3_0.dummy_cell_1rw_14.q bank_0.replica_bitcell_array_0.dummy_array_3_0.dummy_cell_1rw_14.qb din0[1] sky130_fd_pr__nfet_01v8 ad=0.441 pd=3.22 as=0.3864 ps=2.1 w=1.26 l=0.15
X748 a_3797_3467# din0[1] a_3743_3467# din0[1] sky130_fd_pr__nfet_01v8 ad=0.1596 pd=1.6 as=0.1638 ps=1.62 w=0.42 l=0.15
X749 bank_0.replica_bitcell_array_0.dummy_array_3_0.dummy_cell_1rw_0.q din0[1] a_5461_11655# din0[1] sky130_fd_pr__nfet_01v8 ad=0.3864 pd=2.1 as=0.1428 ps=1.52 w=0.42 l=0.15
X750 row_addr_dff_0.dff_1.clkb row_addr_dff_0.dff_3.clk din0[1] din0[1] sky130_fd_pr__nfet_01v8 ad=0.1932 pd=1.76 as=0.1932 ps=1.76 w=0.42 l=0.15
X751 row_addr_dff_0.dff_2.net1 row_addr_dff_0.dff_3.clk addr0[1] din0[1] sky130_fd_pr__pfet_01v8 ad=0.2915 pd=1.61 as=0.253 ps=2.02 w=0.55 l=0.15
X752 din0[1] bank_0.replica_bitcell_array_0.dummy_array_2_0.dummy_cell_1rw_5.q bank_0.replica_bitcell_array_0.dummy_array_2_0.dummy_cell_1rw_5.qb din0[1] sky130_fd_pr__pfet_01v8 ad=0.1925 pd=1.8 as=0.1925 ps=1.8 w=0.55 l=0.15
X753 bank_0.replica_bitcell_array_0.bitcell_array_0.cell_1rw_7.q bank_0.replica_bitcell_array_0.bitcell_array_0.cell_1rw_7.qb din0[1] din0[1] sky130_fd_pr__pfet_01v8 ad=0.1925 pd=1.8 as=0.1925 ps=1.8 w=0.55 l=0.15
X754 a_3483_7391# control_logic_rw_0.wl_en bank_0.port_address_0.wordline_driver_array_0.wordline_driver_8.pnand2_0.nmos_m1_w0_840_sli_dactive_uq0 din0[1] sky130_fd_pr__nfet_01v8 ad=0.3192 pd=2.44 as=0.1848 ps=1.28 w=0.84 l=0.15
X755 din0[1] bank_0.replica_bitcell_array_0.dummy_array_2_0.dummy_cell_1rw_12.q bank_0.replica_bitcell_array_0.dummy_array_2_0.dummy_cell_1rw_12.qb din0[1] sky130_fd_pr__pfet_01v8 ad=0.1925 pd=1.8 as=0.1925 ps=1.8 w=0.55 l=0.15
X756 a_1822_4993# din0[1] a_1768_4993# w_1141_4697# sky130_fd_pr__pfet_01v8 ad=0.3192 pd=2.44 as=0.3276 ps=2.46 w=0.84 l=0.15
X757 a_n1508_n513# control_logic_rw_0.dff_buf_array_0.dout_bar_0 a_n1586_n513# w_n2769_n767# sky130_fd_pr__pfet_01v8 ad=0.3528 pd=1.75 as=0.3528 ps=1.75 w=1.12 l=0.15
X758 bank_0.port_address_0.wordline_driver_array_0.wordline_driver_13.pnand2_0.nmos_m1_w0_840_sli_dactiv_uq0 bank_0.port_address_0.wordline_driver_array_0.in_2 a_3370_4485# din0[1] sky130_fd_pr__nfet_01v8 ad=0.1848 pd=1.28 as=0.3276 ps=2.46 w=0.84 l=0.15
X759 data_dff_0.dff_1.net1 data_dff_0.dff_1.clkb din0[0] din0[1] sky130_fd_pr__nfet_01v8 ad=0.2226 pd=1.48 as=0.1932 ps=1.76 w=0.42 l=0.15
X760 din0[1] bank_0.replica_bitcell_array_0.replica_column_0.dummy_cell_1rw_1.q bank_0.replica_bitcell_array_0.replica_column_0.dummy_cell_1rw_1.qb din0[1] sky130_fd_pr__pfet_01v8 ad=0.1925 pd=1.8 as=0.1925 ps=1.8 w=0.55 l=0.15
X761 din0[1] bank_0.replica_bitcell_array_0.dummy_array_2_0.dummy_cell_1rw_8.q bank_0.replica_bitcell_array_0.dummy_array_2_0.dummy_cell_1rw_8.qb din0[1] sky130_fd_pr__nfet_01v8 ad=0.441 pd=3.22 as=0.3864 ps=2.1 w=1.26 l=0.15
X762 a_n4427_7489# control_logic_rw_0.delay_chain_0.pinv_11_14.Z a_n4480_7489# din0[1] sky130_fd_pr__nfet_01v8 ad=0.1638 pd=1.62 as=0.1596 ps=1.6 w=0.42 l=0.15
X763 din0[1] bank_0.replica_bitcell_array_0.dummy_array_2_0.dummy_cell_1rw_13.q bank_0.replica_bitcell_array_0.dummy_array_2_0.dummy_cell_1rw_13.qb din0[1] sky130_fd_pr__nfet_01v8 ad=0.441 pd=3.22 as=0.3864 ps=2.1 w=1.26 l=0.15
X764 bank_0.port_address_0.hierarchical_decoder_0.and2_dec_0.pnand2_0.nmos_m1_w0_840_sactive_dli_0.S bank_0.port_address_0.hierarchical_decoder_0.predecode_3 a_2676_11463# din0[1] sky130_fd_pr__nfet_01v8 ad=0.1848 pd=1.28 as=0.3276 ps=2.46 w=0.84 l=0.15
X765 bank_0.replica_bitcell_array_0.dummy_array_2_0.dummy_cell_1rw_8.q bank_0.replica_bitcell_array_0.dummy_array_2_0.dummy_cell_1rw_8.qb din0[1] din0[1] sky130_fd_pr__pfet_01v8 ad=0.1925 pd=1.8 as=0.1925 ps=1.8 w=0.55 l=0.15
X766 a_n2461_n213# din0[1] a_n2515_n213# din0[1] sky130_fd_pr__nfet_01v8 ad=0.1596 pd=1.6 as=0.1638 ps=1.62 w=0.42 l=0.15
X767 a_n5369_5703# control_logic_rw_0.delay_chain_0.pinv_11_29.Z a_n5422_5703# din0[1] sky130_fd_pr__nfet_01v8 ad=0.1638 pd=1.62 as=0.1596 ps=1.6 w=0.42 l=0.15
X768 a_n5369_3289# control_logic_rw_0.delay_chain_0.pinv_11_39.Z a_n5422_3289# w_n5644_2820# sky130_fd_pr__pfet_01v8 ad=0.3276 pd=2.46 as=0.3192 ps=2.44 w=0.84 l=0.15
X769 bank_0.replica_bitcell_array_0.dummy_array_3_0.dummy_cell_1rw_9.q bank_0.replica_bitcell_array_0.dummy_array_3_0.dummy_cell_1rw_9.qb din0[1] din0[1] sky130_fd_pr__pfet_01v8 ad=0.1925 pd=1.8 as=0.1925 ps=1.8 w=0.55 l=0.15
X770 din0[1] din0[1] din0[1] din0[1] sky130_fd_pr__nfet_01v8 ad=0.189 pd=1.74 as=0 ps=0 w=0.42 l=0.15
X771 bank_0.replica_bitcell_array_0.replica_column_0.replica_cell_1rw_8.q din0[1] din0[1] din0[1] sky130_fd_pr__pfet_01v8 ad=0.1925 pd=1.8 as=0.1925 ps=1.8 w=0.55 l=0.15
X772 control_logic_rw_0.dff_buf_array_0.dff_buf_0_1.dff_0.clkb din0[1] din0[1] din0[1] sky130_fd_pr__pfet_01v8 ad=0.253 pd=2.02 as=0.253 ps=2.02 w=0.55 l=0.15
X773 a_2789_9065# bank_0.port_address_0.hierarchical_decoder_0.predecode_6 a_2730_9065# w_2422_8769# sky130_fd_pr__pfet_01v8 ad=0.3192 pd=2.44 as=0.1848 ps=1.28 w=0.84 l=0.15
X774 a_2789_7539# bank_0.port_address_0.hierarchical_decoder_0.predecode_6 bank_0.port_address_0.hierarchical_decoder_0.and2_dec_7.pnand2_0.nmos_m1_w0_840_sactive_dli_0.S din0[1] sky130_fd_pr__nfet_01v8 ad=0.3192 pd=2.44 as=0.1848 ps=1.28 w=0.84 l=0.15
X775 bank_0.replica_bitcell_array_0.bitcell_array_0.cell_1rw_9.q bank_0.replica_bitcell_array_0.wl_0_6 din0[1] din0[1] sky130_fd_pr__nfet_01v8 ad=0.3864 pd=2.1 as=0.1428 ps=1.52 w=0.42 l=0.15
X776 din0[1] bank_0.replica_bitcell_array_0.wl_0_5 bank_0.replica_bitcell_array_0.bitcell_array_0.cell_1rw_10.qb din0[1] sky130_fd_pr__nfet_01v8 ad=0.1428 pd=1.52 as=0.3864 ps=2.1 w=0.42 l=0.15
X777 a_1508_4485# row_addr_dff_0.dout_1 bank_0.port_address_0.hierarchical_decoder_0.hierarchical_predecode2x4_1.and2_dec_1.pnand2_0.nmos_m_uq0 din0[1] sky130_fd_pr__nfet_01v8 ad=0.3192 pd=2.44 as=0.1848 ps=1.28 w=0.84 l=0.15
X778 bank_0.replica_bitcell_array_0.dummy_array_3_0.dummy_cell_1rw_16.q bank_0.replica_bitcell_array_0.wl_0_0 a_5461_3511# din0[1] sky130_fd_pr__nfet_01v8 ad=0.3864 pd=2.1 as=0.1428 ps=1.52 w=0.42 l=0.15
X779 a_2789_4847# bank_0.port_address_0.hierarchical_decoder_0.predecode_4 a_2730_4847# w_2422_4697# sky130_fd_pr__pfet_01v8 ad=0.3192 pd=2.44 as=0.1848 ps=1.28 w=0.84 l=0.15
X780 a_n1978_n107# control_logic_rw_0.dff_buf_array_0.dout_bar_0 a_n2056_n107# din0[1] sky130_fd_pr__nfet_01v8 ad=0.1764 pd=1.19 as=0.1764 ps=1.19 w=0.56 l=0.15
X781 din0[1] din0[1] din0[1] din0[1] sky130_fd_pr__nfet_01v8 ad=0.056 pd=0.77 as=0 ps=0 w=0.42 l=0.15
X782 bank_0.replica_bitcell_array_0.bitcell_array_0.cell_1rw_20.q bank_0.replica_bitcell_array_0.bitcell_array_0.cell_1rw_20.qb din0[1] din0[1] sky130_fd_pr__nfet_01v8 ad=0.3864 pd=2.1 as=0.441 ps=3.22 w=1.26 l=0.15
X783 bank_0.replica_bitcell_array_0.dummy_array_2_0.dummy_cell_1rw_10.q bank_0.replica_bitcell_array_0.wl_0_6 a_4421_6565# din0[1] sky130_fd_pr__nfet_01v8 ad=0.3864 pd=2.1 as=0.1428 ps=1.52 w=0.42 l=0.15
X784 data_dff_0.dff_1.net5 din0[1] din0[1] din0[1] sky130_fd_pr__pfet_01v8 ad=0.4345 pd=2.68 as=0.2915 ps=1.61 w=0.55 l=0.15
X785 a_n1801_299# control_logic_rw_0.pdriver_1_0.pinv_8_0.Z a_n1855_299# w_n2769_44# sky130_fd_pr__pfet_01v8 ad=0.2646 pd=1.47 as=0.3276 ps=2.46 w=0.84 l=0.15
X786 a_4490_6379# bank_0.replica_bitcell_array_0.wl_0_5 bank_0.replica_bitcell_array_0.dummy_array_2_0.dummy_cell_1rw_11.qb din0[1] sky130_fd_pr__nfet_01v8 ad=0.1428 pd=1.52 as=0.3864 ps=2.1 w=0.42 l=0.15
X787 bank_0.replica_bitcell_array_0.replica_column_0.replica_cell_1rw_15.q bank_0.replica_bitcell_array_0.wl_0_0 din0[1] din0[1] sky130_fd_pr__nfet_01v8 ad=0.3864 pd=2.1 as=0.1428 ps=1.52 w=0.42 l=0.15
X788 control_logic_rw_0.dff_buf_array_0.dff_buf_0_1.dff_0.clkb din0[1] din0[1] din0[1] sky130_fd_pr__nfet_01v8 ad=0.1932 pd=1.76 as=0.1932 ps=1.76 w=0.42 l=0.15
X789 a_n1143_589# control_logic_rw_0.pdriver_1_0.pinv_6_0.A a_n1221_589# din0[1] sky130_fd_pr__nfet_01v8 ad=0.1976 pd=1.8 as=0.1638 ps=1.15 w=0.52 l=0.15
X790 bank_0.replica_bitcell_array_0.dummy_array_3_0.dummy_cell_1rw_10.q bank_0.replica_bitcell_array_0.dummy_array_3_0.dummy_cell_1rw_10.qb din0[1] din0[1] sky130_fd_pr__pfet_01v8 ad=0.1925 pd=1.8 as=0.1925 ps=1.8 w=0.55 l=0.15
X791 a_3483_11101# control_logic_rw_0.wl_en a_3424_11101# w_2422_10805# sky130_fd_pr__pfet_01v8 ad=0.3192 pd=2.44 as=0.1848 ps=1.28 w=0.84 l=0.15
X792 a_n1586_n227# control_logic_rw_0.dff_buf_array_0.dout_bar_0 a_n1664_n227# din0[1] sky130_fd_pr__nfet_01v8 ad=0.1764 pd=1.19 as=0.1764 ps=1.19 w=0.56 l=0.15
X793 din0[1] bank_0.replica_bitcell_array_0.dummy_array_3_0.dummy_cell_1rw_7.q bank_0.replica_bitcell_array_0.dummy_array_3_0.dummy_cell_1rw_7.qb din0[1] sky130_fd_pr__pfet_01v8 ad=0.1925 pd=1.8 as=0.1925 ps=1.8 w=0.55 l=0.15
X794 din0[1] bank_0.replica_bitcell_array_0.dummy_array_3_0.dummy_cell_1rw_14.q bank_0.replica_bitcell_array_0.dummy_array_3_0.dummy_cell_1rw_14.qb din0[1] sky130_fd_pr__pfet_01v8 ad=0.1925 pd=1.8 as=0.1925 ps=1.8 w=0.55 l=0.15
X795 row_addr_dff_0.dff_1.net4 row_addr_dff_0.dff_3.clk row_addr_dff_0.dff_1.net3 din0[1] sky130_fd_pr__nfet_01v8 ad=0.2226 pd=1.48 as=0.273 ps=2.14 w=0.42 l=0.15
X796 bank_0.replica_bitcell_array_0.bitcell_array_0.cell_1rw_3.q bank_0.replica_bitcell_array_0.bitcell_array_0.cell_1rw_3.qb din0[1] din0[1] sky130_fd_pr__nfet_01v8 ad=0.3864 pd=2.1 as=0.441 ps=3.22 w=1.26 l=0.15
X797 bank_0.port_address_0.hierarchical_decoder_0.hierarchical_predecode2x4_0.and2_dec_1.pnand2_0.nmos_m_uq0 bank_0.port_address_0.hierarchical_decoder_0.hierarchical_predecode2x4_0.pinv_1.Z a_1395_7539# din0[1] sky130_fd_pr__nfet_01v8 ad=0.1848 pd=1.28 as=0.3276 ps=2.46 w=0.84 l=0.15
X798 bank_0.replica_bitcell_array_0.bitcell_array_0.cell_1rw_8.q bank_0.replica_bitcell_array_0.bitcell_array_0.cell_1rw_8.qb din0[1] din0[1] sky130_fd_pr__nfet_01v8 ad=0.3864 pd=2.1 as=0.441 ps=3.22 w=1.26 l=0.15
X799 bank_0.replica_bitcell_array_0.replica_column_0.replica_cell_1rw_9.q din0[1] din0[1] din0[1] sky130_fd_pr__pfet_01v8 ad=0.1925 pd=1.8 as=0.1925 ps=1.8 w=0.55 l=0.15
X800 din0[1] bank_0.replica_bitcell_array_0.dummy_array_3_0.dummy_cell_1rw_10.q bank_0.replica_bitcell_array_0.dummy_array_3_0.dummy_cell_1rw_10.qb din0[1] sky130_fd_pr__nfet_01v8 ad=0.441 pd=3.22 as=0.3864 ps=2.1 w=1.26 l=0.15
X801 a_n5055_4821# control_logic_rw_0.delay_chain_0.pinv_11_34.Z a_n5108_4821# w_n5644_4500# sky130_fd_pr__pfet_01v8 ad=0.3276 pd=2.46 as=0.3192 ps=2.44 w=0.84 l=0.15
X802 a_1449_4847# bank_0.port_address_0.hierarchical_decoder_0.hierarchical_predecode2x4_1.pinv_1.Z a_1395_4847# w_1141_4697# sky130_fd_pr__pfet_01v8 ad=0.1848 pd=1.28 as=0.3276 ps=2.46 w=0.84 l=0.15
X803 a_n1822_n107# control_logic_rw_0.dff_buf_array_0.dout_bar_0 a_n1900_n107# din0[1] sky130_fd_pr__nfet_01v8 ad=0.1764 pd=1.19 as=0.1764 ps=1.19 w=0.56 l=0.15
X804 din0[1] row_addr_dff_0.dff_3.net4 din0[1] din0[1] sky130_fd_pr__nfet_01v8 ad=0.168 pd=1.22 as=0 ps=0 w=0.42 l=0.15
X805 din0[1] bank_0.replica_bitcell_array_0.dummy_array_3_0.dummy_cell_1rw_15.q bank_0.replica_bitcell_array_0.dummy_array_3_0.dummy_cell_1rw_15.qb din0[1] sky130_fd_pr__nfet_01v8 ad=0.441 pd=3.22 as=0.3864 ps=2.1 w=1.26 l=0.15
X806 data_dff_0.dff_1.net5 data_dff_0.dff_1.clkb din0[1] din0[1] sky130_fd_pr__nfet_01v8 ad=0.3318 pd=2.42 as=0.2226 ps=1.48 w=0.42 l=0.15
X807 din0[1] bank_0.replica_bitcell_array_0.wl_0_13 bank_0.replica_bitcell_array_0.bitcell_array_0.cell_1rw_18.qb din0[1] sky130_fd_pr__nfet_01v8 ad=0.1428 pd=1.52 as=0.3864 ps=2.1 w=0.42 l=0.15
X808 din0[1] bank_0.replica_bitcell_array_0.replica_column_0.replica_cell_1rw_6.q din0[1] din0[1] sky130_fd_pr__pfet_01v8 ad=0.1925 pd=1.8 as=0 ps=0 w=0.55 l=0.15
X809 din0[1] bank_0.replica_bitcell_array_0.replica_column_0.replica_cell_1rw_13.q din0[1] din0[1] sky130_fd_pr__pfet_01v8 ad=0.1925 pd=1.8 as=0 ps=0 w=0.55 l=0.15
X810 din0[1] data_dff_0.dff_1.net3 data_dff_0.dff_1.net2 din0[1] sky130_fd_pr__pfet_01v8 ad=0.22 pd=1.35 as=0.2915 ps=2.16 w=0.55 l=0.15
X811 bank_0.replica_bitcell_array_0.dummy_array_2_0.dummy_cell_1rw_4.q bank_0.replica_bitcell_array_0.dummy_array_2_0.dummy_cell_1rw_4.qb din0[1] din0[1] sky130_fd_pr__nfet_01v8 ad=0.3864 pd=2.1 as=0.441 ps=3.22 w=1.26 l=0.15
X812 bank_0.replica_bitcell_array_0.dummy_array_2_0.dummy_cell_1rw_9.q bank_0.replica_bitcell_array_0.dummy_array_2_0.dummy_cell_1rw_9.qb din0[1] din0[1] sky130_fd_pr__nfet_01v8 ad=0.3864 pd=2.1 as=0.441 ps=3.22 w=1.26 l=0.15
X813 a_n2088_n255# control_logic_rw_0.pand2_1.pnand2_0_0.nmos_m1_w0_840_sactive_dli_0.G control_logic_rw_0.pand2_1.pnand2_0_0.nmos_m1_w0_840_sactive_dli_0.S din0[1] sky130_fd_pr__nfet_01v8 ad=0.3192 pd=2.44 as=0.1848 ps=1.28 w=0.84 l=0.15
X814 a_1822_3467# din0[1] a_1768_3467# din0[1] sky130_fd_pr__nfet_01v8 ad=0.1596 pd=1.6 as=0.1638 ps=1.62 w=0.42 l=0.15
X815 din0[1] control_logic_rw_0.dff_buf_array_0.dff_buf_0_1.pinv_0_0.A control_logic_rw_0.dff_buf_array_0.dff_buf_0_1.dff_0.net5 din0[1] sky130_fd_pr__pfet_01v8 ad=0.22 pd=1.35 as=0.308 ps=2.22 w=0.55 l=0.15
X816 bank_0.replica_bitcell_array_0.dummy_array_0_0.dummy_cell_1rw_1.q din0[1] a_4941_11655# din0[1] sky130_fd_pr__nfet_01v8 ad=0.3864 pd=2.1 as=0.1428 ps=1.52 w=0.42 l=0.15
X817 din0[1] bank_0.replica_bitcell_array_0.wl_0_5 bank_0.replica_bitcell_array_0.bitcell_array_0.cell_1rw_26.q din0[1] sky130_fd_pr__nfet_01v8 ad=0.1428 pd=1.52 as=0.3864 ps=2.1 w=0.42 l=0.15
X818 a_n3839_n213# control_logic_rw_0.dff_buf_array_0.dff_buf_0_0.pinv_0_0.A a_n3917_n213# din0[1] sky130_fd_pr__nfet_01v8 ad=0.1596 pd=1.6 as=0.1323 ps=1.05 w=0.42 l=0.15
X819 din0[1] din0[1] din0[1] din0[1] sky130_fd_pr__pfet_01v8 ad=0.0696 pd=0.9 as=0 ps=0 w=0.19 l=10m
X820 bank_0.replica_bitcell_array_0.dummy_array_3_0.dummy_cell_1rw_5.q bank_0.replica_bitcell_array_0.dummy_array_3_0.dummy_cell_1rw_5.qb din0[1] din0[1] sky130_fd_pr__pfet_01v8 ad=0.1925 pd=1.8 as=0.1925 ps=1.8 w=0.55 l=0.15
X821 din0[1] din0[1] din0[1] din0[1] sky130_fd_pr__nfet_01v8 ad=0.1485 pd=1.34 as=0 ps=0 w=0.84 l=0.15
X822 a_n1432_123# control_logic_rw_0.dff_buf_array_0.dout_bar_0 a_n1510_123# w_n2769_44# sky130_fd_pr__pfet_01v8 ad=0.4256 pd=3 as=0.3528 ps=1.75 w=1.12 l=0.15
X823 a_5461_9433# bank_0.replica_bitcell_array_0.wl_0_11 bank_0.replica_bitcell_array_0.dummy_array_3_0.dummy_cell_1rw_5.q din0[1] sky130_fd_pr__nfet_01v8 ad=0.1428 pd=1.52 as=0.3864 ps=2.1 w=0.42 l=0.15
X824 din0[1] data_dff_0.dff_1.net3 data_dff_0.dff_1.net2 din0[1] sky130_fd_pr__nfet_01v8 ad=0.168 pd=1.22 as=0.2226 ps=1.9 w=0.42 l=0.15
X825 a_n1841_705# control_logic_rw_0.dff_buf_array_0.dout_bar_0 a_n1919_705# din0[1] sky130_fd_pr__nfet_01v8 ad=0.189 pd=1.23 as=0.189 ps=1.23 w=0.6 l=0.15
X826 bank_0.replica_bitcell_array_0.dummy_array_1_0.dummy_cell_1rw_1.q bank_0.replica_bitcell_array_0.dummy_array_1_0.dummy_cell_1rw_1.qb din0[1] din0[1] sky130_fd_pr__nfet_01v8 ad=0.3864 pd=2.1 as=0.441 ps=3.22 w=1.26 l=0.15
X827 row_addr_dff_0.dout_3 row_addr_dff_0.dff_0.net4 din0[1] din0[1] sky130_fd_pr__nfet_01v8 ad=0.168 pd=1.64 as=0.168 ps=1.22 w=0.42 l=0.15
X828 din0[1] bank_0.replica_bitcell_array_0.wl_0_11 bank_0.replica_bitcell_array_0.replica_column_0.replica_cell_1rw_4.q din0[1] sky130_fd_pr__nfet_01v8 ad=0.1428 pd=1.52 as=0.3864 ps=2.1 w=0.42 l=0.15
X829 bank_0.replica_bitcell_array_0.replica_column_0.replica_cell_1rw_4.q din0[1] din0[1] din0[1] sky130_fd_pr__pfet_01v8 ad=0.1925 pd=1.8 as=0.1925 ps=1.8 w=0.55 l=0.15
X830 a_n4113_7383# control_logic_rw_0.delay_chain_0.pinv_11_24.Z a_n4166_7383# din0[1] sky130_fd_pr__nfet_01v8 ad=0.1638 pd=1.62 as=0.1596 ps=1.6 w=0.42 l=0.15
X831 a_n4113_6501# control_logic_rw_0.delay_chain_0.pinv_11_29.Z a_n4166_6501# w_n5644_6180# sky130_fd_pr__pfet_01v8 ad=0.3276 pd=2.46 as=0.3192 ps=2.44 w=0.84 l=0.15
X832 a_n1645_n919# control_logic_rw_0.pdriver_0_0.pinv_6_0.A a_n1723_n919# din0[1] sky130_fd_pr__nfet_01v8 ad=0.1638 pd=1.15 as=0.1638 ps=1.15 w=0.52 l=0.15
X833 a_n987_n919# control_logic_rw_0.pdriver_0_0.pinv_7_0.A a_n1065_n919# din0[1] sky130_fd_pr__nfet_01v8 ad=0.1795 pd=1.2 as=0.1795 ps=1.2 w=0.57 l=0.15
X834 a_n2402_1160# control_logic_rw_0.pnand2_1_0.nmos_m1_w0_840_sactive_dli_0.G a_n2418_1160# w_n2769_857# sky130_fd_pr__pfet_01v8 ad=1.7m pd=0.36 as=1.7m ps=0.36 w=0.17 l=0.15
X835 a_3483_3975# control_logic_rw_0.wl_en a_3424_3975# w_2422_3679# sky130_fd_pr__pfet_01v8 ad=0.3192 pd=2.44 as=0.1848 ps=1.28 w=0.84 l=0.15
X836 din0[1] control_logic_rw_0.dff_buf_array_0.dff_buf_0_1.pinv_0_0.A control_logic_rw_0.dff_buf_array_0.dff_buf_0_1.dff_0.net5 din0[1] sky130_fd_pr__nfet_01v8 ad=0.168 pd=1.22 as=0.2352 ps=1.96 w=0.42 l=0.15
X837 a_2789_4337# bank_0.port_address_0.hierarchical_decoder_0.predecode_4 bank_0.port_address_0.hierarchical_decoder_0.and2_dec_14.pnand2_0.nmos_m1_w0_840_sactive_dli_0.S din0[1] sky130_fd_pr__nfet_01v8 ad=0.3192 pd=2.44 as=0.1848 ps=1.28 w=0.84 l=0.15
X838 a_n2069_n919# control_logic_rw_0.pdriver_0_0.pinv_4_0.A a_n2147_n919# din0[1] sky130_fd_pr__nfet_01v8 ad=0.1596 pd=1.6 as=0.1323 ps=1.05 w=0.42 l=0.15
X839 a_3797_11101# din0[1] a_3743_11101# w_2422_10805# sky130_fd_pr__pfet_01v8 ad=0.3192 pd=2.44 as=0.3276 ps=2.46 w=0.84 l=0.15
X840 din0[1] bank_0.replica_bitcell_array_0.wl_0_15 bank_0.replica_bitcell_array_0.bitcell_array_0.cell_1rw_0.qb din0[1] sky130_fd_pr__nfet_01v8 ad=0.1428 pd=1.52 as=0.3864 ps=2.1 w=0.42 l=0.15
X841 bank_0.replica_bitcell_array_0.dummy_array_1_0.dummy_cell_1rw_1.qb din0[1] a_5010_2493# din0[1] sky130_fd_pr__nfet_01v8 ad=0.3864 pd=2.1 as=0.1428 ps=1.52 w=0.42 l=0.15
X842 bank_0.replica_bitcell_array_0.dummy_array_3_0.dummy_cell_1rw_6.q bank_0.replica_bitcell_array_0.dummy_array_3_0.dummy_cell_1rw_6.qb din0[1] din0[1] sky130_fd_pr__nfet_01v8 ad=0.3864 pd=2.1 as=0.441 ps=3.22 w=1.26 l=0.15
X843 a_n363_n919# control_logic_rw_0.pdriver_0_0.pinv_7_0.A a_n441_n919# din0[1] sky130_fd_pr__nfet_01v8 ad=0.2166 pd=1.9 as=0.1795 ps=1.2 w=0.57 l=0.15
X844 data_dff_0.dff_1.net3 data_dff_0.dff_1.net1 din0[1] din0[1] sky130_fd_pr__pfet_01v8 ad=0.3465 pd=2.36 as=0.22 ps=1.35 w=0.55 l=0.15
X845 a_n2402_1923# control_logic_rw_0.dff_buf_array_0.dout_bar_0 a_n2461_1923# w_n2769_1669# sky130_fd_pr__pfet_01v8 ad=0.1848 pd=1.28 as=0.1848 ps=1.28 w=0.84 l=0.15
X846 bank_0.replica_bitcell_array_0.replica_column_0.replica_cell_1rw_5.q din0[1] din0[1] din0[1] sky130_fd_pr__nfet_01v8 ad=0.3864 pd=2.1 as=0.441 ps=3.22 w=1.26 l=0.15
X847 bank_0.replica_bitcell_array_0.dummy_array_3_0.dummy_cell_1rw_8.qb bank_0.replica_bitcell_array_0.wl_0_8 a_5530_7583# din0[1] sky130_fd_pr__nfet_01v8 ad=0.3864 pd=2.1 as=0.1428 ps=1.52 w=0.42 l=0.15
X848 a_2789_7391# bank_0.port_address_0.hierarchical_decoder_0.predecode_5 bank_0.port_address_0.hierarchical_decoder_0.and2_dec_8.pnand2_0.nmos_m1_w0_840_sactive_dli_0.S din0[1] sky130_fd_pr__nfet_01v8 ad=0.3192 pd=2.44 as=0.1848 ps=1.28 w=0.84 l=0.15
X849 bank_0.replica_bitcell_array_0.bitcell_array_0.cell_1rw_4.q bank_0.replica_bitcell_array_0.bitcell_array_0.cell_1rw_4.qb din0[1] din0[1] sky130_fd_pr__nfet_01v8 ad=0.3864 pd=2.1 as=0.441 ps=3.22 w=1.26 l=0.15
X850 a_n4113_5809# control_logic_rw_0.delay_chain_0.pinv_11_29.Z a_n4166_5809# din0[1] sky130_fd_pr__nfet_01v8 ad=0.1638 pd=1.62 as=0.1596 ps=1.6 w=0.42 l=0.15
X851 bank_0.port_address_0.hierarchical_decoder_0.and2_dec_13.pnand2_0.nmos_m1_w0_840_sactive_dli_0.S bank_0.port_address_0.hierarchical_decoder_0.predecode_2 a_2676_4485# din0[1] sky130_fd_pr__nfet_01v8 ad=0.1848 pd=1.28 as=0.3276 ps=2.46 w=0.84 l=0.15
X852 bank_0.port_address_0.hierarchical_decoder_0.hierarchical_predecode2x4_1.and2_dec_2.pnand2_0.nmos_m_uq0 din0[1] a_1395_4337# din0[1] sky130_fd_pr__nfet_01v8 ad=0.1848 pd=1.28 as=0.3276 ps=2.46 w=0.84 l=0.15
X853 a_3483_8919# control_logic_rw_0.wl_en a_3424_8919# w_2422_8769# sky130_fd_pr__pfet_01v8 ad=0.3192 pd=2.44 as=0.1848 ps=1.28 w=0.84 l=0.15
X854 a_3797_8451# din0[1] a_3743_8451# din0[1] sky130_fd_pr__nfet_01v8 ad=0.1596 pd=1.6 as=0.1638 ps=1.62 w=0.42 l=0.15
X855 a_3103_7901# din0[1] a_3049_7901# w_2422_7751# sky130_fd_pr__pfet_01v8 ad=0.3192 pd=2.44 as=0.3276 ps=2.46 w=0.84 l=0.15
X856 din0[1] bank_0.replica_bitcell_array_0.wl_0_8 din0[1] din0[1] sky130_fd_pr__nfet_01v8 ad=0.3864 pd=2.1 as=0 ps=0 w=0.42 l=0.15
X857 control_logic_rw_0.dff_buf_array_0.dff_buf_0_0.dff_0.net4 control_logic_rw_0.dff_buf_array_0.dff_buf_0_0.dff_0.clkb control_logic_rw_0.dff_buf_array_0.dff_buf_0_0.dff_0.net3 din0[1] sky130_fd_pr__pfet_01v8 ad=0.2915 pd=1.61 as=0.352 ps=2.38 w=0.55 l=0.15
X858 bank_0.replica_bitcell_array_0.bitcell_array_0.cell_1rw_27.qb bank_0.replica_bitcell_array_0.wl_0_4 din0[1] din0[1] sky130_fd_pr__nfet_01v8 ad=0.3864 pd=2.1 as=0.1428 ps=1.52 w=0.42 l=0.15
X859 row_addr_dff_0.dff_3.clkb row_addr_dff_0.dff_3.clk din0[1] din0[1] sky130_fd_pr__nfet_01v8 ad=0.1932 pd=1.76 as=0.1932 ps=1.76 w=0.42 l=0.15
X860 bank_0.replica_bitcell_array_0.dummy_array_2_0.dummy_cell_1rw_5.q bank_0.replica_bitcell_array_0.dummy_array_2_0.dummy_cell_1rw_5.qb din0[1] din0[1] sky130_fd_pr__nfet_01v8 ad=0.3864 pd=2.1 as=0.441 ps=3.22 w=1.26 l=0.15
X861 din0[1] bank_0.replica_bitcell_array_0.bitcell_array_0.cell_1rw_7.q bank_0.replica_bitcell_array_0.bitcell_array_0.cell_1rw_7.qb din0[1] sky130_fd_pr__pfet_01v8 ad=0.1925 pd=1.8 as=0.1925 ps=1.8 w=0.55 l=0.15
X862 a_n4741_4023# control_logic_rw_0.delay_chain_0.pinv_11_39.Z a_n4794_4023# din0[1] sky130_fd_pr__nfet_01v8 ad=0.1638 pd=1.62 as=0.1596 ps=1.6 w=0.42 l=0.15
X863 data_dff_0.dff_1.net3 data_dff_0.dff_1.net1 din0[1] din0[1] sky130_fd_pr__nfet_01v8 ad=0.2604 pd=2.08 as=0.168 ps=1.22 w=0.42 l=0.15
X864 din0[1] bank_0.replica_bitcell_array_0.bitcell_array_0.cell_1rw_3.q bank_0.replica_bitcell_array_0.bitcell_array_0.cell_1rw_3.qb din0[1] sky130_fd_pr__nfet_01v8 ad=0.441 pd=3.22 as=0.3864 ps=2.1 w=1.26 l=0.15
X865 din0[1] bank_0.replica_bitcell_array_0.bitcell_array_0.cell_1rw_8.q bank_0.replica_bitcell_array_0.bitcell_array_0.cell_1rw_8.qb din0[1] sky130_fd_pr__nfet_01v8 ad=0.441 pd=3.22 as=0.3864 ps=2.1 w=1.26 l=0.15
X866 din0[1] din0[1] din0[1] din0[1] sky130_fd_pr__nfet_01v8 ad=0.42 pd=2.68 as=0 ps=0 w=0.84 l=0.15
X867 a_5313_1928# control_logic_rw_0.p_en_bar a_5259_1928# w_4605_1519# sky130_fd_pr__pfet_01v8 ad=0.1848 pd=1.28 as=0.3276 ps=2.46 w=0.84 l=0.15
X868 bank_0.port_address_0.hierarchical_decoder_0.hierarchical_predecode2x4_0.and2_dec_2.pnand2_0.nmos_m_uq0 row_addr_dff_0.dout_2 a_1395_7391# din0[1] sky130_fd_pr__nfet_01v8 ad=0.1848 pd=1.28 as=0.3276 ps=2.46 w=0.84 l=0.15
X869 a_3797_5503# din0[1] a_3743_5503# din0[1] sky130_fd_pr__nfet_01v8 ad=0.1596 pd=1.6 as=0.1638 ps=1.62 w=0.42 l=0.15
X870 a_n675_n691# control_logic_rw_0.pdriver_0_0.pinv_7_0.A a_n753_n691# w_n2769_n767# sky130_fd_pr__pfet_01v8 ad=0.3622 pd=1.78 as=0.3622 ps=1.78 w=1.15 l=0.15
X871 din0[1] bank_0.replica_bitcell_array_0.bitcell_array_0.cell_1rw_16.q bank_0.replica_bitcell_array_0.bitcell_array_0.cell_1rw_16.qb din0[1] sky130_fd_pr__pfet_01v8 ad=0.1925 pd=1.8 as=0.1925 ps=1.8 w=0.55 l=0.15
X872 bank_0.replica_bitcell_array_0.dummy_array_2_0.dummy_cell_1rw_2.q bank_0.replica_bitcell_array_0.dummy_array_2_0.dummy_cell_1rw_2.qb din0[1] din0[1] sky130_fd_pr__pfet_01v8 ad=0.1925 pd=1.8 as=0.1925 ps=1.8 w=0.55 l=0.15
X873 din0[1] bank_0.replica_bitcell_array_0.dummy_array_2_0.dummy_cell_1rw_8.q bank_0.replica_bitcell_array_0.dummy_array_2_0.dummy_cell_1rw_8.qb din0[1] sky130_fd_pr__pfet_01v8 ad=0.1925 pd=1.8 as=0.1925 ps=1.8 w=0.55 l=0.15
X874 a_5530_10451# bank_0.replica_bitcell_array_0.wl_0_13 bank_0.replica_bitcell_array_0.dummy_array_3_0.dummy_cell_1rw_3.qb din0[1] sky130_fd_pr__nfet_01v8 ad=0.1428 pd=1.52 as=0.3864 ps=2.1 w=0.42 l=0.15
X875 din0[1] bank_0.replica_bitcell_array_0.dummy_array_2_0.dummy_cell_1rw_4.q bank_0.replica_bitcell_array_0.dummy_array_2_0.dummy_cell_1rw_4.qb din0[1] sky130_fd_pr__nfet_01v8 ad=0.441 pd=3.22 as=0.3864 ps=2.1 w=1.26 l=0.15
X876 bank_0.port_address_0.wordline_driver_array_0.wordline_driver_9.pnand2_0.nmos_m1_w0_840_sli_dactive_uq0 bank_0.port_address_0.wordline_driver_array_0.in_6 a_3370_6521# din0[1] sky130_fd_pr__nfet_01v8 ad=0.1848 pd=1.28 as=0.3276 ps=2.46 w=0.84 l=0.15
X877 din0[1] bank_0.replica_bitcell_array_0.dummy_array_2_0.dummy_cell_1rw_9.q bank_0.replica_bitcell_array_0.dummy_array_2_0.dummy_cell_1rw_9.qb din0[1] sky130_fd_pr__nfet_01v8 ad=0.441 pd=3.22 as=0.3864 ps=2.1 w=1.26 l=0.15
X878 bank_0.port_address_0.wordline_driver_array_0.wordline_driver_1.pnand2_0.nmos_m1_w0_840_sli_dactive_uq0 bank_0.port_address_0.wordline_driver_array_0.in_14 a_3370_10593# din0[1] sky130_fd_pr__nfet_01v8 ad=0.1848 pd=1.28 as=0.3276 ps=2.46 w=0.84 l=0.15
X879 row_addr_dff_0.dout_1 row_addr_dff_0.dff_2.net4 din0[1] din0[1] sky130_fd_pr__nfet_01v8 ad=0.168 pd=1.64 as=0.168 ps=1.22 w=0.42 l=0.15
X880 bank_0.replica_bitcell_array_0.dummy_array_2_0.dummy_cell_1rw_3.q bank_0.replica_bitcell_array_0.dummy_array_2_0.dummy_cell_1rw_3.qb din0[1] din0[1] sky130_fd_pr__pfet_01v8 ad=0.1925 pd=1.8 as=0.1925 ps=1.8 w=0.55 l=0.15
X881 a_3103_4993# din0[1] a_3049_4993# w_2422_4697# sky130_fd_pr__pfet_01v8 ad=0.3192 pd=2.44 as=0.3276 ps=2.46 w=0.84 l=0.15
X882 a_n5055_4129# control_logic_rw_0.delay_chain_0.pinv_11_34.Z a_n5108_4129# din0[1] sky130_fd_pr__nfet_01v8 ad=0.1638 pd=1.62 as=0.1596 ps=1.6 w=0.42 l=0.15
X883 a_n1529_927# control_logic_rw_0.dff_buf_array_0.dout_bar_0 a_n1607_927# w_n2769_857# sky130_fd_pr__pfet_01v8 ad=0.456 pd=3.16 as=0.378 ps=1.83 w=1.2 l=0.15
X884 row_addr_dff_0.dff_0.clkb row_addr_dff_0.dff_3.clk din0[1] din0[1] sky130_fd_pr__nfet_01v8 ad=0.1932 pd=1.76 as=0.1932 ps=1.76 w=0.42 l=0.15
X885 a_n3447_n919# control_logic_rw_0.dff_buf_array_0.dout_bar_0 a_n3525_n919# din0[1] sky130_fd_pr__nfet_01v8 ad=0.1764 pd=1.19 as=0.1764 ps=1.19 w=0.56 l=0.15
X886 a_n1822_123# control_logic_rw_0.dff_buf_array_0.dout_bar_0 a_n1900_123# w_n2769_44# sky130_fd_pr__pfet_01v8 ad=0.3528 pd=1.75 as=0.3528 ps=1.75 w=1.12 l=0.15
X887 din0[1] bank_0.replica_bitcell_array_0.bitcell_array_0.cell_1rw_17.q bank_0.replica_bitcell_array_0.bitcell_array_0.cell_1rw_17.qb din0[1] sky130_fd_pr__pfet_01v8 ad=0.1925 pd=1.8 as=0.1925 ps=1.8 w=0.55 l=0.15
X888 a_n1143_298# control_logic_rw_0.pdriver_1_0.pinv_6_0.A a_n1221_298# w_n2769_44# sky130_fd_pr__pfet_01v8 ad=0.399 pd=2.86 as=0.3307 ps=1.68 w=1.05 l=0.15
X889 bank_0.replica_bitcell_array_0.dummy_array_1_0.dummy_cell_1rw_0.q bank_0.replica_bitcell_array_0.dummy_array_1_0.dummy_cell_1rw_0.qb din0[1] din0[1] sky130_fd_pr__nfet_01v8 ad=0.3864 pd=2.1 as=0.441 ps=3.22 w=1.26 l=0.15
X890 a_n3447_n513# control_logic_rw_0.dff_buf_array_0.dout_bar_0 a_n3525_n513# w_n4225_n767# sky130_fd_pr__pfet_01v8 ad=0.3528 pd=1.75 as=0.3528 ps=1.75 w=1.12 l=0.15
X891 din0[1] din0[1] din0[1] din0[1] sky130_fd_pr__nfet_01v8 ad=0.1597 pd=1.34 as=0 ps=0 w=0.54 l=0.15
X892 bank_0.replica_bitcell_array_0.dummy_array_0_0.dummy_cell_1rw_0.q bank_0.replica_bitcell_array_0.dummy_array_0_0.dummy_cell_1rw_0.qb din0[1] din0[1] sky130_fd_pr__pfet_01v8 ad=0.1925 pd=1.8 as=0.1925 ps=1.8 w=0.55 l=0.15
X893 din0[1] bank_0.replica_bitcell_array_0.bitcell_array_0.cell_1rw_14.q bank_0.replica_bitcell_array_0.bitcell_array_0.cell_1rw_14.qb din0[1] sky130_fd_pr__pfet_01v8 ad=0.1925 pd=1.8 as=0.1925 ps=1.8 w=0.55 l=0.15
X894 bank_0.replica_bitcell_array_0.dummy_array_1_0.dummy_cell_1rw_1.q bank_0.replica_bitcell_array_0.dummy_array_1_0.dummy_cell_1rw_1.qb din0[1] din0[1] sky130_fd_pr__pfet_01v8 ad=0.1925 pd=1.8 as=0.1925 ps=1.8 w=0.55 l=0.15
X895 a_n2088_n464# control_logic_rw_0.pand2_1.pnand2_0_0.nmos_m1_w0_840_sactive_dli_0.G a_n2104_n464# w_n2769_n767# sky130_fd_pr__pfet_01v8 ad=1.7m pd=0.36 as=1.7m ps=0.36 w=0.17 l=0.15
X896 bank_0.replica_bitcell_array_0.dummy_array_3_0.dummy_cell_1rw_1.q bank_0.replica_bitcell_array_0.dummy_array_3_0.dummy_cell_1rw_1.qb din0[1] din0[1] sky130_fd_pr__pfet_01v8 ad=0.1925 pd=1.8 as=0.1925 ps=1.8 w=0.55 l=0.15
X897 bank_0.replica_bitcell_array_0.bitcell_array_0.cell_1rw_5.q bank_0.replica_bitcell_array_0.wl_0_10 din0[1] din0[1] sky130_fd_pr__nfet_01v8 ad=0.3864 pd=2.1 as=0.1428 ps=1.52 w=0.42 l=0.15
X898 bank_0.replica_bitcell_array_0.dummy_array_2_0.dummy_cell_1rw_18.q bank_0.replica_bitcell_array_0.dummy_array_2_0.dummy_cell_1rw_18.qb din0[1] din0[1] sky130_fd_pr__nfet_01v8 ad=0.3864 pd=2.1 as=0.441 ps=3.22 w=1.26 l=0.15
X899 din0[1] bank_0.replica_bitcell_array_0.wl_0_9 bank_0.replica_bitcell_array_0.bitcell_array_0.cell_1rw_6.qb din0[1] sky130_fd_pr__nfet_01v8 ad=0.1428 pd=1.52 as=0.3864 ps=2.1 w=0.42 l=0.15
X900 a_1508_6521# bank_0.port_address_0.hierarchical_decoder_0.hierarchical_predecode2x4_0.pinv_0.Z bank_0.port_address_0.hierarchical_decoder_0.hierarchical_predecode2x4_0.and2_dec_3.pnand2_0.nmos_m_uq0 din0[1] sky130_fd_pr__nfet_01v8 ad=0.3192 pd=2.44 as=0.1848 ps=1.28 w=0.84 l=0.15
X901 din0[1] data_dff_0.dff_1.clkb data_dff_0.dff_1.net3 din0[1] sky130_fd_pr__pfet_01v8 ad=0.2915 pd=1.61 as=0.352 ps=2.38 w=0.55 l=0.15
X902 a_n1919_1923# control_logic_rw_0.dff_buf_array_0.dout_1 a_n1997_1923# w_n2769_1669# sky130_fd_pr__pfet_01v8 ad=0.3192 pd=2.44 as=0.2646 ps=1.47 w=0.84 l=0.15
X903 din0[1] bank_0.replica_bitcell_array_0.dummy_array_2_0.dummy_cell_1rw_15.q bank_0.replica_bitcell_array_0.dummy_array_2_0.dummy_cell_1rw_15.qb din0[1] sky130_fd_pr__pfet_01v8 ad=0.1925 pd=1.8 as=0.1925 ps=1.8 w=0.55 l=0.15
X904 din0[1] bank_0.replica_bitcell_array_0.wl_0_15 din0[1] din0[1] sky130_fd_pr__nfet_01v8 ad=0.1428 pd=1.52 as=0 ps=0 w=0.42 l=0.15
X905 a_2789_10955# bank_0.port_address_0.hierarchical_decoder_0.predecode_7 a_2730_10955# w_2422_10805# sky130_fd_pr__pfet_01v8 ad=0.3192 pd=2.44 as=0.1848 ps=1.28 w=0.84 l=0.15
X906 a_3483_8409# control_logic_rw_0.wl_en bank_0.port_address_0.wordline_driver_array_0.wordline_driver_6.pnand2_0.nmos_m1_w0_840_sli_dactive_uq0 din0[1] sky130_fd_pr__nfet_01v8 ad=0.3192 pd=2.44 as=0.1848 ps=1.28 w=0.84 l=0.15
X907 a_n1430_n513# control_logic_rw_0.dff_buf_array_0.dout_bar_0 a_n1508_n513# w_n2769_n767# sky130_fd_pr__pfet_01v8 ad=0.3528 pd=1.75 as=0.3528 ps=1.75 w=1.12 l=0.15
X908 a_3103_9937# din0[1] a_3049_9937# w_2422_9787# sky130_fd_pr__pfet_01v8 ad=0.3192 pd=2.44 as=0.3276 ps=2.46 w=0.84 l=0.15
X909 bank_0.replica_bitcell_array_0.dummy_array_2_0.dummy_cell_1rw_6.q bank_0.replica_bitcell_array_0.wl_0_10 a_4421_8601# din0[1] sky130_fd_pr__nfet_01v8 ad=0.3864 pd=2.1 as=0.1428 ps=1.52 w=0.42 l=0.15
X910 a_4490_8415# bank_0.replica_bitcell_array_0.wl_0_9 bank_0.replica_bitcell_array_0.dummy_array_2_0.dummy_cell_1rw_7.qb din0[1] sky130_fd_pr__nfet_01v8 ad=0.1428 pd=1.52 as=0.3864 ps=2.1 w=0.42 l=0.15
X911 a_3424_7029# bank_0.port_address_0.wordline_driver_array_0.in_7 a_3370_7029# w_2422_6733# sky130_fd_pr__pfet_01v8 ad=0.1848 pd=1.28 as=0.3276 ps=2.46 w=0.84 l=0.15
X912 control_logic_rw_0.dff_buf_array_0.dff_buf_0_1.dff_0.net3 control_logic_rw_0.dff_buf_array_0.dff_buf_0_1.dff_0.net1 din0[1] din0[1] sky130_fd_pr__pfet_01v8 ad=0.3465 pd=2.36 as=0.22 ps=1.35 w=0.55 l=0.15
X913 bank_0.replica_bitcell_array_0.bitcell_array_0.cell_1rw_27.q bank_0.replica_bitcell_array_0.bitcell_array_0.cell_1rw_27.qb din0[1] din0[1] sky130_fd_pr__pfet_01v8 ad=0.1925 pd=1.8 as=0.1925 ps=1.8 w=0.55 l=0.15
X914 din0[1] bank_0.replica_bitcell_array_0.bitcell_array_0.cell_1rw_28.q bank_0.replica_bitcell_array_0.bitcell_array_0.cell_1rw_28.qb din0[1] sky130_fd_pr__pfet_01v8 ad=0.1925 pd=1.8 as=0.1925 ps=1.8 w=0.55 l=0.15
X915 row_addr_dff_0.dff_3.net4 row_addr_dff_0.dff_3.clk row_addr_dff_0.dff_3.net3 din0[1] sky130_fd_pr__nfet_01v8 ad=0.2226 pd=1.48 as=0.273 ps=2.14 w=0.42 l=0.15
X916 bank_0.replica_bitcell_array_0.dummy_array_3_0.dummy_cell_1rw_6.q bank_0.replica_bitcell_array_0.dummy_array_3_0.dummy_cell_1rw_6.qb din0[1] din0[1] sky130_fd_pr__pfet_01v8 ad=0.1925 pd=1.8 as=0.1925 ps=1.8 w=0.55 l=0.15
X917 bank_0.replica_bitcell_array_0.bitcell_array_0.cell_1rw_13.qb bank_0.replica_bitcell_array_0.wl_0_2 din0[1] din0[1] sky130_fd_pr__nfet_01v8 ad=0.3864 pd=2.1 as=0.1428 ps=1.52 w=0.42 l=0.15
X918 din0[1] bank_0.replica_bitcell_array_0.bitcell_array_0.cell_1rw_3.q bank_0.replica_bitcell_array_0.bitcell_array_0.cell_1rw_3.qb din0[1] sky130_fd_pr__pfet_01v8 ad=0.1925 pd=1.8 as=0.1925 ps=1.8 w=0.55 l=0.15
X919 din0[1] bank_0.replica_bitcell_array_0.replica_column_0.replica_cell_1rw_5.q din0[1] din0[1] sky130_fd_pr__nfet_01v8 ad=0.3864 pd=2.1 as=0 ps=0 w=1.26 l=0.15
X920 a_n909_n919# control_logic_rw_0.pdriver_0_0.pinv_7_0.A a_n987_n919# din0[1] sky130_fd_pr__nfet_01v8 ad=0.1795 pd=1.2 as=0.1795 ps=1.2 w=0.57 l=0.15
X921 din0[1] din0[1] data_dff_0.dff_1.net3 din0[1] sky130_fd_pr__nfet_01v8 ad=0.2226 pd=1.48 as=0.273 ps=2.14 w=0.42 l=0.15
X922 din0[1] din0[1] din0[1] din0[1] sky130_fd_pr__nfet_01v8 ad=0.189 pd=1.74 as=0 ps=0 w=0.42 l=0.27
X923 a_3483_11463# control_logic_rw_0.wl_en bank_0.port_address_0.wordline_driver_array_0.wordline_driver_0.pnand2_0.nmos_m1_w0_840_sactive_dli_uq0 din0[1] sky130_fd_pr__nfet_01v8 ad=0.3192 pd=2.44 as=0.1848 ps=1.28 w=0.84 l=0.15
X924 din0[1] bank_0.replica_bitcell_array_0.replica_column_0.replica_cell_1rw_2.q din0[1] din0[1] sky130_fd_pr__pfet_01v8 ad=0.1925 pd=1.8 as=0 ps=0 w=0.55 l=0.15
X925 a_1822_8451# din0[1] a_1768_8451# din0[1] sky130_fd_pr__nfet_01v8 ad=0.1596 pd=1.6 as=0.1638 ps=1.62 w=0.42 l=0.15
X926 bank_0.replica_bitcell_array_0.bitcell_array_0.cell_1rw_28.q bank_0.replica_bitcell_array_0.bitcell_array_0.cell_1rw_28.qb din0[1] din0[1] sky130_fd_pr__pfet_01v8 ad=0.1925 pd=1.8 as=0.1925 ps=1.8 w=0.55 l=0.15
X927 din0[1] bank_0.replica_bitcell_array_0.bitcell_array_0.cell_1rw_4.q bank_0.replica_bitcell_array_0.bitcell_array_0.cell_1rw_4.qb din0[1] sky130_fd_pr__nfet_01v8 ad=0.441 pd=3.22 as=0.3864 ps=2.1 w=1.26 l=0.15
X928 a_3797_9065# din0[1] a_3743_9065# w_2422_8769# sky130_fd_pr__pfet_01v8 ad=0.3192 pd=2.44 as=0.3276 ps=2.46 w=0.84 l=0.15
X929 bank_0.replica_bitcell_array_0.replica_column_0.replica_cell_1rw_5.q din0[1] din0[1] din0[1] sky130_fd_pr__pfet_01v8 ad=0.1925 pd=1.8 as=0.1925 ps=1.8 w=0.55 l=0.15
X930 a_3797_7539# din0[1] a_3743_7539# din0[1] sky130_fd_pr__nfet_01v8 ad=0.1596 pd=1.6 as=0.1638 ps=1.62 w=0.42 l=0.15
X931 din0[1] bank_0.replica_bitcell_array_0.dummy_array_3_0.dummy_cell_1rw_11.q bank_0.replica_bitcell_array_0.dummy_array_3_0.dummy_cell_1rw_11.qb din0[1] sky130_fd_pr__nfet_01v8 ad=0.441 pd=3.22 as=0.3864 ps=2.1 w=1.26 l=0.15
X932 bank_0.replica_bitcell_array_0.dummy_array_2_0.dummy_cell_1rw_14.qb bank_0.replica_bitcell_array_0.wl_0_2 a_4490_4529# din0[1] sky130_fd_pr__nfet_01v8 ad=0.3864 pd=2.1 as=0.1428 ps=1.52 w=0.42 l=0.15
X933 a_5201_3325# bank_0.replica_bitcell_array_0.rbl_wl_0_0 bank_0.replica_bitcell_array_0.dummy_array_0.dummy_cell_1rw_0.q din0[1] sky130_fd_pr__nfet_01v8 ad=0.1428 pd=1.52 as=0.3864 ps=2.1 w=0.42 l=0.15
X934 bank_0.replica_bitcell_array_0.dummy_array_3_0.dummy_cell_1rw_2.q bank_0.replica_bitcell_array_0.dummy_array_3_0.dummy_cell_1rw_2.qb din0[1] din0[1] sky130_fd_pr__nfet_01v8 ad=0.3864 pd=2.1 as=0.441 ps=3.22 w=1.26 l=0.15
X935 din0[1] bank_0.replica_bitcell_array_0.dummy_array_2_0.dummy_cell_1rw_4.q bank_0.replica_bitcell_array_0.dummy_array_2_0.dummy_cell_1rw_4.qb din0[1] sky130_fd_pr__pfet_01v8 ad=0.1925 pd=1.8 as=0.1925 ps=1.8 w=0.55 l=0.15
X936 a_3797_4847# din0[1] a_3743_4847# w_2422_4697# sky130_fd_pr__pfet_01v8 ad=0.3192 pd=2.44 as=0.3276 ps=2.46 w=0.84 l=0.15
X937 a_n4427_4023# control_logic_rw_0.delay_chain_0.pinv_11_39.Z a_n4480_4023# din0[1] sky130_fd_pr__nfet_01v8 ad=0.1638 pd=1.62 as=0.1596 ps=1.6 w=0.42 l=0.15
X938 control_logic_rw_0.dff_buf_array_0.dff_buf_0_1.dff_0.net3 control_logic_rw_0.dff_buf_array_0.dff_buf_0_1.dff_0.net1 din0[1] din0[1] sky130_fd_pr__nfet_01v8 ad=0.2604 pd=2.08 as=0.168 ps=1.22 w=0.42 l=0.15
X939 bank_0.port_address_0.wordline_driver_array_0.wordline_driver_5.pnand2_0.nmos_m1_w0_840_sli_dactive_uq0 bank_0.port_address_0.wordline_driver_array_0.in_10 a_3370_8557# din0[1] sky130_fd_pr__nfet_01v8 ad=0.1848 pd=1.28 as=0.3276 ps=2.46 w=0.84 l=0.15
X940 a_5530_4343# bank_0.replica_bitcell_array_0.wl_0_1 bank_0.replica_bitcell_array_0.dummy_array_3_0.dummy_cell_1rw_15.qb din0[1] sky130_fd_pr__nfet_01v8 ad=0.1428 pd=1.52 as=0.3864 ps=2.1 w=0.42 l=0.15
X941 din0[1] bank_0.replica_bitcell_array_0.dummy_array_2_0.dummy_cell_1rw_5.q bank_0.replica_bitcell_array_0.dummy_array_2_0.dummy_cell_1rw_5.qb din0[1] sky130_fd_pr__nfet_01v8 ad=0.441 pd=3.22 as=0.3864 ps=2.1 w=1.26 l=0.15
X942 a_3424_5865# bank_0.port_address_0.wordline_driver_array_0.in_4 a_3370_5865# w_2422_5715# sky130_fd_pr__pfet_01v8 ad=0.1848 pd=1.28 as=0.3276 ps=2.46 w=0.84 l=0.15
X943 a_2789_3975# bank_0.port_address_0.hierarchical_decoder_0.predecode_4 a_2730_3975# w_2422_3679# sky130_fd_pr__pfet_01v8 ad=0.3192 pd=2.44 as=0.1848 ps=1.28 w=0.84 l=0.15
X944 din0[1] din0[1] din0[1] din0[1] sky130_fd_pr__nfet_01v8 ad=0.2751 pd=1.65 as=0 ps=0 w=0.42 l=0.15
X945 a_4421_3325# bank_0.replica_bitcell_array_0.rbl_wl_0_0 bank_0.replica_bitcell_array_0.dummy_array_2_0.dummy_cell_1rw_17.q din0[1] sky130_fd_pr__nfet_01v8 ad=0.1428 pd=1.52 as=0.3864 ps=2.1 w=0.42 l=0.15
X946 din0[1] bank_0.replica_bitcell_array_0.wl_0_1 din0[1] din0[1] sky130_fd_pr__nfet_01v8 ad=0.1428 pd=1.52 as=0 ps=0 w=0.42 l=0.15
X947 din0[1] bank_0.replica_bitcell_array_0.dummy_array_2_0.dummy_cell_1rw_1.q bank_0.replica_bitcell_array_0.dummy_array_2_0.dummy_cell_1rw_1.qb din0[1] sky130_fd_pr__pfet_01v8 ad=0.1925 pd=1.8 as=0.1925 ps=1.8 w=0.55 l=0.15
X948 a_1508_7029# bank_0.port_address_0.hierarchical_decoder_0.hierarchical_predecode2x4_0.pinv_0.Z a_1449_7029# w_1141_6733# sky130_fd_pr__pfet_01v8 ad=0.3192 pd=2.44 as=0.1848 ps=1.28 w=0.84 l=0.15
X949 a_n2147_599# control_logic_rw_0.pdriver_1_0.pinv_8_0.A a_n2201_599# din0[1] sky130_fd_pr__nfet_01v8 ad=0.1596 pd=1.6 as=0.1638 ps=1.62 w=0.42 l=0.15
X950 row_addr_dff_0.dff_0.net4 row_addr_dff_0.dff_3.clk row_addr_dff_0.dff_0.net3 din0[1] sky130_fd_pr__nfet_01v8 ad=0.2226 pd=1.48 as=0.273 ps=2.14 w=0.42 l=0.15
X951 a_n5055_8329# control_logic_rw_0.delay_chain_0.pinv_11_9.Z a_n5108_8329# w_n5644_7860# sky130_fd_pr__pfet_01v8 ad=0.3276 pd=2.46 as=0.3192 ps=2.44 w=0.84 l=0.15
X952 din0[1] bank_0.replica_bitcell_array_0.wl_0_9 bank_0.replica_bitcell_array_0.bitcell_array_0.cell_1rw_22.q din0[1] sky130_fd_pr__nfet_01v8 ad=0.1428 pd=1.52 as=0.3864 ps=2.1 w=0.42 l=0.15
X953 bank_0.replica_bitcell_array_0.bitcell_array_0.cell_1rw_22.q bank_0.replica_bitcell_array_0.bitcell_array_0.cell_1rw_22.qb din0[1] din0[1] sky130_fd_pr__pfet_01v8 ad=0.1925 pd=1.8 as=0.1925 ps=1.8 w=0.55 l=0.15
X954 din0[1] bank_0.replica_bitcell_array_0.dummy_array_3_0.dummy_cell_1rw_1.q bank_0.replica_bitcell_array_0.dummy_array_3_0.dummy_cell_1rw_1.qb din0[1] sky130_fd_pr__pfet_01v8 ad=0.1925 pd=1.8 as=0.1925 ps=1.8 w=0.55 l=0.15
X955 row_addr_dff_0.dff_2.clkb row_addr_dff_0.dff_3.clk din0[1] din0[1] sky130_fd_pr__nfet_01v8 ad=0.1932 pd=1.76 as=0.1932 ps=1.76 w=0.42 l=0.15
X956 a_4421_10451# bank_0.replica_bitcell_array_0.wl_0_13 bank_0.replica_bitcell_array_0.dummy_array_2_0.dummy_cell_1rw_3.q din0[1] sky130_fd_pr__nfet_01v8 ad=0.1428 pd=1.52 as=0.3864 ps=2.1 w=0.42 l=0.15
X957 bank_0.replica_bitcell_array_0.bitcell_array_0.cell_1rw_29.q bank_0.replica_bitcell_array_0.bitcell_array_0.cell_1rw_29.qb din0[1] din0[1] sky130_fd_pr__nfet_01v8 ad=0.3864 pd=2.1 as=0.441 ps=3.22 w=1.26 l=0.15
X958 din0[1] din0[1] data_dff_0.dff_1.net5 din0[1] sky130_fd_pr__pfet_01v8 ad=0.2302 pd=1.47 as=0.308 ps=2.22 w=0.55 l=0.15
X959 a_3103_3467# din0[1] a_3049_3467# din0[1] sky130_fd_pr__nfet_01v8 ad=0.1596 pd=1.6 as=0.1638 ps=1.62 w=0.42 l=0.15
X960 bank_0.replica_bitcell_array_0.bitcell_array_0.cell_1rw_0.q bank_0.replica_bitcell_array_0.bitcell_array_0.cell_1rw_0.qb din0[1] din0[1] sky130_fd_pr__nfet_01v8 ad=0.3864 pd=2.1 as=0.441 ps=3.22 w=1.26 l=0.15
X961 a_5530_7397# bank_0.replica_bitcell_array_0.wl_0_7 bank_0.replica_bitcell_array_0.dummy_array_3_0.dummy_cell_1rw_9.qb din0[1] sky130_fd_pr__nfet_01v8 ad=0.1428 pd=1.52 as=0.3864 ps=2.1 w=0.42 l=0.15
X962 a_5461_10451# bank_0.replica_bitcell_array_0.wl_0_13 bank_0.replica_bitcell_array_0.dummy_array_3_0.dummy_cell_1rw_3.q din0[1] sky130_fd_pr__nfet_01v8 ad=0.1428 pd=1.52 as=0.3864 ps=2.1 w=0.42 l=0.15
X963 din0[1] control_logic_rw_0.dff_buf_array_0.dff_buf_0_1.dff_0.net3 control_logic_rw_0.dff_buf_array_0.dff_buf_0_1.dff_0.net2 din0[1] sky130_fd_pr__pfet_01v8 ad=0.22 pd=1.35 as=0.2915 ps=2.16 w=0.55 l=0.15
X964 din0[1] bank_0.replica_bitcell_array_0.dummy_array_3_0.dummy_cell_1rw_17.q bank_0.replica_bitcell_array_0.dummy_array_3_0.dummy_cell_1rw_17.qb din0[1] sky130_fd_pr__pfet_01v8 ad=0.1925 pd=1.8 as=0.1925 ps=1.8 w=0.55 l=0.15
X965 din0[1] bank_0.replica_bitcell_array_0.dummy_array_2_0.dummy_cell_1rw_2.q bank_0.replica_bitcell_array_0.dummy_array_2_0.dummy_cell_1rw_2.qb din0[1] sky130_fd_pr__pfet_01v8 ad=0.1925 pd=1.8 as=0.1925 ps=1.8 w=0.55 l=0.15
X966 din0[1] bank_0.replica_bitcell_array_0.wl_0_7 din0[1] din0[1] sky130_fd_pr__nfet_01v8 ad=0.1428 pd=1.52 as=0 ps=0 w=0.42 l=0.15
X967 bank_0.replica_bitcell_array_0.bitcell_array_0.cell_1rw_29.q bank_0.replica_bitcell_array_0.wl_0_2 din0[1] din0[1] sky130_fd_pr__nfet_01v8 ad=0.3864 pd=2.1 as=0.1428 ps=1.52 w=0.42 l=0.15
X968 a_1449_3975# din0[1] a_1395_3975# w_1141_3679# sky130_fd_pr__pfet_01v8 ad=0.1848 pd=1.28 as=0.3276 ps=2.46 w=0.84 l=0.15
X969 a_n1508_n227# control_logic_rw_0.dff_buf_array_0.dout_bar_0 a_n1586_n227# din0[1] sky130_fd_pr__nfet_01v8 ad=0.1764 pd=1.19 as=0.1764 ps=1.19 w=0.56 l=0.15
X970 a_n1919_927# control_logic_rw_0.dff_buf_array_0.dout_bar_0 a_n1997_927# w_n2769_857# sky130_fd_pr__pfet_01v8 ad=0.378 pd=1.83 as=0.378 ps=1.83 w=1.2 l=0.15
X971 row_addr_dff_0.dff_1.net2 row_addr_dff_0.dff_1.clkb row_addr_dff_0.dff_1.net1 din0[1] sky130_fd_pr__pfet_01v8 ad=0.374 pd=2.46 as=0.2915 ps=1.61 w=0.55 l=0.15
X972 bank_0.replica_bitcell_array_0.dummy_array_3_0.dummy_cell_1rw_8.q bank_0.replica_bitcell_array_0.wl_0_8 a_5461_7583# din0[1] sky130_fd_pr__nfet_01v8 ad=0.3864 pd=2.1 as=0.1428 ps=1.52 w=0.42 l=0.15
X973 a_n2056_123# control_logic_rw_0.dff_buf_array_0.dout_bar_0 a_n2110_123# w_n2769_44# sky130_fd_pr__pfet_01v8 ad=0.3528 pd=1.75 as=0.4368 ps=3.02 w=1.12 l=0.15
X974 a_n2461_963# control_logic_rw_0.dff_buf_array_0.dout_bar_0 a_n2515_963# w_n2769_857# sky130_fd_pr__pfet_01v8 ad=0.1848 pd=1.28 as=0.3276 ps=2.46 w=0.84 l=0.15
X975 din0[1] bank_0.replica_bitcell_array_0.bitcell_array_0.cell_1rw_17.q bank_0.replica_bitcell_array_0.bitcell_array_0.cell_1rw_17.qb din0[1] sky130_fd_pr__nfet_01v8 ad=0.441 pd=3.22 as=0.3864 ps=2.1 w=1.26 l=0.15
X976 a_2789_10445# bank_0.port_address_0.hierarchical_decoder_0.predecode_7 bank_0.port_address_0.hierarchical_decoder_0.and2_dec_2.pnand2_0.nmos_m1_w0_840_sactive_dli_0.S din0[1] sky130_fd_pr__nfet_01v8 ad=0.3192 pd=2.44 as=0.1848 ps=1.28 w=0.84 l=0.15
X977 a_2789_8919# bank_0.port_address_0.hierarchical_decoder_0.predecode_6 a_2730_8919# w_2422_8769# sky130_fd_pr__pfet_01v8 ad=0.3192 pd=2.44 as=0.1848 ps=1.28 w=0.84 l=0.15
X978 a_n1744_n107# control_logic_rw_0.dff_buf_array_0.dout_bar_0 a_n1822_n107# din0[1] sky130_fd_pr__nfet_01v8 ad=0.1764 pd=1.19 as=0.1764 ps=1.19 w=0.56 l=0.15
X979 a_n1723_299# control_logic_rw_0.pdriver_1_0.pinv_8_0.Z a_n1801_299# w_n2769_44# sky130_fd_pr__pfet_01v8 ad=0.3192 pd=2.44 as=0.2646 ps=1.47 w=0.84 l=0.15
X980 din0[1] bank_0.replica_bitcell_array_0.dummy_array_1_0.dummy_cell_1rw_0.q bank_0.replica_bitcell_array_0.dummy_array_1_0.dummy_cell_1rw_0.qb din0[1] sky130_fd_pr__nfet_01v8 ad=0.441 pd=3.22 as=0.3864 ps=2.1 w=1.26 l=0.15
X981 bank_0.replica_bitcell_array_0.replica_column_0.dummy_cell_1rw_0.q bank_0.replica_bitcell_array_0.replica_column_0.dummy_cell_1rw_0.qb din0[1] din0[1] sky130_fd_pr__pfet_01v8 ad=0.1925 pd=1.8 as=0.1925 ps=1.8 w=0.55 l=0.15
X982 bank_0.replica_bitcell_array_0.dummy_array_2_0.dummy_cell_1rw_0.q bank_0.replica_bitcell_array_0.dummy_array_2_0.dummy_cell_1rw_0.qb din0[1] din0[1] sky130_fd_pr__nfet_01v8 ad=0.3864 pd=2.1 as=0.441 ps=3.22 w=1.26 l=0.15
X983 din0[1] bank_0.replica_bitcell_array_0.dummy_array_3_0.dummy_cell_1rw_2.q bank_0.replica_bitcell_array_0.dummy_array_3_0.dummy_cell_1rw_2.qb din0[1] sky130_fd_pr__pfet_01v8 ad=0.1925 pd=1.8 as=0.1925 ps=1.8 w=0.55 l=0.15
X984 din0[1] din0[1] data_dff_0.dff_1.net5 din0[1] sky130_fd_pr__nfet_01v8 ad=0.1782 pd=1.34 as=0.2352 ps=1.96 w=0.42 l=0.15
X985 din0[1] bank_0.replica_bitcell_array_0.replica_column_0.replica_cell_1rw_16.q din0[1] din0[1] sky130_fd_pr__pfet_01v8 ad=0.1925 pd=1.8 as=0 ps=0 w=0.55 l=0.15
X986 bank_0.replica_bitcell_array_0.dummy_array_1_0.dummy_cell_1rw_0.q bank_0.replica_bitcell_array_0.dummy_array_1_0.dummy_cell_1rw_0.qb din0[1] din0[1] sky130_fd_pr__pfet_01v8 ad=0.1925 pd=1.8 as=0.1925 ps=1.8 w=0.55 l=0.15
X987 bank_0.replica_bitcell_array_0.bitcell_array_0.cell_1rw_16.q bank_0.replica_bitcell_array_0.bitcell_array_0.cell_1rw_16.qb din0[1] din0[1] sky130_fd_pr__pfet_01v8 ad=0.1925 pd=1.8 as=0.1925 ps=1.8 w=0.55 l=0.15
X988 bank_0.replica_bitcell_array_0.replica_column_0.replica_cell_1rw_7.q bank_0.replica_bitcell_array_0.wl_0_8 din0[1] din0[1] sky130_fd_pr__nfet_01v8 ad=0.3864 pd=2.1 as=0.1428 ps=1.52 w=0.42 l=0.15
X989 a_n4113_3141# din0[1] a_n4166_3141# w_n5644_2820# sky130_fd_pr__pfet_01v8 ad=0.3276 pd=2.46 as=0.3192 ps=2.44 w=0.84 l=0.15
X990 bank_0.replica_bitcell_array_0.dummy_array_3_0.dummy_cell_1rw_7.q bank_0.replica_bitcell_array_0.dummy_array_3_0.dummy_cell_1rw_7.qb din0[1] din0[1] sky130_fd_pr__nfet_01v8 ad=0.3864 pd=2.1 as=0.441 ps=3.22 w=1.26 l=0.15
X991 din0[1] bank_0.replica_bitcell_array_0.bitcell_array_0.cell_1rw_24.q bank_0.replica_bitcell_array_0.bitcell_array_0.cell_1rw_24.qb din0[1] sky130_fd_pr__pfet_01v8 ad=0.1925 pd=1.8 as=0.1925 ps=1.8 w=0.55 l=0.15
X992 din0[1] bank_0.replica_bitcell_array_0.dummy_array_2_0.dummy_cell_1rw_18.q bank_0.replica_bitcell_array_0.dummy_array_2_0.dummy_cell_1rw_18.qb din0[1] sky130_fd_pr__nfet_01v8 ad=0.441 pd=3.22 as=0.3864 ps=2.1 w=1.26 l=0.15
X993 a_n5369_9063# control_logic_rw_0.delay_chain_0.pinv_11_9.Z a_n5422_9063# din0[1] sky130_fd_pr__nfet_01v8 ad=0.1638 pd=1.62 as=0.1596 ps=1.6 w=0.42 l=0.15
X994 bank_0.replica_bitcell_array_0.bitcell_array_0.cell_1rw_9.qb bank_0.replica_bitcell_array_0.wl_0_6 din0[1] din0[1] sky130_fd_pr__nfet_01v8 ad=0.3864 pd=2.1 as=0.1428 ps=1.52 w=0.42 l=0.15
X995 din0[1] control_logic_rw_0.dff_buf_array_0.dff_buf_0_1.dff_0.net3 control_logic_rw_0.dff_buf_array_0.dff_buf_0_1.dff_0.net2 din0[1] sky130_fd_pr__nfet_01v8 ad=0.168 pd=1.22 as=0.2226 ps=1.9 w=0.42 l=0.15
X996 bank_0.replica_bitcell_array_0.dummy_array_2_0.dummy_cell_1rw_18.q bank_0.replica_bitcell_array_0.dummy_array_2_0.dummy_cell_1rw_18.qb din0[1] din0[1] sky130_fd_pr__pfet_01v8 ad=0.1925 pd=1.8 as=0.1925 ps=1.8 w=0.55 l=0.15
X997 bank_0.replica_bitcell_array_0.replica_column_0.replica_cell_1rw_6.q din0[1] din0[1] din0[1] sky130_fd_pr__nfet_01v8 ad=0.3864 pd=2.1 as=0.441 ps=3.22 w=1.26 l=0.15
X998 bank_0.replica_bitcell_array_0.dummy_array_3_0.dummy_cell_1rw_15.q bank_0.replica_bitcell_array_0.dummy_array_3_0.dummy_cell_1rw_15.qb din0[1] din0[1] sky130_fd_pr__pfet_01v8 ad=0.1925 pd=1.8 as=0.1925 ps=1.8 w=0.55 l=0.15
X999 control_logic_rw_0.dff_buf_array_0.dff_buf_0_0.dff_0.net5 din0[1] control_logic_rw_0.dff_buf_array_0.dff_buf_0_0.dff_0.net4 din0[1] sky130_fd_pr__pfet_01v8 ad=0.4345 pd=2.68 as=0.2915 ps=1.61 w=0.55 l=0.15
X1000 bank_0.port_address_0.hierarchical_decoder_0.and2_dec_9.pnand2_0.nmos_m1_w0_840_sactive_dli_0.S bank_0.port_address_0.hierarchical_decoder_0.predecode_2 a_2676_6521# din0[1] sky130_fd_pr__nfet_01v8 ad=0.1848 pd=1.28 as=0.3276 ps=2.46 w=0.84 l=0.15
X1001 control_logic_rw_0.pand3_0_0.pnand3_0_0.nmos_m1_w0_840_sactive_dactive_0.D control_logic_rw_0.dff_buf_array_0.dout_bar_0 control_logic_rw_0.pand3_0_0.pnand3_0_0.nmos_m1_w0_840_sactive_dactive_0.S din0[1] sky130_fd_pr__nfet_01v8 ad=0.1848 pd=1.28 as=0.1848 ps=1.28 w=0.84 l=0.15
X1002 bank_0.replica_bitcell_array_0.dummy_array_3_0.dummy_cell_1rw_3.q bank_0.replica_bitcell_array_0.dummy_array_3_0.dummy_cell_1rw_3.qb din0[1] din0[1] sky130_fd_pr__nfet_01v8 ad=0.3864 pd=2.1 as=0.441 ps=3.22 w=1.26 l=0.15
X1003 a_n4113_9861# control_logic_rw_0.delay_chain_0.pinv_11_9.Z a_n4166_9861# w_n5644_9540# sky130_fd_pr__pfet_01v8 ad=0.3276 pd=2.46 as=0.3192 ps=2.44 w=0.84 l=0.15
X1004 bank_0.replica_bitcell_array_0.dummy_array_2_0.dummy_cell_1rw_10.qb bank_0.replica_bitcell_array_0.wl_0_6 a_4490_6565# din0[1] sky130_fd_pr__nfet_01v8 ad=0.3864 pd=2.1 as=0.1428 ps=1.52 w=0.42 l=0.15
X1005 din0[1] bank_0.replica_bitcell_array_0.wl_0_3 bank_0.replica_bitcell_array_0.bitcell_array_0.cell_1rw_12.q din0[1] sky130_fd_pr__nfet_01v8 ad=0.1428 pd=1.52 as=0.3864 ps=2.1 w=0.42 l=0.15
X1006 din0[1] bank_0.replica_bitcell_array_0.wl_0_15 bank_0.replica_bitcell_array_0.replica_column_0.replica_cell_1rw_0.q din0[1] sky130_fd_pr__nfet_01v8 ad=0.1428 pd=1.52 as=0.3864 ps=2.1 w=0.42 l=0.15
X1007 bank_0.replica_bitcell_array_0.bitcell_array_0.cell_1rw_11.q bank_0.replica_bitcell_array_0.bitcell_array_0.cell_1rw_11.qb din0[1] din0[1] sky130_fd_pr__pfet_01v8 ad=0.1925 pd=1.8 as=0.1925 ps=1.8 w=0.55 l=0.15
X1008 bank_0.port_address_0.wordline_driver_array_0.wordline_driver_12.pnand2_0.nmos_m1_w0_840_sli_dactiv_uq0 bank_0.port_address_0.wordline_driver_array_0.in_3 a_3370_5355# din0[1] sky130_fd_pr__nfet_01v8 ad=0.1848 pd=1.28 as=0.3276 ps=2.46 w=0.84 l=0.15
X1009 bank_0.replica_bitcell_array_0.replica_column_0.replica_cell_1rw_14.q din0[1] din0[1] din0[1] sky130_fd_pr__pfet_01v8 ad=0.1925 pd=1.8 as=0.1925 ps=1.8 w=0.55 l=0.15
X1010 a_3424_11101# bank_0.port_address_0.wordline_driver_array_0.in_15 a_3370_11101# w_2422_10805# sky130_fd_pr__pfet_01v8 ad=0.1848 pd=1.28 as=0.3276 ps=2.46 w=0.84 l=0.15
X1011 din0[1] bank_0.replica_bitcell_array_0.bitcell_array_0.cell_1rw_25.q bank_0.replica_bitcell_array_0.bitcell_array_0.cell_1rw_25.qb din0[1] sky130_fd_pr__pfet_01v8 ad=0.1925 pd=1.8 as=0.1925 ps=1.8 w=0.55 l=0.15
X1012 a_4421_5361# bank_0.replica_bitcell_array_0.wl_0_3 bank_0.replica_bitcell_array_0.dummy_array_2_0.dummy_cell_1rw_13.q din0[1] sky130_fd_pr__nfet_01v8 ad=0.1428 pd=1.52 as=0.3864 ps=2.1 w=0.42 l=0.15
X1013 a_739_3975# row_addr_dff_0.dout_1 a_685_3975# w_431_3679# sky130_fd_pr__pfet_01v8 ad=0.3192 pd=2.44 as=0.3276 ps=2.46 w=0.84 l=0.15
X1014 bank_0.replica_bitcell_array_0.bitcell_array_0.cell_1rw_17.q bank_0.replica_bitcell_array_0.bitcell_array_0.cell_1rw_17.qb din0[1] din0[1] sky130_fd_pr__nfet_01v8 ad=0.3864 pd=2.1 as=0.441 ps=3.22 w=1.26 l=0.15
X1015 din0[1] bank_0.replica_bitcell_array_0.bitcell_array_0.cell_1rw_21.q bank_0.replica_bitcell_array_0.bitcell_array_0.cell_1rw_21.qb din0[1] sky130_fd_pr__nfet_01v8 ad=0.441 pd=3.22 as=0.3864 ps=2.1 w=1.26 l=0.15
X1016 a_1822_7539# din0[1] a_1768_7539# din0[1] sky130_fd_pr__nfet_01v8 ad=0.1596 pd=1.6 as=0.1638 ps=1.62 w=0.42 l=0.15
X1017 bank_0.replica_bitcell_array_0.dummy_array_2_0.dummy_cell_1rw_12.q bank_0.replica_bitcell_array_0.dummy_array_2_0.dummy_cell_1rw_12.qb din0[1] din0[1] sky130_fd_pr__pfet_01v8 ad=0.1925 pd=1.8 as=0.1925 ps=1.8 w=0.55 l=0.15
X1018 a_1822_4847# din0[1] a_1768_4847# w_1141_4697# sky130_fd_pr__pfet_01v8 ad=0.3192 pd=2.44 as=0.3276 ps=2.46 w=0.84 l=0.15
X1019 a_n4113_2449# din0[1] a_n4166_2449# din0[1] sky130_fd_pr__nfet_01v8 ad=0.1638 pd=1.62 as=0.1596 ps=1.6 w=0.42 l=0.15
X1020 din0[1] bank_0.replica_bitcell_array_0.replica_column_0.dummy_cell_1rw_0.q bank_0.replica_bitcell_array_0.replica_column_0.dummy_cell_1rw_0.qb din0[1] sky130_fd_pr__pfet_01v8 ad=0.1925 pd=1.8 as=0.1925 ps=1.8 w=0.55 l=0.15
X1021 bank_0.replica_bitcell_array_0.bitcell_array_0.cell_1rw_12.q bank_0.replica_bitcell_array_0.bitcell_array_0.cell_1rw_12.qb din0[1] din0[1] sky130_fd_pr__pfet_01v8 ad=0.1925 pd=1.8 as=0.1925 ps=1.8 w=0.55 l=0.15
X1022 row_addr_dff_0.dff_1.net3 row_addr_dff_0.dff_1.net1 din0[1] din0[1] sky130_fd_pr__nfet_01v8 ad=0.2604 pd=2.08 as=0.168 ps=1.22 w=0.42 l=0.15
X1023 row_addr_dff_0.dff_2.net4 row_addr_dff_0.dff_3.clk row_addr_dff_0.dff_2.net3 din0[1] sky130_fd_pr__nfet_01v8 ad=0.2226 pd=1.48 as=0.273 ps=2.14 w=0.42 l=0.15
X1024 a_n1774_1411# control_logic_rw_0.pdriver_4_0.pinv_8_0.A a_n1828_1411# din0[1] sky130_fd_pr__nfet_01v8 ad=0.1596 pd=1.6 as=0.1638 ps=1.62 w=0.42 l=0.15
X1025 a_n1489_n681# control_logic_rw_0.pdriver_0_0.pinv_6_0.A a_n1567_n681# w_n2769_n767# sky130_fd_pr__pfet_01v8 ad=0.399 pd=2.86 as=0.3307 ps=1.68 w=1.05 l=0.15
X1026 a_n1763_705# control_logic_rw_0.dff_buf_array_0.dout_bar_0 a_n1841_705# din0[1] sky130_fd_pr__nfet_01v8 ad=0.189 pd=1.23 as=0.189 ps=1.23 w=0.6 l=0.15
X1027 bank_0.replica_bitcell_array_0.dummy_array_2_0.dummy_cell_1rw_13.q bank_0.replica_bitcell_array_0.dummy_array_2_0.dummy_cell_1rw_13.qb din0[1] din0[1] sky130_fd_pr__pfet_01v8 ad=0.1925 pd=1.8 as=0.1925 ps=1.8 w=0.55 l=0.15
X1028 bank_0.replica_bitcell_array_0.bitcell_array_0.cell_1rw_25.q bank_0.replica_bitcell_array_0.bitcell_array_0.cell_1rw_25.qb din0[1] din0[1] sky130_fd_pr__nfet_01v8 ad=0.3864 pd=2.1 as=0.441 ps=3.22 w=1.26 l=0.15
X1029 bank_0.replica_bitcell_array_0.bitcell_array_0.cell_1rw_30.q bank_0.replica_bitcell_array_0.bitcell_array_0.cell_1rw_30.qb din0[1] din0[1] sky130_fd_pr__nfet_01v8 ad=0.3864 pd=2.1 as=0.441 ps=3.22 w=1.26 l=0.15
X1030 bank_0.port_data_0.sense_amp_array_0.sense_amp_1.net1 bank_0.port_data_0.sense_amp_array_0.sense_amp_1.net1 din0[1] din0[1] sky130_fd_pr__pfet_01v8 ad=0.22 pd=1.9 as=0.2475 ps=2 w=0.55 l=0.15
X1031 bank_0.replica_bitcell_array_0.bitcell_array_0.cell_1rw_6.q bank_0.replica_bitcell_array_0.bitcell_array_0.cell_1rw_6.qb din0[1] din0[1] sky130_fd_pr__pfet_01v8 ad=0.1925 pd=1.8 as=0.1925 ps=1.8 w=0.55 l=0.15
X1032 bank_0.replica_bitcell_array_0.bitcell_array_0.cell_1rw_25.q bank_0.replica_bitcell_array_0.wl_0_6 din0[1] din0[1] sky130_fd_pr__nfet_01v8 ad=0.3864 pd=2.1 as=0.1428 ps=1.52 w=0.42 l=0.15
X1033 din0[1] din0[1] din0[1] din0[1] sky130_fd_pr__nfet_01v8 ad=0.126 pd=1.02 as=0 ps=0 w=0.42 l=0.15
X1034 din0[1] bank_0.port_data_0.sense_amp_array_0.sense_amp_1.net1 din0[1] din0[1] sky130_fd_pr__pfet_01v8 ad=0.45 pd=2.9 as=0 ps=0 w=1 l=0.15
X1035 bank_0.replica_bitcell_array_0.replica_column_0.replica_cell_1rw_0.q din0[1] din0[1] din0[1] sky130_fd_pr__nfet_01v8 ad=0.3864 pd=2.1 as=0.441 ps=3.22 w=1.26 l=0.15
X1036 bank_0.replica_bitcell_array_0.dummy_array_2_0.dummy_cell_1rw_2.qb bank_0.replica_bitcell_array_0.wl_0_14 a_4490_10637# din0[1] sky130_fd_pr__nfet_01v8 ad=0.3864 pd=2.1 as=0.1428 ps=1.52 w=0.42 l=0.15
X1037 a_n5055_8181# control_logic_rw_0.delay_chain_0.pinv_11_14.Z a_n5108_8181# w_n5644_7860# sky130_fd_pr__pfet_01v8 ad=0.3276 pd=2.46 as=0.3192 ps=2.44 w=0.84 l=0.15
X1038 a_2789_8409# bank_0.port_address_0.hierarchical_decoder_0.predecode_6 bank_0.port_address_0.hierarchical_decoder_0.and2_dec_6.pnand2_0.nmos_m1_w0_840_sactive_dli_0.S din0[1] sky130_fd_pr__nfet_01v8 ad=0.3192 pd=2.44 as=0.1848 ps=1.28 w=0.84 l=0.15
X1039 control_logic_rw_0.pand3_0.pnand3_0_0.nmos_m1_w0_840_sactive_dactive_0.D control_logic_rw_0.pand3_0.B control_logic_rw_0.pand3_0.pnand3_0_0.nmos_m1_w0_840_sactive_dactive_0.S din0[1] sky130_fd_pr__nfet_01v8 ad=0.1848 pd=1.28 as=0.1848 ps=1.28 w=0.84 l=0.15
X1040 row_addr_dff_0.dff_3.net2 row_addr_dff_0.dff_3.clkb row_addr_dff_0.dff_3.net1 din0[1] sky130_fd_pr__pfet_01v8 ad=0.374 pd=2.46 as=0.2915 ps=1.61 w=0.55 l=0.15
X1041 a_2730_7029# bank_0.port_address_0.hierarchical_decoder_0.predecode_3 a_2676_7029# w_2422_6733# sky130_fd_pr__pfet_01v8 ad=0.1848 pd=1.28 as=0.3276 ps=2.46 w=0.84 l=0.15
X1042 a_3483_6011# control_logic_rw_0.wl_en a_3424_6011# w_2422_5715# sky130_fd_pr__pfet_01v8 ad=0.3192 pd=2.44 as=0.1848 ps=1.28 w=0.84 l=0.15
X1043 a_1508_5355# row_addr_dff_0.dout_1 bank_0.port_address_0.hierarchical_decoder_0.hierarchical_predecode2x4_1.and2_dec_0.pnand2_0.nmos_m_uq0 din0[1] sky130_fd_pr__nfet_01v8 ad=0.3192 pd=2.44 as=0.1848 ps=1.28 w=0.84 l=0.15
X1044 din0[1] bank_0.replica_bitcell_array_0.wl_0_13 bank_0.replica_bitcell_array_0.bitcell_array_0.cell_1rw_18.q din0[1] sky130_fd_pr__nfet_01v8 ad=0.1428 pd=1.52 as=0.3864 ps=2.1 w=0.42 l=0.15
X1045 din0[1] bank_0.replica_bitcell_array_0.bitcell_array_0.cell_1rw_18.q bank_0.replica_bitcell_array_0.bitcell_array_0.cell_1rw_18.qb din0[1] sky130_fd_pr__nfet_01v8 ad=0.441 pd=3.22 as=0.3864 ps=2.1 w=1.26 l=0.15
X1046 a_n4741_7383# control_logic_rw_0.delay_chain_0.pinv_11_19.Z a_n4794_7383# din0[1] sky130_fd_pr__nfet_01v8 ad=0.1638 pd=1.62 as=0.1596 ps=1.6 w=0.42 l=0.15
X1047 a_n4741_6501# control_logic_rw_0.delay_chain_0.pinv_11_24.Z a_n4794_6501# w_n5644_6180# sky130_fd_pr__pfet_01v8 ad=0.3276 pd=2.46 as=0.3192 ps=2.44 w=0.84 l=0.15
X1048 a_n5055_4969# control_logic_rw_0.delay_chain_0.pinv_11_29.Z a_n5108_4969# w_n5644_4500# sky130_fd_pr__pfet_01v8 ad=0.3276 pd=2.46 as=0.3192 ps=2.44 w=0.84 l=0.15
X1049 bank_0.replica_bitcell_array_0.bitcell_array_0.cell_1rw_13.q bank_0.replica_bitcell_array_0.bitcell_array_0.cell_1rw_13.qb din0[1] din0[1] sky130_fd_pr__nfet_01v8 ad=0.3864 pd=2.1 as=0.441 ps=3.22 w=1.26 l=0.15
X1050 bank_0.replica_bitcell_array_0.dummy_array_2_0.dummy_cell_1rw_7.q bank_0.replica_bitcell_array_0.dummy_array_2_0.dummy_cell_1rw_7.qb din0[1] din0[1] sky130_fd_pr__pfet_01v8 ad=0.1925 pd=1.8 as=0.1925 ps=1.8 w=0.55 l=0.15
X1051 bank_0.port_data_0.write_driver_array_0.write_driver_0.net6 din0[1] din0[1] din0[1] sky130_fd_pr__pfet_01v8 ad=0.275 pd=2.1 as=0.2722 ps=1.54 w=0.55 l=0.15
X1052 bank_0.replica_bitcell_array_0.dummy_array_2_0.dummy_cell_1rw_14.q bank_0.replica_bitcell_array_0.dummy_array_2_0.dummy_cell_1rw_14.qb din0[1] din0[1] sky130_fd_pr__nfet_01v8 ad=0.3864 pd=2.1 as=0.441 ps=3.22 w=1.26 l=0.15
X1053 control_logic_rw_0.dff_buf_array_0.dff_buf_0_1.dff_0.net1 din0[1] csb0 din0[1] sky130_fd_pr__pfet_01v8 ad=0.2915 pd=1.61 as=0.253 ps=2.02 w=0.55 l=0.15
X1054 din0[1] bank_0.replica_bitcell_array_0.dummy_array_2_0.dummy_cell_1rw_2.q bank_0.replica_bitcell_array_0.dummy_array_2_0.dummy_cell_1rw_2.qb din0[1] sky130_fd_pr__nfet_01v8 ad=0.441 pd=3.22 as=0.3864 ps=2.1 w=1.26 l=0.15
X1055 a_n2056_n107# control_logic_rw_0.dff_buf_array_0.dout_bar_0 a_n2110_n107# din0[1] sky130_fd_pr__nfet_01v8 ad=0.1764 pd=1.19 as=0.2184 ps=1.9 w=0.56 l=0.15
X1056 a_n2088_1111# control_logic_rw_0.delay_chain_0.out a_n2142_1111# w_n2769_857# sky130_fd_pr__pfet_01v8 ad=0.3192 pd=2.44 as=0.3276 ps=2.46 w=0.84 l=0.15
X1057 a_3103_11505# din0[1] a_3049_11505# din0[1] sky130_fd_pr__nfet_01v8 ad=0.1596 pd=1.6 as=0.1638 ps=1.62 w=0.42 l=0.15
X1058 din0[1] bank_0.replica_bitcell_array_0.dummy_array_3_0.dummy_cell_1rw_2.q bank_0.replica_bitcell_array_0.dummy_array_3_0.dummy_cell_1rw_2.qb din0[1] sky130_fd_pr__nfet_01v8 ad=0.441 pd=3.22 as=0.3864 ps=2.1 w=1.26 l=0.15
X1059 din0[1] din0[1] bank_0.port_data_0.write_driver_array_0.write_driver_0.net6 din0[1] sky130_fd_pr__pfet_01v8 ad=0.275 pd=2.1 as=0.275 ps=2.1 w=0.55 l=0.15
X1060 bank_0.port_address_0.hierarchical_decoder_0.and2_dec_5.pnand2_0.nmos_m1_w0_840_sactive_dli_0.S bank_0.port_address_0.hierarchical_decoder_0.predecode_2 a_2676_8557# din0[1] sky130_fd_pr__nfet_01v8 ad=0.1848 pd=1.28 as=0.3276 ps=2.46 w=0.84 l=0.15
X1061 bank_0.port_address_0.hierarchical_decoder_0.hierarchical_predecode2x4_0.and2_dec_0.pnand2_0.nmos_m_uq0 row_addr_dff_0.dout_2 a_1395_8409# din0[1] sky130_fd_pr__nfet_01v8 ad=0.1848 pd=1.28 as=0.3276 ps=2.46 w=0.84 l=0.15
X1062 bank_0.replica_bitcell_array_0.dummy_array_0_0.dummy_cell_1rw_0.qb din0[1] a_5270_11655# din0[1] sky130_fd_pr__nfet_01v8 ad=0.3864 pd=2.1 as=0.1428 ps=1.52 w=0.42 l=0.15
X1063 a_2730_5865# bank_0.port_address_0.hierarchical_decoder_0.predecode_0 a_2676_5865# w_2422_5715# sky130_fd_pr__pfet_01v8 ad=0.1848 pd=1.28 as=0.3276 ps=2.46 w=0.84 l=0.15
X1064 a_n5055_7489# control_logic_rw_0.delay_chain_0.pinv_11_14.Z a_n5108_7489# din0[1] sky130_fd_pr__nfet_01v8 ad=0.1638 pd=1.62 as=0.1596 ps=1.6 w=0.42 l=0.15
X1065 a_5461_4343# bank_0.replica_bitcell_array_0.wl_0_1 bank_0.replica_bitcell_array_0.dummy_array_3_0.dummy_cell_1rw_15.q din0[1] sky130_fd_pr__nfet_01v8 ad=0.1428 pd=1.52 as=0.3864 ps=2.1 w=0.42 l=0.15
X1066 bank_0.replica_bitcell_array_0.bitcell_array_0.cell_1rw_19.qb bank_0.replica_bitcell_array_0.wl_0_12 din0[1] din0[1] sky130_fd_pr__nfet_01v8 ad=0.3864 pd=2.1 as=0.1428 ps=1.52 w=0.42 l=0.15
X1067 a_n597_n691# control_logic_rw_0.pdriver_0_0.pinv_7_0.A a_n675_n691# w_n2769_n767# sky130_fd_pr__pfet_01v8 ad=0.3622 pd=1.78 as=0.3622 ps=1.78 w=1.15 l=0.15
X1068 a_n4741_5809# control_logic_rw_0.delay_chain_0.pinv_11_24.Z a_n4794_5809# din0[1] sky130_fd_pr__nfet_01v8 ad=0.1638 pd=1.62 as=0.1596 ps=1.6 w=0.42 l=0.15
X1069 control_logic_rw_0.dff_buf_array_0.dff_buf_0_1.dff_0.net1 control_logic_rw_0.dff_buf_array_0.dff_buf_0_1.dff_0.clkb csb0 din0[1] sky130_fd_pr__nfet_01v8 ad=0.2226 pd=1.48 as=0.1932 ps=1.76 w=0.42 l=0.15
X1070 bank_0.replica_bitcell_array_0.bitcell_array_0.cell_1rw_18.q bank_0.replica_bitcell_array_0.bitcell_array_0.cell_1rw_18.qb din0[1] din0[1] sky130_fd_pr__nfet_01v8 ad=0.3864 pd=2.1 as=0.441 ps=3.22 w=1.26 l=0.15
X1071 din0[1] bank_0.replica_bitcell_array_0.replica_column_0.replica_cell_1rw_6.q din0[1] din0[1] sky130_fd_pr__nfet_01v8 ad=0.3864 pd=2.1 as=0 ps=0 w=1.26 l=0.15
X1072 din0[1] bank_0.replica_bitcell_array_0.wl_0_1 bank_0.replica_bitcell_array_0.replica_column_0.replica_cell_1rw_14.q din0[1] sky130_fd_pr__nfet_01v8 ad=0.1428 pd=1.52 as=0.3864 ps=2.1 w=0.42 l=0.15
X1073 a_n4113_6649# control_logic_rw_0.delay_chain_0.pinv_11_24.Z a_n4166_6649# w_n5644_6180# sky130_fd_pr__pfet_01v8 ad=0.3276 pd=2.46 as=0.3192 ps=2.44 w=0.84 l=0.15
X1074 din0[1] bank_0.replica_bitcell_array_0.dummy_array_0_0.dummy_cell_1rw_0.q bank_0.replica_bitcell_array_0.dummy_array_0_0.dummy_cell_1rw_0.qb din0[1] sky130_fd_pr__nfet_01v8 ad=0.441 pd=3.22 as=0.3864 ps=2.1 w=1.26 l=0.15
X1075 a_n5369_4821# control_logic_rw_0.delay_chain_0.pinv_11_34.Z a_n5422_4821# w_n5644_4500# sky130_fd_pr__pfet_01v8 ad=0.3276 pd=2.46 as=0.3192 ps=2.44 w=0.84 l=0.15
X1076 a_n3369_n919# control_logic_rw_0.dff_buf_array_0.dout_bar_0 a_n3447_n919# din0[1] sky130_fd_pr__nfet_01v8 ad=0.2128 pd=1.88 as=0.1764 ps=1.19 w=0.56 l=0.15
X1077 a_5461_7397# bank_0.replica_bitcell_array_0.wl_0_7 bank_0.replica_bitcell_array_0.dummy_array_3_0.dummy_cell_1rw_9.q din0[1] sky130_fd_pr__nfet_01v8 ad=0.1428 pd=1.52 as=0.3864 ps=2.1 w=0.42 l=0.15
X1078 a_n3369_n513# control_logic_rw_0.dff_buf_array_0.dout_bar_0 a_n3447_n513# w_n4225_n767# sky130_fd_pr__pfet_01v8 ad=0.4256 pd=3 as=0.3528 ps=1.75 w=1.12 l=0.15
X1079 row_addr_dff_0.dff_1.net5 row_addr_dff_0.dff_3.clk row_addr_dff_0.dff_1.net4 din0[1] sky130_fd_pr__pfet_01v8 ad=0.4345 pd=2.68 as=0.2915 ps=1.61 w=0.55 l=0.15
X1080 a_3103_8451# din0[1] a_3049_8451# din0[1] sky130_fd_pr__nfet_01v8 ad=0.1596 pd=1.6 as=0.1638 ps=1.62 w=0.42 l=0.15
X1081 a_3424_7901# bank_0.port_address_0.wordline_driver_array_0.in_8 a_3370_7901# w_2422_7751# sky130_fd_pr__pfet_01v8 ad=0.1848 pd=1.28 as=0.3276 ps=2.46 w=0.84 l=0.15
X1082 bank_0.replica_bitcell_array_0.dummy_array_3_0.dummy_cell_1rw_16.q bank_0.replica_bitcell_array_0.dummy_array_3_0.dummy_cell_1rw_16.qb din0[1] din0[1] sky130_fd_pr__nfet_01v8 ad=0.3864 pd=2.1 as=0.441 ps=3.22 w=1.26 l=0.15
X1083 din0[1] bank_0.replica_bitcell_array_0.wl_0_7 bank_0.replica_bitcell_array_0.replica_column_0.replica_cell_1rw_8.q din0[1] sky130_fd_pr__nfet_01v8 ad=0.1428 pd=1.52 as=0.3864 ps=2.1 w=0.42 l=0.15
X1084 a_n1744_123# control_logic_rw_0.dff_buf_array_0.dout_bar_0 a_n1822_123# w_n2769_44# sky130_fd_pr__pfet_01v8 ad=0.3528 pd=1.75 as=0.3528 ps=1.75 w=1.12 l=0.15
X1085 a_n4113_9169# control_logic_rw_0.delay_chain_0.pinv_11_9.Z a_n4166_9169# din0[1] sky130_fd_pr__nfet_01v8 ad=0.1638 pd=1.62 as=0.1596 ps=1.6 w=0.42 l=0.15
X1086 din0[1] row_addr_dff_0.dout_2 row_addr_dff_0.dff_1.net5 din0[1] sky130_fd_pr__nfet_01v8 ad=0.168 pd=1.22 as=0.2352 ps=1.96 w=0.42 l=0.15
X1087 a_n1352_n513# control_logic_rw_0.dff_buf_array_0.dout_bar_0 a_n1430_n513# w_n2769_n767# sky130_fd_pr__pfet_01v8 ad=0.3528 pd=1.75 as=0.3528 ps=1.75 w=1.12 l=0.15
X1088 bank_0.replica_bitcell_array_0.dummy_array_3_0.dummy_cell_1rw_18.qb din0[1] a_5530_2493# din0[1] sky130_fd_pr__nfet_01v8 ad=0.3864 pd=2.1 as=0.1428 ps=1.52 w=0.42 l=0.15
X1089 bank_0.replica_bitcell_array_0.replica_column_0.replica_cell_1rw_15.q din0[1] din0[1] din0[1] sky130_fd_pr__nfet_01v8 ad=0.3864 pd=2.1 as=0.441 ps=3.22 w=1.26 l=0.15
X1090 bank_0.replica_bitcell_array_0.bitcell_array_0.cell_1rw_1.q bank_0.replica_bitcell_array_0.wl_0_14 din0[1] din0[1] sky130_fd_pr__nfet_01v8 ad=0.3864 pd=2.1 as=0.1428 ps=1.52 w=0.42 l=0.15
X1091 a_3483_8047# control_logic_rw_0.wl_en a_3424_8047# w_2422_7751# sky130_fd_pr__pfet_01v8 ad=0.3192 pd=2.44 as=0.1848 ps=1.28 w=0.84 l=0.15
X1092 bank_0.replica_bitcell_array_0.bitcell_array_0.cell_1rw_9.q bank_0.replica_bitcell_array_0.bitcell_array_0.cell_1rw_9.qb din0[1] din0[1] sky130_fd_pr__nfet_01v8 ad=0.3864 pd=2.1 as=0.441 ps=3.22 w=1.26 l=0.15
X1093 a_3103_5503# din0[1] a_3049_5503# din0[1] sky130_fd_pr__nfet_01v8 ad=0.1596 pd=1.6 as=0.1638 ps=1.62 w=0.42 l=0.15
X1094 bank_0.replica_bitcell_array_0.bitcell_array_0.cell_1rw_14.q bank_0.replica_bitcell_array_0.bitcell_array_0.cell_1rw_14.qb din0[1] din0[1] sky130_fd_pr__nfet_01v8 ad=0.3864 pd=2.1 as=0.441 ps=3.22 w=1.26 l=0.15
X1095 a_5053_1712# control_logic_rw_0.p_en_bar a_4999_1712# w_4605_1519# sky130_fd_pr__pfet_01v8 ad=0.3192 pd=2.44 as=0.3276 ps=2.46 w=0.84 l=0.15
X1096 a_3483_3829# control_logic_rw_0.wl_en a_3424_3829# w_2422_3679# sky130_fd_pr__pfet_01v8 ad=0.3192 pd=2.44 as=0.1848 ps=1.28 w=0.84 l=0.15
X1097 a_n2461_151# din0[1] a_n2515_151# w_n2769_44# sky130_fd_pr__pfet_01v8 ad=0.133 pd=1.35 as=0.3276 ps=2.46 w=0.84 l=0.15
X1098 a_3797_3361# din0[1] a_3743_3361# din0[1] sky130_fd_pr__nfet_01v8 ad=0.1596 pd=1.6 as=0.1638 ps=1.62 w=0.42 l=0.15
X1099 bank_0.replica_bitcell_array_0.replica_column_0.dummy_cell_1rw_1.qb din0[1] a_4750_2493# din0[1] sky130_fd_pr__nfet_01v8 ad=0.3864 pd=2.1 as=0.1428 ps=1.52 w=0.42 l=0.15
X1100 din0[1] din0[1] din0[1] din0[1] sky130_fd_pr__pfet_01v8 ad=0.2962 pd=1.75 as=0 ps=0 w=0.55 l=0.15
X1101 din0[1] bank_0.replica_bitcell_array_0.dummy_array_2_0.dummy_cell_1rw_3.q bank_0.replica_bitcell_array_0.dummy_array_2_0.dummy_cell_1rw_3.qb din0[1] sky130_fd_pr__nfet_01v8 ad=0.441 pd=3.22 as=0.3864 ps=2.1 w=1.26 l=0.15
X1102 a_n4427_7383# control_logic_rw_0.delay_chain_0.pinv_11_19.Z a_n4480_7383# din0[1] sky130_fd_pr__nfet_01v8 ad=0.1638 pd=1.62 as=0.1596 ps=1.6 w=0.42 l=0.15
X1103 a_n4427_6501# control_logic_rw_0.delay_chain_0.pinv_11_24.Z a_n4480_6501# w_n5644_6180# sky130_fd_pr__pfet_01v8 ad=0.3276 pd=2.46 as=0.3192 ps=2.44 w=0.84 l=0.15
X1104 bank_0.replica_bitcell_array_0.dummy_array_2_0.dummy_cell_1rw_10.q bank_0.replica_bitcell_array_0.dummy_array_2_0.dummy_cell_1rw_10.qb din0[1] din0[1] sky130_fd_pr__nfet_01v8 ad=0.3864 pd=2.1 as=0.441 ps=3.22 w=1.26 l=0.15
X1105 bank_0.replica_bitcell_array_0.dummy_array_2_0.dummy_cell_1rw_15.q bank_0.replica_bitcell_array_0.dummy_array_2_0.dummy_cell_1rw_15.qb din0[1] din0[1] sky130_fd_pr__nfet_01v8 ad=0.3864 pd=2.1 as=0.441 ps=3.22 w=1.26 l=0.15
X1106 a_3797_3975# din0[1] a_3743_3975# w_2422_3679# sky130_fd_pr__pfet_01v8 ad=0.3192 pd=2.44 as=0.3276 ps=2.46 w=0.84 l=0.15
X1107 a_n831_n919# control_logic_rw_0.pdriver_0_0.pinv_7_0.A a_n909_n919# din0[1] sky130_fd_pr__nfet_01v8 ad=0.1795 pd=1.2 as=0.1795 ps=1.2 w=0.57 l=0.15
X1108 din0[1] bank_0.replica_bitcell_array_0.dummy_array_1_0.dummy_cell_1rw_0.q bank_0.replica_bitcell_array_0.dummy_array_1_0.dummy_cell_1rw_0.qb din0[1] sky130_fd_pr__pfet_01v8 ad=0.1925 pd=1.8 as=0.1925 ps=1.8 w=0.55 l=0.15
X1109 control_logic_rw_0.dff_buf_array_0.dff_buf_0_1.pinv_0_0.A control_logic_rw_0.dff_buf_array_0.dff_buf_0_1.dff_0.net4 din0[1] din0[1] sky130_fd_pr__pfet_01v8 ad=0.22 pd=1.9 as=0.22 ps=1.35 w=0.55 l=0.15
X1110 a_1508_7901# row_addr_dff_0.dout_3 a_1449_7901# w_1141_7751# sky130_fd_pr__pfet_01v8 ad=0.3192 pd=2.44 as=0.1848 ps=1.28 w=0.84 l=0.15
X1111 bank_0.replica_bitcell_array_0.dummy_array_3_0.dummy_cell_1rw_12.qb bank_0.replica_bitcell_array_0.wl_0_4 a_5530_5547# din0[1] sky130_fd_pr__nfet_01v8 ad=0.3864 pd=2.1 as=0.1428 ps=1.52 w=0.42 l=0.15
X1112 a_3424_4993# bank_0.port_address_0.wordline_driver_array_0.in_3 a_3370_4993# w_2422_4697# sky130_fd_pr__pfet_01v8 ad=0.1848 pd=1.28 as=0.3276 ps=2.46 w=0.84 l=0.15
X1113 din0[1] bank_0.replica_bitcell_array_0.bitcell_array_0.cell_1rw_13.q bank_0.replica_bitcell_array_0.bitcell_array_0.cell_1rw_13.qb din0[1] sky130_fd_pr__nfet_01v8 ad=0.441 pd=3.22 as=0.3864 ps=2.1 w=1.26 l=0.15
X1114 row_addr_dff_0.dout_3 row_addr_dff_0.dff_0.net4 din0[1] din0[1] sky130_fd_pr__pfet_01v8 ad=0.22 pd=1.9 as=0.22 ps=1.35 w=0.55 l=0.15
X1115 din0[1] bank_0.replica_bitcell_array_0.dummy_array_3_0.dummy_cell_1rw_3.q bank_0.replica_bitcell_array_0.dummy_array_3_0.dummy_cell_1rw_3.qb din0[1] sky130_fd_pr__nfet_01v8 ad=0.441 pd=3.22 as=0.3864 ps=2.1 w=1.26 l=0.15
X1116 bank_0.port_address_0.hierarchical_decoder_0.and2_dec_12.pnand2_0.nmos_m1_w0_840_sactive_dli_0.S bank_0.port_address_0.hierarchical_decoder_0.predecode_3 a_2676_5355# din0[1] sky130_fd_pr__nfet_01v8 ad=0.1848 pd=1.28 as=0.3276 ps=2.46 w=0.84 l=0.15
X1117 a_n3917_n661# control_logic_rw_0.dff_buf_array_0.dff_buf_0_1.pinv_0_0.A a_n3971_n661# w_n4225_n767# sky130_fd_pr__pfet_01v8 ad=0.2646 pd=1.47 as=0.3276 ps=2.46 w=0.84 l=0.15
X1118 din0[1] din0[1] din0[1] din0[1] sky130_fd_pr__nfet_01v8 ad=0.21 pd=1.84 as=0 ps=0 w=0.42 l=0.15
X1119 a_3483_9575# control_logic_rw_0.wl_en bank_0.port_address_0.wordline_driver_array_0.wordline_driver_3.pnand2_0.nmos_m1_w0_840_sli_dactive_uq0 din0[1] sky130_fd_pr__nfet_01v8 ad=0.3192 pd=2.44 as=0.1848 ps=1.28 w=0.84 l=0.15
X1120 a_3483_6883# control_logic_rw_0.wl_en a_3424_6883# w_2422_6733# sky130_fd_pr__pfet_01v8 ad=0.3192 pd=2.44 as=0.1848 ps=1.28 w=0.84 l=0.15
X1121 control_logic_rw_0.dff_buf_array_0.dff_buf_0_0.dff_0.net2 din0[1] control_logic_rw_0.dff_buf_array_0.dff_buf_0_0.dff_0.net1 din0[1] sky130_fd_pr__nfet_01v8 ad=0.2856 pd=2.2 as=0.2226 ps=1.48 w=0.42 l=0.15
X1122 din0[1] bank_0.replica_bitcell_array_0.dummy_array_2_0.dummy_cell_1rw_18.q bank_0.replica_bitcell_array_0.dummy_array_2_0.dummy_cell_1rw_18.qb din0[1] sky130_fd_pr__pfet_01v8 ad=0.1925 pd=1.8 as=0.1925 ps=1.8 w=0.55 l=0.15
X1123 din0[1] bank_0.replica_bitcell_array_0.dummy_array_2_0.dummy_cell_1rw_14.q bank_0.replica_bitcell_array_0.dummy_array_2_0.dummy_cell_1rw_14.qb din0[1] sky130_fd_pr__nfet_01v8 ad=0.441 pd=3.22 as=0.3864 ps=2.1 w=1.26 l=0.15
X1124 din0[1] row_addr_dff_0.dff_1.net3 row_addr_dff_0.dff_1.net2 din0[1] sky130_fd_pr__pfet_01v8 ad=0.22 pd=1.35 as=0.2915 ps=2.16 w=0.55 l=0.15
X1125 bank_0.replica_bitcell_array_0.bitcell_array_0.cell_1rw_19.q bank_0.replica_bitcell_array_0.bitcell_array_0.cell_1rw_19.qb din0[1] din0[1] sky130_fd_pr__pfet_01v8 ad=0.1925 pd=1.8 as=0.1925 ps=1.8 w=0.55 l=0.15
X1126 din0[1] bank_0.replica_bitcell_array_0.wl_0_4 din0[1] din0[1] sky130_fd_pr__nfet_01v8 ad=0.3864 pd=2.1 as=0 ps=0 w=0.42 l=0.15
X1127 bank_0.replica_bitcell_array_0.bitcell_array_0.cell_1rw_5.qb bank_0.replica_bitcell_array_0.wl_0_10 din0[1] din0[1] sky130_fd_pr__nfet_01v8 ad=0.3864 pd=2.1 as=0.1428 ps=1.52 w=0.42 l=0.15
X1128 bank_0.replica_bitcell_array_0.dummy_array_0.dummy_cell_1rw_1.q bank_0.replica_bitcell_array_0.dummy_array_0.dummy_cell_1rw_1.qb din0[1] din0[1] sky130_fd_pr__pfet_01v8 ad=0.1925 pd=1.8 as=0.1925 ps=1.8 w=0.55 l=0.15
X1129 a_2730_10955# bank_0.port_address_0.hierarchical_decoder_0.predecode_2 a_2676_10955# w_2422_10805# sky130_fd_pr__pfet_01v8 ad=0.1848 pd=1.28 as=0.3276 ps=2.46 w=0.84 l=0.15
X1130 control_logic_rw_0.dff_buf_array_0.dff_buf_0_1.pinv_0_0.A control_logic_rw_0.dff_buf_array_0.dff_buf_0_1.dff_0.net4 din0[1] din0[1] sky130_fd_pr__nfet_01v8 ad=0.168 pd=1.64 as=0.168 ps=1.22 w=0.42 l=0.15
X1131 a_n3447_n227# control_logic_rw_0.dff_buf_array_0.dout_bar_0 a_n3525_n227# din0[1] sky130_fd_pr__nfet_01v8 ad=0.1764 pd=1.19 as=0.1764 ps=1.19 w=0.56 l=0.15
X1132 bank_0.replica_bitcell_array_0.replica_column_0.dummy_cell_1rw_0.qb din0[1] a_4750_11655# din0[1] sky130_fd_pr__nfet_01v8 ad=0.3864 pd=2.1 as=0.1428 ps=1.52 w=0.42 l=0.15
X1133 bank_0.replica_bitcell_array_0.dummy_array_2_0.dummy_cell_1rw_6.qb bank_0.replica_bitcell_array_0.wl_0_10 a_4490_8601# din0[1] sky130_fd_pr__nfet_01v8 ad=0.3864 pd=2.1 as=0.1428 ps=1.52 w=0.42 l=0.15
X1134 a_n4427_5809# control_logic_rw_0.delay_chain_0.pinv_11_24.Z a_n4480_5809# din0[1] sky130_fd_pr__nfet_01v8 ad=0.1638 pd=1.62 as=0.1596 ps=1.6 w=0.42 l=0.15
X1135 row_addr_dff_0.dff_1.net1 row_addr_dff_0.dff_3.clk addr0[2] din0[1] sky130_fd_pr__pfet_01v8 ad=0.2915 pd=1.61 as=0.253 ps=2.02 w=0.55 l=0.15
X1136 a_3797_8919# din0[1] a_3743_8919# w_2422_8769# sky130_fd_pr__pfet_01v8 ad=0.3192 pd=2.44 as=0.3276 ps=2.46 w=0.84 l=0.15
X1137 a_n1801_599# control_logic_rw_0.pdriver_1_0.pinv_8_0.Z a_n1855_599# din0[1] sky130_fd_pr__nfet_01v8 ad=0.1323 pd=1.05 as=0.1638 ps=1.62 w=0.42 l=0.15
X1138 a_3424_9937# bank_0.port_address_0.wordline_driver_array_0.in_12 a_3370_9937# w_2422_9787# sky130_fd_pr__pfet_01v8 ad=0.1848 pd=1.28 as=0.3276 ps=2.46 w=0.84 l=0.15
X1139 din0[1] bank_0.replica_bitcell_array_0.bitcell_array_0.cell_1rw_21.q bank_0.replica_bitcell_array_0.bitcell_array_0.cell_1rw_21.qb din0[1] sky130_fd_pr__pfet_01v8 ad=0.1925 pd=1.8 as=0.1925 ps=1.8 w=0.55 l=0.15
X1140 din0[1] bank_0.replica_bitcell_array_0.replica_column_0.dummy_cell_1rw_0.q bank_0.replica_bitcell_array_0.replica_column_0.dummy_cell_1rw_0.qb din0[1] sky130_fd_pr__nfet_01v8 ad=0.441 pd=3.22 as=0.3864 ps=2.1 w=1.26 l=0.15
X1141 bank_0.port_address_0.wordline_driver_array_0.wordline_driver_0.pnand2_0.nmos_m1_w0_840_sactive_dli_uq0 bank_0.port_address_0.wordline_driver_array_0.in_15 a_3370_11463# din0[1] sky130_fd_pr__nfet_01v8 ad=0.1848 pd=1.28 as=0.3276 ps=2.46 w=0.84 l=0.15
X1142 row_addr_dff_0.dff_3.net5 row_addr_dff_0.dff_3.clk row_addr_dff_0.dff_3.net4 din0[1] sky130_fd_pr__pfet_01v8 ad=0.4345 pd=2.68 as=0.2915 ps=1.61 w=0.55 l=0.15
X1143 row_addr_dff_0.dff_3.net3 row_addr_dff_0.dff_3.net1 din0[1] din0[1] sky130_fd_pr__nfet_01v8 ad=0.2604 pd=2.08 as=0.168 ps=1.22 w=0.42 l=0.15
X1144 a_1508_4993# row_addr_dff_0.dout_1 a_1449_4993# w_1141_4697# sky130_fd_pr__pfet_01v8 ad=0.3192 pd=2.44 as=0.1848 ps=1.28 w=0.84 l=0.15
X1145 din0[1] bank_0.replica_bitcell_array_0.bitcell_array_0.cell_1rw_22.q bank_0.replica_bitcell_array_0.bitcell_array_0.cell_1rw_22.qb din0[1] sky130_fd_pr__nfet_01v8 ad=0.441 pd=3.22 as=0.3864 ps=2.1 w=1.26 l=0.15
X1146 a_n1430_n227# control_logic_rw_0.dff_buf_array_0.dout_bar_0 a_n1508_n227# din0[1] sky130_fd_pr__nfet_01v8 ad=0.1764 pd=1.19 as=0.1764 ps=1.19 w=0.56 l=0.15
X1147 a_3103_10955# din0[1] a_3049_10955# w_2422_10805# sky130_fd_pr__pfet_01v8 ad=0.3192 pd=2.44 as=0.3276 ps=2.46 w=0.84 l=0.15
X1148 a_2789_6011# bank_0.port_address_0.hierarchical_decoder_0.predecode_5 a_2730_6011# w_2422_5715# sky130_fd_pr__pfet_01v8 ad=0.3192 pd=2.44 as=0.1848 ps=1.28 w=0.84 l=0.15
X1149 din0[1] bank_0.replica_bitcell_array_0.wl_0_5 bank_0.replica_bitcell_array_0.bitcell_array_0.cell_1rw_26.qb din0[1] sky130_fd_pr__nfet_01v8 ad=0.1428 pd=1.52 as=0.3864 ps=2.1 w=0.42 l=0.15
X1150 a_n2461_1775# control_logic_rw_0.delay_chain_0.out a_n2515_1775# w_n2769_1669# sky130_fd_pr__pfet_01v8 ad=0.3192 pd=2.44 as=0.3276 ps=2.46 w=0.84 l=0.15
X1151 bank_0.replica_bitcell_array_0.bitcell_array_0.cell_1rw_15.q bank_0.replica_bitcell_array_0.wl_0_0 din0[1] din0[1] sky130_fd_pr__nfet_01v8 ad=0.3864 pd=2.1 as=0.1428 ps=1.52 w=0.42 l=0.15
X1152 a_n3525_n689# control_logic_rw_0.dff_buf_array_0.dout_bar_0 a_n3579_n689# w_n4225_n767# sky130_fd_pr__pfet_01v8 ad=0.3528 pd=1.75 as=0.4368 ps=3.02 w=1.12 l=0.15
X1153 a_5372_1928# control_logic_rw_0.p_en_bar a_5313_1928# w_4605_1519# sky130_fd_pr__pfet_01v8 ad=0.3192 pd=2.44 as=0.1848 ps=1.28 w=0.84 l=0.15
X1154 a_5270_3325# bank_0.replica_bitcell_array_0.rbl_wl_0_0 bank_0.replica_bitcell_array_0.dummy_array_0.dummy_cell_1rw_0.qb din0[1] sky130_fd_pr__nfet_01v8 ad=0.1428 pd=1.52 as=0.3864 ps=2.1 w=0.42 l=0.15
X1155 a_2789_10083# bank_0.port_address_0.hierarchical_decoder_0.predecode_7 a_2730_10083# w_2422_9787# sky130_fd_pr__pfet_01v8 ad=0.3192 pd=2.44 as=0.1848 ps=1.28 w=0.84 l=0.15
X1156 a_3103_9065# din0[1] a_3049_9065# w_2422_8769# sky130_fd_pr__pfet_01v8 ad=0.3192 pd=2.44 as=0.3276 ps=2.46 w=0.84 l=0.15
X1157 a_3103_7539# din0[1] a_3049_7539# din0[1] sky130_fd_pr__nfet_01v8 ad=0.1596 pd=1.6 as=0.1638 ps=1.62 w=0.42 l=0.15
X1158 a_3483_3319# din0[1] bank_0.port_address_0.and2_dec_0_0.pnand2_0.nmos_m1_w0_840_sactive_dli_0.S din0[1] sky130_fd_pr__nfet_01v8 ad=0.3192 pd=2.44 as=0.1848 ps=1.28 w=0.84 l=0.15
X1159 bank_0.replica_bitcell_array_0.bitcell_array_0.cell_1rw_26.q bank_0.replica_bitcell_array_0.bitcell_array_0.cell_1rw_26.qb din0[1] din0[1] sky130_fd_pr__nfet_01v8 ad=0.3864 pd=2.1 as=0.441 ps=3.22 w=1.26 l=0.15
X1160 a_3103_4847# din0[1] a_3049_4847# w_2422_4697# sky130_fd_pr__pfet_01v8 ad=0.3192 pd=2.44 as=0.3276 ps=2.46 w=0.84 l=0.15
X1161 din0[1] din0[1] din0[1] din0[1] sky130_fd_pr__pfet_01v8 ad=0.275 pd=2.1 as=0 ps=0 w=0.55 l=0.15
X1162 a_4490_3325# bank_0.replica_bitcell_array_0.rbl_wl_0_0 bank_0.replica_bitcell_array_0.dummy_array_2_0.dummy_cell_1rw_17.qb din0[1] sky130_fd_pr__nfet_01v8 ad=0.1428 pd=1.52 as=0.3864 ps=2.1 w=0.42 l=0.15
X1163 bank_0.replica_bitcell_array_0.dummy_array_2_0.dummy_cell_1rw_16.q bank_0.replica_bitcell_array_0.wl_0_0 a_4421_3511# din0[1] sky130_fd_pr__nfet_01v8 ad=0.3864 pd=2.1 as=0.1428 ps=1.52 w=0.42 l=0.15
X1164 a_3797_5397# din0[1] a_3743_5397# din0[1] sky130_fd_pr__nfet_01v8 ad=0.1596 pd=1.6 as=0.1638 ps=1.62 w=0.42 l=0.15
X1165 a_n1841_927# control_logic_rw_0.dff_buf_array_0.dout_bar_0 a_n1919_927# w_n2769_857# sky130_fd_pr__pfet_01v8 ad=0.378 pd=1.83 as=0.378 ps=1.83 w=1.2 l=0.15
X1166 bank_0.replica_bitcell_array_0.bitcell_array_0.cell_1rw_21.q bank_0.replica_bitcell_array_0.wl_0_10 din0[1] din0[1] sky130_fd_pr__nfet_01v8 ad=0.3864 pd=2.1 as=0.1428 ps=1.52 w=0.42 l=0.15
X1167 a_n5369_4129# control_logic_rw_0.delay_chain_0.pinv_11_34.Z a_n5422_4129# din0[1] sky130_fd_pr__nfet_01v8 ad=0.1638 pd=1.62 as=0.1596 ps=1.6 w=0.42 l=0.15
X1168 bank_0.replica_bitcell_array_0.dummy_array_3_0.dummy_cell_1rw_16.q bank_0.replica_bitcell_array_0.dummy_array_3_0.dummy_cell_1rw_16.qb din0[1] din0[1] sky130_fd_pr__pfet_01v8 ad=0.1925 pd=1.8 as=0.1925 ps=1.8 w=0.55 l=0.15
X1169 row_addr_dff_0.dff_0.net3 row_addr_dff_0.dff_0.net1 din0[1] din0[1] sky130_fd_pr__nfet_01v8 ad=0.2604 pd=2.08 as=0.168 ps=1.22 w=0.42 l=0.15
X1170 din0[1] bank_0.replica_bitcell_array_0.bitcell_array_0.cell_1rw_6.q bank_0.replica_bitcell_array_0.bitcell_array_0.cell_1rw_6.qb din0[1] sky130_fd_pr__pfet_01v8 ad=0.1925 pd=1.8 as=0.1925 ps=1.8 w=0.55 l=0.15
X1171 din0[1] bank_0.replica_bitcell_array_0.bitcell_array_0.cell_1rw_13.q bank_0.replica_bitcell_array_0.bitcell_array_0.cell_1rw_13.qb din0[1] sky130_fd_pr__pfet_01v8 ad=0.1925 pd=1.8 as=0.1925 ps=1.8 w=0.55 l=0.15
X1172 din0[1] bank_0.replica_bitcell_array_0.replica_column_0.replica_cell_1rw_15.q din0[1] din0[1] sky130_fd_pr__nfet_01v8 ad=0.3864 pd=2.1 as=0 ps=0 w=1.26 l=0.15
X1173 din0[1] bank_0.replica_bitcell_array_0.bitcell_array_0.cell_1rw_9.q bank_0.replica_bitcell_array_0.bitcell_array_0.cell_1rw_9.qb din0[1] sky130_fd_pr__nfet_01v8 ad=0.441 pd=3.22 as=0.3864 ps=2.1 w=1.26 l=0.15
X1174 din0[1] bank_0.replica_bitcell_array_0.dummy_array_3_0.dummy_cell_1rw_13.q bank_0.replica_bitcell_array_0.dummy_array_3_0.dummy_cell_1rw_13.qb din0[1] sky130_fd_pr__pfet_01v8 ad=0.1925 pd=1.8 as=0.1925 ps=1.8 w=0.55 l=0.15
X1175 din0[1] bank_0.replica_bitcell_array_0.bitcell_array_0.cell_1rw_14.q bank_0.replica_bitcell_array_0.bitcell_array_0.cell_1rw_14.qb din0[1] sky130_fd_pr__nfet_01v8 ad=0.441 pd=3.22 as=0.3864 ps=2.1 w=1.26 l=0.15
X1176 bank_0.replica_bitcell_array_0.replica_column_0.replica_cell_1rw_15.q din0[1] din0[1] din0[1] sky130_fd_pr__pfet_01v8 ad=0.1925 pd=1.8 as=0.1925 ps=1.8 w=0.55 l=0.15
X1177 a_n1567_n681# control_logic_rw_0.pdriver_0_0.pinv_6_0.A a_n1645_n681# w_n2769_n767# sky130_fd_pr__pfet_01v8 ad=0.3307 pd=1.68 as=0.3307 ps=1.68 w=1.05 l=0.15
X1178 row_addr_dff_0.dout_1 row_addr_dff_0.dff_2.net4 din0[1] din0[1] sky130_fd_pr__pfet_01v8 ad=0.22 pd=1.9 as=0.22 ps=1.35 w=0.55 l=0.15
X1179 din0[1] bank_0.replica_bitcell_array_0.dummy_array_2_0.dummy_cell_1rw_7.q bank_0.replica_bitcell_array_0.dummy_array_2_0.dummy_cell_1rw_7.qb din0[1] sky130_fd_pr__pfet_01v8 ad=0.1925 pd=1.8 as=0.1925 ps=1.8 w=0.55 l=0.15
X1180 a_3483_6373# control_logic_rw_0.wl_en bank_0.port_address_0.wordline_driver_array_0.wordline_driver_10.pnand2_0.nmos_m1_w0_840_sli_dactiv_uq0 din0[1] sky130_fd_pr__nfet_01v8 ad=0.3192 pd=2.44 as=0.1848 ps=1.28 w=0.84 l=0.15
X1181 din0[1] bank_0.replica_bitcell_array_0.dummy_array_2_0.dummy_cell_1rw_14.q bank_0.replica_bitcell_array_0.dummy_array_2_0.dummy_cell_1rw_14.qb din0[1] sky130_fd_pr__pfet_01v8 ad=0.1925 pd=1.8 as=0.1925 ps=1.8 w=0.55 l=0.15
X1182 din0[1] bank_0.replica_bitcell_array_0.replica_column_0.replica_cell_1rw_12.q din0[1] din0[1] sky130_fd_pr__pfet_01v8 ad=0.1925 pd=1.8 as=0 ps=0 w=0.55 l=0.15
X1183 a_1822_3975# din0[1] a_1768_3975# w_1141_3679# sky130_fd_pr__pfet_01v8 ad=0.3192 pd=2.44 as=0.3276 ps=2.46 w=0.84 l=0.15
X1184 bank_0.port_address_0.wordline_driver_array_0.wordline_driver_15.pnand2_0.nmos_m1_w0_840_sli_dactiv_uq0 bank_0.port_address_0.wordline_driver_array_0.in_0 a_3370_3467# din0[1] sky130_fd_pr__nfet_01v8 ad=0.1848 pd=1.28 as=0.3276 ps=2.46 w=0.84 l=0.15
X1185 din0[1] bank_0.replica_bitcell_array_0.dummy_array_2_0.dummy_cell_1rw_10.q bank_0.replica_bitcell_array_0.dummy_array_2_0.dummy_cell_1rw_10.qb din0[1] sky130_fd_pr__nfet_01v8 ad=0.441 pd=3.22 as=0.3864 ps=2.1 w=1.26 l=0.15
X1186 din0[1] bank_0.replica_bitcell_array_0.dummy_array_2_0.dummy_cell_1rw_15.q bank_0.replica_bitcell_array_0.dummy_array_2_0.dummy_cell_1rw_15.qb din0[1] sky130_fd_pr__nfet_01v8 ad=0.441 pd=3.22 as=0.3864 ps=2.1 w=1.26 l=0.15
X1187 row_addr_dff_0.dff_0.clkb row_addr_dff_0.dff_3.clk din0[1] din0[1] sky130_fd_pr__pfet_01v8 ad=0.253 pd=2.02 as=0.253 ps=2.02 w=0.55 l=0.15
X1188 din0[1] row_addr_dff_0.dff_3.net3 row_addr_dff_0.dff_3.net2 din0[1] sky130_fd_pr__pfet_01v8 ad=0.22 pd=1.35 as=0.2915 ps=2.16 w=0.55 l=0.15
X1189 bank_0.port_address_0.hierarchical_decoder_0.and2_dec_2.pnand2_0.nmos_m1_w0_840_sactive_dli_0.S bank_0.port_address_0.hierarchical_decoder_0.predecode_1 a_2676_10445# din0[1] sky130_fd_pr__nfet_01v8 ad=0.1848 pd=1.28 as=0.3276 ps=2.46 w=0.84 l=0.15
X1190 a_n1997_1923# control_logic_rw_0.dff_buf_array_0.dout_1 a_n2051_1923# w_n2769_1669# sky130_fd_pr__pfet_01v8 ad=0.2646 pd=1.47 as=0.3276 ps=2.46 w=0.84 l=0.15
X1191 a_n4741_3141# control_logic_rw_0.delay_chain_0.pinv_11_44.Z a_n4794_3141# w_n5644_2820# sky130_fd_pr__pfet_01v8 ad=0.3276 pd=2.46 as=0.3192 ps=2.44 w=0.84 l=0.15
X1192 a_n1489_n919# control_logic_rw_0.pdriver_0_0.pinv_6_0.A a_n1567_n919# din0[1] sky130_fd_pr__nfet_01v8 ad=0.1976 pd=1.8 as=0.1638 ps=1.15 w=0.52 l=0.15
X1193 a_4941_3325# bank_0.replica_bitcell_array_0.rbl_wl_0_0 bank_0.replica_bitcell_array_0.dummy_array_0.dummy_cell_1rw_1.q din0[1] sky130_fd_pr__nfet_01v8 ad=0.1428 pd=1.52 as=0.3864 ps=2.1 w=0.42 l=0.15
X1194 din0[1] bank_0.replica_bitcell_array_0.wl_0_11 bank_0.replica_bitcell_array_0.bitcell_array_0.cell_1rw_4.q din0[1] sky130_fd_pr__nfet_01v8 ad=0.1428 pd=1.52 as=0.3864 ps=2.1 w=0.42 l=0.15
X1195 a_2730_7901# bank_0.port_address_0.hierarchical_decoder_0.predecode_0 a_2676_7901# w_2422_7751# sky130_fd_pr__pfet_01v8 ad=0.1848 pd=1.28 as=0.3276 ps=2.46 w=0.84 l=0.15
X1196 a_739_7433# row_addr_dff_0.dout_3 a_685_7433# din0[1] sky130_fd_pr__nfet_01v8 ad=0.1596 pd=1.6 as=0.1638 ps=1.62 w=0.42 l=0.15
X1197 bank_0.replica_bitcell_array_0.dummy_array_3_0.dummy_cell_1rw_11.q bank_0.replica_bitcell_array_0.dummy_array_3_0.dummy_cell_1rw_11.qb din0[1] din0[1] sky130_fd_pr__pfet_01v8 ad=0.1925 pd=1.8 as=0.1925 ps=1.8 w=0.55 l=0.15
X1198 din0[1] din0[1] din0[1] din0[1] sky130_fd_pr__nfet_01v8 ad=0.056 pd=0.77 as=0 ps=0 w=0.19 l=10m
X1199 a_n1377_589# control_logic_rw_0.pdriver_1_0.pinv_6_0.A a_n1431_589# din0[1] sky130_fd_pr__nfet_01v8 ad=0.1638 pd=1.15 as=0.2028 ps=1.82 w=0.52 l=0.15
X1200 a_n2343_1018# control_logic_rw_0.pand3_0.pnand3_0_0.nmos_m1_w0_840_sactive_dli_0.G a_n2402_963# w_n2769_857# sky130_fd_pr__pfet_01v8 ad=0.1102 pd=1.34 as=0.1848 ps=1.28 w=0.36 l=0.15
X1201 din0[1] din0[1] din0[1] din0[1] sky130_fd_pr__pfet_01v8 ad=0.2475 pd=2 as=0 ps=0 w=0.55 l=0.15
X1202 row_addr_dff_0.dff_3.net1 row_addr_dff_0.dff_3.clk addr0[0] din0[1] sky130_fd_pr__pfet_01v8 ad=0.2915 pd=1.61 as=0.253 ps=2.02 w=0.55 l=0.15
X1203 bank_0.replica_bitcell_array_0.bitcell_array_0.cell_1rw_3.q bank_0.replica_bitcell_array_0.bitcell_array_0.cell_1rw_3.qb din0[1] din0[1] sky130_fd_pr__pfet_01v8 ad=0.1925 pd=1.8 as=0.1925 ps=1.8 w=0.55 l=0.15
X1204 bank_0.port_address_0.wordline_driver_array_0.wordline_driver_4.pnand2_0.nmos_m1_w0_840_sli_dactive_uq0 bank_0.port_address_0.wordline_driver_array_0.in_11 a_3370_9427# din0[1] sky130_fd_pr__nfet_01v8 ad=0.1848 pd=1.28 as=0.3276 ps=2.46 w=0.84 l=0.15
X1205 a_4421_9433# bank_0.replica_bitcell_array_0.wl_0_11 bank_0.replica_bitcell_array_0.dummy_array_2_0.dummy_cell_1rw_5.q din0[1] sky130_fd_pr__nfet_01v8 ad=0.1428 pd=1.52 as=0.3864 ps=2.1 w=0.42 l=0.15
X1206 bank_0.replica_bitcell_array_0.replica_column_0.replica_cell_1rw_10.q din0[1] din0[1] din0[1] sky130_fd_pr__pfet_01v8 ad=0.1925 pd=1.8 as=0.1925 ps=1.8 w=0.55 l=0.15
X1207 bank_0.replica_bitcell_array_0.dummy_array_0.dummy_cell_1rw_0.q bank_0.replica_bitcell_array_0.dummy_array_0.dummy_cell_1rw_0.qb din0[1] din0[1] sky130_fd_pr__pfet_01v8 ad=0.1925 pd=1.8 as=0.1925 ps=1.8 w=0.55 l=0.15
X1208 a_n4741_9861# control_logic_rw_0.delay_chain_0.out a_n4794_9861# w_n5644_9540# sky130_fd_pr__pfet_01v8 ad=0.3276 pd=2.46 as=0.3192 ps=2.44 w=0.84 l=0.15
X1209 bank_0.replica_bitcell_array_0.dummy_array_2_0.dummy_cell_1rw_4.q bank_0.replica_bitcell_array_0.dummy_array_2_0.dummy_cell_1rw_4.qb din0[1] din0[1] sky130_fd_pr__pfet_01v8 ad=0.1925 pd=1.8 as=0.1925 ps=1.8 w=0.55 l=0.15
X1210 a_n1685_705# control_logic_rw_0.dff_buf_array_0.dout_bar_0 a_n1763_705# din0[1] sky130_fd_pr__nfet_01v8 ad=0.189 pd=1.23 as=0.189 ps=1.23 w=0.6 l=0.15
X1211 a_2789_8047# bank_0.port_address_0.hierarchical_decoder_0.predecode_6 a_2730_8047# w_2422_7751# sky130_fd_pr__pfet_01v8 ad=0.3192 pd=2.44 as=0.1848 ps=1.28 w=0.84 l=0.15
X1212 din0[1] bank_0.replica_bitcell_array_0.wl_0_3 bank_0.replica_bitcell_array_0.bitcell_array_0.cell_1rw_12.qb din0[1] sky130_fd_pr__nfet_01v8 ad=0.1428 pd=1.52 as=0.3864 ps=2.1 w=0.42 l=0.15
X1213 a_n1143_n691# control_logic_rw_0.pdriver_0_0.pinv_7_0.A a_n1197_n691# w_n2769_n767# sky130_fd_pr__pfet_01v8 ad=0.3622 pd=1.78 as=0.4485 ps=3.08 w=1.15 l=0.15
X1214 bank_0.replica_bitcell_array_0.dummy_array_3_0.dummy_cell_1rw_18.q din0[1] a_5461_2493# din0[1] sky130_fd_pr__nfet_01v8 ad=0.3864 pd=2.1 as=0.1428 ps=1.52 w=0.42 l=0.15
X1215 bank_0.replica_bitcell_array_0.dummy_array_2_0.dummy_cell_1rw_17.q bank_0.replica_bitcell_array_0.dummy_array_2_0.dummy_cell_1rw_17.qb din0[1] din0[1] sky130_fd_pr__pfet_01v8 ad=0.1925 pd=1.8 as=0.1925 ps=1.8 w=0.55 l=0.15
X1216 bank_0.replica_bitcell_array_0.replica_column_0.dummy_cell_1rw_0.q din0[1] a_4681_11655# din0[1] sky130_fd_pr__nfet_01v8 ad=0.3864 pd=2.1 as=0.1428 ps=1.52 w=0.42 l=0.15
X1217 a_2789_3829# bank_0.port_address_0.hierarchical_decoder_0.predecode_4 a_2730_3829# w_2422_3679# sky130_fd_pr__pfet_01v8 ad=0.3192 pd=2.44 as=0.1848 ps=1.28 w=0.84 l=0.15
X1218 a_1508_3467# bank_0.port_address_0.hierarchical_decoder_0.hierarchical_predecode2x4_1.pinv_0.Z bank_0.port_address_0.hierarchical_decoder_0.hierarchical_predecode2x4_1.and2_dec_3.pnand2_0.nmos_m_uq0 din0[1] sky130_fd_pr__nfet_01v8 ad=0.3192 pd=2.44 as=0.1848 ps=1.28 w=0.84 l=0.15
X1219 bank_0.port_data_0.sense_amp_array_0.sense_amp_1.net1 din0[1] din0[1] din0[1] sky130_fd_pr__nfet_01v8 ad=0.168 pd=1.64 as=0.189 ps=1.74 w=0.42 l=0.15
X1220 a_n4741_2449# control_logic_rw_0.delay_chain_0.pinv_11_44.Z a_n4794_2449# din0[1] sky130_fd_pr__nfet_01v8 ad=0.1638 pd=1.62 as=0.1596 ps=1.6 w=0.42 l=0.15
X1221 a_n4113_5703# control_logic_rw_0.delay_chain_0.pinv_11_34.Z a_n4166_5703# din0[1] sky130_fd_pr__nfet_01v8 ad=0.1638 pd=1.62 as=0.1596 ps=1.6 w=0.42 l=0.15
X1222 din0[1] din0[1] din0[1] din0[1] sky130_fd_pr__pfet_01v8 ad=0.0696 pd=0.9 as=0 ps=0 w=0.55 l=0.15
X1223 din0[1] din0[1] row_addr_dff_0.dff_3.net5 din0[1] sky130_fd_pr__nfet_01v8 ad=0.168 pd=1.22 as=0.2352 ps=1.96 w=0.42 l=0.15
X1224 bank_0.replica_bitcell_array_0.dummy_array_3_0.dummy_cell_1rw_12.q bank_0.replica_bitcell_array_0.dummy_array_3_0.dummy_cell_1rw_12.qb din0[1] din0[1] sky130_fd_pr__nfet_01v8 ad=0.3864 pd=2.1 as=0.441 ps=3.22 w=1.26 l=0.15
X1225 a_4490_5361# bank_0.replica_bitcell_array_0.wl_0_3 bank_0.replica_bitcell_array_0.dummy_array_2_0.dummy_cell_1rw_13.qb din0[1] sky130_fd_pr__nfet_01v8 ad=0.1428 pd=1.52 as=0.3864 ps=2.1 w=0.42 l=0.15
X1226 bank_0.replica_bitcell_array_0.replica_column_0.dummy_cell_1rw_1.q din0[1] a_4681_2493# din0[1] sky130_fd_pr__nfet_01v8 ad=0.3864 pd=2.1 as=0.1428 ps=1.52 w=0.42 l=0.15
X1227 a_n4113_3289# control_logic_rw_0.delay_chain_0.pinv_11_44.Z a_n4166_3289# w_n5644_2820# sky130_fd_pr__pfet_01v8 ad=0.3276 pd=2.46 as=0.3192 ps=2.44 w=0.84 l=0.15
X1228 bank_0.replica_bitcell_array_0.dummy_array_3_0.dummy_cell_1rw_17.q bank_0.replica_bitcell_array_0.dummy_array_3_0.dummy_cell_1rw_17.qb din0[1] din0[1] sky130_fd_pr__nfet_01v8 ad=0.3864 pd=2.1 as=0.441 ps=3.22 w=1.26 l=0.15
X1229 a_2730_4993# bank_0.port_address_0.hierarchical_decoder_0.predecode_3 a_2676_4993# w_2422_4697# sky130_fd_pr__pfet_01v8 ad=0.1848 pd=1.28 as=0.3276 ps=2.46 w=0.84 l=0.15
X1230 control_logic_rw_0.dff_buf_array_0.dff_buf_0_0.dff_0.clkb din0[1] din0[1] din0[1] sky130_fd_pr__pfet_01v8 ad=0.253 pd=2.02 as=0.253 ps=2.02 w=0.55 l=0.15
X1231 a_n1666_123# control_logic_rw_0.dff_buf_array_0.dout_bar_0 a_n1744_123# w_n2769_44# sky130_fd_pr__pfet_01v8 ad=0.3528 pd=1.75 as=0.3528 ps=1.75 w=1.12 l=0.15
X1232 a_n5369_8329# control_logic_rw_0.delay_chain_0.pinv_11_9.Z a_n5422_8329# w_n5644_7860# sky130_fd_pr__pfet_01v8 ad=0.3276 pd=2.46 as=0.3192 ps=2.44 w=0.84 l=0.15
X1233 a_n2461_n661# clk0 a_n2515_n661# w_n2769_n767# sky130_fd_pr__pfet_01v8 ad=0.3192 pd=2.44 as=0.3276 ps=2.46 w=0.84 l=0.15
X1234 row_addr_dff_0.dff_2.net3 row_addr_dff_0.dff_2.net1 din0[1] din0[1] sky130_fd_pr__nfet_01v8 ad=0.2604 pd=2.08 as=0.168 ps=1.22 w=0.42 l=0.15
X1235 a_2789_9575# bank_0.port_address_0.hierarchical_decoder_0.predecode_7 bank_0.port_address_0.hierarchical_decoder_0.and2_dec_3.pnand2_0.nmos_m1_w0_840_sactive_dli_0.S din0[1] sky130_fd_pr__nfet_01v8 ad=0.3192 pd=2.44 as=0.1848 ps=1.28 w=0.84 l=0.15
X1236 a_1449_8047# row_addr_dff_0.dout_2 a_1395_8047# w_1141_7751# sky130_fd_pr__pfet_01v8 ad=0.1848 pd=1.28 as=0.3276 ps=2.46 w=0.84 l=0.15
X1237 din0[1] bank_0.replica_bitcell_array_0.dummy_array_3_0.dummy_cell_1rw_9.q bank_0.replica_bitcell_array_0.dummy_array_3_0.dummy_cell_1rw_9.qb din0[1] sky130_fd_pr__pfet_01v8 ad=0.1925 pd=1.8 as=0.1925 ps=1.8 w=0.55 l=0.15
X1238 bank_0.replica_bitcell_array_0.replica_column_0.replica_cell_1rw_11.q din0[1] din0[1] din0[1] sky130_fd_pr__nfet_01v8 ad=0.3864 pd=2.1 as=0.441 ps=3.22 w=1.26 l=0.15
X1239 bank_0.replica_bitcell_array_0.dummy_array_3_0.dummy_cell_1rw_12.q bank_0.replica_bitcell_array_0.wl_0_4 a_5461_5547# din0[1] sky130_fd_pr__nfet_01v8 ad=0.3864 pd=2.1 as=0.1428 ps=1.52 w=0.42 l=0.15
X1240 a_1822_5397# din0[1] a_1768_5397# din0[1] sky130_fd_pr__nfet_01v8 ad=0.1596 pd=1.6 as=0.1638 ps=1.62 w=0.42 l=0.15
X1241 din0[1] din0[1] din0[1] din0[1] sky130_fd_pr__nfet_01v8 ad=0.189 pd=1.74 as=0 ps=0 w=0.42 l=0.15
X1242 bank_0.replica_bitcell_array_0.replica_column_0.replica_cell_1rw_16.q din0[1] din0[1] din0[1] sky130_fd_pr__nfet_01v8 ad=0.3864 pd=2.1 as=0.441 ps=3.22 w=1.26 l=0.15
X1243 a_2789_6883# bank_0.port_address_0.hierarchical_decoder_0.predecode_5 a_2730_6883# w_2422_6733# sky130_fd_pr__pfet_01v8 ad=0.3192 pd=2.44 as=0.1848 ps=1.28 w=0.84 l=0.15
X1244 bank_0.replica_bitcell_array_0.bitcell_array_0.cell_1rw_10.q bank_0.replica_bitcell_array_0.bitcell_array_0.cell_1rw_10.qb din0[1] din0[1] sky130_fd_pr__nfet_01v8 ad=0.3864 pd=2.1 as=0.441 ps=3.22 w=1.26 l=0.15
X1245 a_1449_3829# bank_0.port_address_0.hierarchical_decoder_0.hierarchical_predecode2x4_1.pinv_1.Z a_1395_3829# w_1141_3679# sky130_fd_pr__pfet_01v8 ad=0.1848 pd=1.28 as=0.3276 ps=2.46 w=0.84 l=0.15
X1246 row_addr_dff_0.dff_0.net4 row_addr_dff_0.dff_0.clkb row_addr_dff_0.dff_0.net3 din0[1] sky130_fd_pr__pfet_01v8 ad=0.2915 pd=1.61 as=0.352 ps=2.38 w=0.55 l=0.15
X1247 din0[1] bank_0.replica_bitcell_array_0.replica_column_0.replica_cell_1rw_8.q din0[1] din0[1] sky130_fd_pr__pfet_01v8 ad=0.1925 pd=1.8 as=0 ps=0 w=0.55 l=0.15
X1248 bank_0.replica_bitcell_array_0.replica_column_0.replica_cell_1rw_11.q bank_0.replica_bitcell_array_0.wl_0_4 din0[1] din0[1] sky130_fd_pr__nfet_01v8 ad=0.3864 pd=2.1 as=0.1428 ps=1.52 w=0.42 l=0.15
X1249 a_n519_n691# control_logic_rw_0.pdriver_0_0.pinv_7_0.A a_n597_n691# w_n2769_n767# sky130_fd_pr__pfet_01v8 ad=0.3622 pd=1.78 as=0.3622 ps=1.78 w=1.15 l=0.15
X1250 row_addr_dff_0.dff_2.clkb row_addr_dff_0.dff_3.clk din0[1] din0[1] sky130_fd_pr__pfet_01v8 ad=0.253 pd=2.02 as=0.253 ps=2.02 w=0.55 l=0.15
X1251 bank_0.replica_bitcell_array_0.dummy_array_2_0.dummy_cell_1rw_11.q bank_0.replica_bitcell_array_0.dummy_array_2_0.dummy_cell_1rw_11.qb din0[1] din0[1] sky130_fd_pr__nfet_01v8 ad=0.3864 pd=2.1 as=0.441 ps=3.22 w=1.26 l=0.15
X1252 a_5053_1928# control_logic_rw_0.p_en_bar a_4999_1928# w_4605_1519# sky130_fd_pr__pfet_01v8 ad=0.1848 pd=1.28 as=0.3276 ps=2.46 w=0.84 l=0.15
X1253 din0[1] bank_0.replica_bitcell_array_0.bitcell_array_0.cell_1rw_31.q bank_0.replica_bitcell_array_0.bitcell_array_0.cell_1rw_31.qb din0[1] sky130_fd_pr__nfet_01v8 ad=0.441 pd=3.22 as=0.3864 ps=2.1 w=1.26 l=0.15
X1254 din0[1] row_addr_dff_0.dout_3 row_addr_dff_0.dff_0.net5 din0[1] sky130_fd_pr__nfet_01v8 ad=0.168 pd=1.22 as=0.2352 ps=1.96 w=0.42 l=0.15
X1255 din0[1] bank_0.replica_bitcell_array_0.dummy_array_3_0.dummy_cell_1rw_10.q bank_0.replica_bitcell_array_0.dummy_array_3_0.dummy_cell_1rw_10.qb din0[1] sky130_fd_pr__pfet_01v8 ad=0.1925 pd=1.8 as=0.1925 ps=1.8 w=0.55 l=0.15
X1256 a_n5055_4023# control_logic_rw_0.delay_chain_0.pinv_11_39.Z a_n5108_4023# din0[1] sky130_fd_pr__nfet_01v8 ad=0.1638 pd=1.62 as=0.1596 ps=1.6 w=0.42 l=0.15
X1257 a_2730_9937# bank_0.port_address_0.hierarchical_decoder_0.predecode_0 a_2676_9937# w_2422_9787# sky130_fd_pr__pfet_01v8 ad=0.1848 pd=1.28 as=0.3276 ps=2.46 w=0.84 l=0.15
X1258 din0[1] bank_0.replica_bitcell_array_0.dummy_array_3_0.dummy_cell_1rw_6.q bank_0.replica_bitcell_array_0.dummy_array_3_0.dummy_cell_1rw_6.qb din0[1] sky130_fd_pr__nfet_01v8 ad=0.441 pd=3.22 as=0.3864 ps=2.1 w=1.26 l=0.15
X1259 a_1449_6883# bank_0.port_address_0.hierarchical_decoder_0.hierarchical_predecode2x4_0.pinv_1.Z a_1395_6883# w_1141_6733# sky130_fd_pr__pfet_01v8 ad=0.1848 pd=1.28 as=0.3276 ps=2.46 w=0.84 l=0.15
X1260 din0[1] bank_0.replica_bitcell_array_0.wl_0_3 bank_0.replica_bitcell_array_0.bitcell_array_0.cell_1rw_28.q din0[1] sky130_fd_pr__nfet_01v8 ad=0.1428 pd=1.52 as=0.3864 ps=2.1 w=0.42 l=0.15
X1261 a_n4427_3141# control_logic_rw_0.delay_chain_0.pinv_11_44.Z a_n4480_3141# w_n5644_2820# sky130_fd_pr__pfet_01v8 ad=0.3276 pd=2.46 as=0.3192 ps=2.44 w=0.84 l=0.15
X1262 din0[1] bank_0.replica_bitcell_array_0.replica_column_0.replica_cell_1rw_9.q din0[1] din0[1] sky130_fd_pr__pfet_01v8 ad=0.1925 pd=1.8 as=0 ps=0 w=0.55 l=0.15
X1263 a_3797_11505# din0[1] a_3743_11505# din0[1] sky130_fd_pr__nfet_01v8 ad=0.1596 pd=1.6 as=0.1638 ps=1.62 w=0.42 l=0.15
X1264 din0[1] control_logic_rw_0.dff_buf_array_0.dff_buf_0_0.pinv_0_0.A control_logic_rw_0.dff_buf_array_0.dff_buf_0_0.dff_0.net5 din0[1] sky130_fd_pr__pfet_01v8 ad=0.22 pd=1.35 as=0.308 ps=2.22 w=0.55 l=0.15
X1265 a_3483_2957# din0[1] a_3424_2957# w_3116_2703# sky130_fd_pr__pfet_01v8 ad=0.3192 pd=2.44 as=0.1848 ps=1.28 w=0.84 l=0.15
X1266 a_n1274_n513# control_logic_rw_0.dff_buf_array_0.dout_bar_0 a_n1352_n513# w_n2769_n767# sky130_fd_pr__pfet_01v8 ad=0.3528 pd=1.75 as=0.3528 ps=1.75 w=1.12 l=0.15
C0 bank_0.replica_bitcell_array_0.dummy_array_3_0.dummy_cell_1rw_2.qb bank_0.replica_bitcell_array_0.dummy_array_3_0.dummy_cell_1rw_2.q 0.28699f
C1 bank_0.replica_bitcell_array_0.dummy_array_0_0.dummy_cell_1rw_1.q bank_0.replica_bitcell_array_0.dummy_array_0_0.dummy_cell_1rw_0.qb 0.02064f
C2 row_addr_dff_0.dff_0.net3 row_addr_dff_0.dff_3.clk 0.09332f
C3 control_logic_rw_0.delay_chain_0.out control_logic_rw_0.delay_chain_0.pinv_11_3.Z 0.18584f
C4 bank_0.port_address_0.hierarchical_decoder_0.predecode_1 a_1822_3975# 0.01558f
C5 bank_0.replica_bitcell_array_0.wl_0_2 a_5530_4529# 0.04184f
C6 row_addr_dff_0.dff_0.clkb addr0[1] 0.01915f
C7 bank_0.replica_bitcell_array_0.dummy_array_2_0.dummy_cell_1rw_11.q a_4421_6379# 0.01645f
C8 bank_0.replica_bitcell_array_0.wl_0_4 a_5461_5547# 0.05176f
C9 a_n5108_4969# control_logic_rw_0.delay_chain_0.pinv_11_26.Z 0.0129f
C10 bank_0.port_address_0.hierarchical_decoder_0.predecode_0 bank_0.port_address_0.hierarchical_decoder_0.predecode_7 0.50304f
C11 control_logic_rw_0.pinv_3_1.gnd a_n1588_n107# 0.01066f
C12 bank_0.port_address_0.wordline_driver_array_0.in_5 bank_0.port_address_0.wordline_driver_array_0.in_6 0.01362f
C13 row_addr_dff_0.dff_0.clkb row_addr_dff_0.dff_0.net2 0.07662f
C14 row_addr_dff_0.dff_3.net3 row_addr_dff_0.dff_3.clkb 0.14179f
C15 addr0[1] row_addr_dff_0.dff_1.net1 0.01887f
C16 bank_0.replica_bitcell_array_0.dummy_array_3_0.dummy_cell_1rw_17.q bank_0.replica_bitcell_array_0.dummy_array_0.dummy_cell_1rw_0.qb 0.01651f
C17 bank_0.replica_bitcell_array_0.dummy_array_3_0.dummy_cell_1rw_0.qb bank_0.replica_bitcell_array_0.dummy_array_3_0.dummy_cell_1rw_0.q 0.28699f
C18 bank_0.port_address_0.wordline_driver_array_0.in_7 bank_0.port_address_0.wordline_driver_array_0.in_6 0.01302f
C19 control_logic_rw_0.dff_buf_array_0.dff_buf_0_0.dff_0.net3 control_logic_rw_0.dff_buf_array_0.dff_buf_0_0.dff_0.net2 0.03271f
C20 row_addr_dff_0.dff_3.net4 row_addr_dff_0.dff_3.clkb 0.08731f
C21 a_1822_4993# bank_0.port_address_0.hierarchical_decoder_0.predecode_3 0.01558f
C22 bank_0.port_address_0.hierarchical_decoder_0.predecode_3 w_1141_4697# 0.24572f
C23 a_4421_11469# a_4490_11469# 0.06598f
C24 control_logic_rw_0.pdriver_0_0.pinv_7_0.A control_logic_rw_0.pdriver_0_0.pinv_6_0.A 0.21971f
C25 row_addr_dff_0.dff_0.clkb row_addr_dff_0.dff_3.clk 0.83283f
C26 bank_0.replica_bitcell_array_0.wl_0_0 bank_0.replica_bitcell_array_0.rbl_wl_0_0 0.13236f
C27 a_4681_2493# bank_0.replica_bitcell_array_0.replica_column_0.dummy_cell_1rw_1.q 0.01645f
C28 control_logic_rw_0.pinv_3_1.gnd a_n2056_n107# 0.01089f
C29 bank_0.replica_bitcell_array_0.dummy_array_2_0.dummy_cell_1rw_3.qb a_4490_10451# 0.0163f
C30 control_logic_rw_0.p_en_bar w_4605_1519# 0.37311f
C31 a_5530_10451# a_5461_10451# 0.06598f
C32 bank_0.replica_bitcell_array_0.bitcell_array_0.cell_1rw_12.qb bank_0.replica_bitcell_array_0.wl_0_3 0.03696f
C33 bank_0.replica_bitcell_array_0.bitcell_array_0.cell_1rw_27.q bank_0.replica_bitcell_array_0.wl_0_4 0.04155f
C34 bank_0.replica_bitcell_array_0.dummy_array_2_0.dummy_cell_1rw_5.qb bank_0.replica_bitcell_array_0.dummy_array_2_0.dummy_cell_1rw_5.q 0.28699f
C35 control_logic_rw_0.dff_buf_array_0.dff_buf_0_1.dff_0.clkb control_logic_rw_0.dff_buf_array_0.dff_buf_0_1.dff_0.net5 0.03696f
C36 w_n2769_44# control_logic_rw_0.pdriver_1_0.pinv_8_0.Z 0.18899f
C37 control_logic_rw_0.delay_chain_0.pinv_11_23.Z w_n5644_6180# 0.20256f
C38 w_n2769_n767# control_logic_rw_0.pinv_3_1.gnd 0.04713f
C39 row_addr_dff_0.dff_1.clkb row_addr_dff_0.dff_1.net2 0.07662f
C40 bank_0.replica_bitcell_array_0.dummy_array_3_0.dummy_cell_1rw_9.qb a_5530_7397# 0.0163f
C41 bank_0.replica_bitcell_array_0.dummy_array_2_0.dummy_cell_1rw_15.q bank_0.replica_bitcell_array_0.dummy_array_2_0.dummy_cell_1rw_15.qb 0.28699f
C42 control_logic_rw_0.dff_buf_array_0.dff_buf_0_1.dff_0.net3 control_logic_rw_0.dff_buf_array_0.dff_buf_0_1.dff_0.net2 0.03271f
C43 bank_0.replica_bitcell_array_0.dummy_array_3_0.dummy_cell_1rw_14.qb bank_0.replica_bitcell_array_0.dummy_array_3_0.dummy_cell_1rw_14.q 0.28699f
C44 a_5530_2493# bank_0.replica_bitcell_array_0.dummy_array_3_0.dummy_cell_1rw_18.qb 0.0163f
C45 control_logic_rw_0.delay_chain_0.pinv_11_25.Z a_n5422_4969# 0.0129f
C46 row_addr_dff_0.dff_1.net1 row_addr_dff_0.dff_3.clk 0.31285f
C47 control_logic_rw_0.delay_chain_0.out control_logic_rw_0.dff_buf_array_0.dout_1 0.19915f
C48 bank_0.replica_bitcell_array_0.wl_0_0 w_2422_3679# 0.16398f
C49 bank_0.replica_bitcell_array_0.wl_0_12 bank_0.replica_bitcell_array_0.dummy_array_3_0.dummy_cell_1rw_4.qb 0.03696f
C50 row_addr_dff_0.dout_1 bank_0.port_address_0.hierarchical_decoder_0.hierarchical_predecode2x4_1.pinv_1.Z 0.55118f
C51 bank_0.replica_bitcell_array_0.dummy_array_3_0.dummy_cell_1rw_12.qb bank_0.replica_bitcell_array_0.wl_0_4 0.03696f
C52 data_dff_0.dff_0.net3 data_dff_0.dff_0.net4 0.04611f
C53 a_5270_11655# a_5201_11655# 0.06598f
C54 w_2422_6733# bank_0.port_address_0.hierarchical_decoder_0.predecode_2 0.02155f
C55 bank_0.replica_bitcell_array_0.wl_0_12 a_4421_9619# 0.05228f
C56 a_n2088_n513# control_logic_rw_0.dff_buf_array_0.dout_bar_0 0.01494f
C57 bank_0.port_address_0.hierarchical_decoder_0.predecode_7 w_2422_7751# 0.20528f
C58 w_1141_6733# row_addr_dff_0.dout_3 0.12164f
C59 a_n1118_n513# control_logic_rw_0.dff_buf_array_0.dout_bar_0 0.03322f
C60 row_addr_dff_0.dout_1 row_addr_dff_0.dout_3 0.03236f
C61 bank_0.port_address_0.wordline_driver_array_0.in_9 bank_0.port_address_0.wordline_driver_array_0.in_8 0.01302f
C62 a_n3525_n689# control_logic_rw_0.dff_buf_array_0.dff_buf_0_1.pinv_1_0.vdd 0.02305f
C63 bank_0.replica_bitcell_array_0.wl_0_8 a_5461_7583# 0.05176f
C64 bank_0.replica_bitcell_array_0.bitcell_array_0.cell_1rw_25.q bank_0.replica_bitcell_array_0.wl_0_6 0.04155f
C65 a_n3917_n513# control_logic_rw_0.dff_buf_array_0.dout_bar_0 0.02331f
C66 a_n2515_n107# control_logic_rw_0.pinv_3_1.gnd 0.01544f
C67 w_n5644_2820# control_logic_rw_0.delay_chain_0.pinv_11_44.Z 1.16277f
C68 bank_0.replica_bitcell_array_0.bitcell_array_0.cell_1rw_30.q bank_0.replica_bitcell_array_0.bitcell_array_0.cell_1rw_14.qb 0.02064f
C69 bank_0.port_address_0.wordline_driver_array_0.in_15 a_3103_11101# 0.01304f
C70 bank_0.replica_bitcell_array_0.dummy_array_2_0.dummy_cell_1rw_3.qb bank_0.replica_bitcell_array_0.wl_0_13 0.03923f
C71 a_n3579_n919# control_logic_rw_0.dff_buf_array_0.dff_buf_0_1.pinv_1_0.gnd 0.01131f
C72 bank_0.port_address_0.wordline_driver_array_0.in_4 control_logic_rw_0.wl_en 0.18688f
C73 a_n2147_n919# control_logic_rw_0.pdriver_0_0.pinv_6_0.A 0.01144f
C74 bank_0.port_address_0.hierarchical_decoder_0.predecode_6 bank_0.port_address_0.hierarchical_decoder_0.predecode_1 0.43402f
C75 control_logic_rw_0.delay_chain_0.pinv_11_20.Z control_logic_rw_0.delay_chain_0.pinv_11_21.Z 0.04321f
C76 row_addr_dff_0.dff_2.net1 row_addr_dff_0.dff_2.clkb 0.1543f
C77 control_logic_rw_0.delay_chain_0.pinv_11_34.Z control_logic_rw_0.delay_chain_0.pinv_11_30.Z 0.11884f
C78 bank_0.replica_bitcell_array_0.dummy_array_2_0.dummy_cell_1rw_8.qb bank_0.replica_bitcell_array_0.wl_0_8 0.03924f
C79 control_logic_rw_0.delay_chain_0.out a_n1685_927# 0.02356f
C80 bank_0.replica_bitcell_array_0.wl_0_9 bank_0.replica_bitcell_array_0.dummy_array_3_0.dummy_cell_1rw_7.q 0.04136f
C81 control_logic_rw_0.delay_chain_0.pinv_11_32.Z control_logic_rw_0.delay_chain_0.pinv_11_33.Z 0.04321f
C82 control_logic_rw_0.pinv_3_1.gnd a_n1742_n227# 0.01089f
C83 bank_0.replica_bitcell_array_0.dummy_array_3_0.dummy_cell_1rw_14.qb a_5530_4529# 0.0163f
C84 w_2422_9787# bank_0.port_address_0.hierarchical_decoder_0.predecode_7 0.44085f
C85 row_addr_dff_0.dff_1.net3 row_addr_dff_0.dff_3.clk 0.09335f
C86 control_logic_rw_0.delay_chain_0.pinv_11_20.Z a_n5422_6501# 0.0129f
C87 w_2422_9787# bank_0.port_address_0.wordline_driver_array_0.in_13 0.14946f
C88 w_1141_4697# bank_0.port_address_0.hierarchical_decoder_0.predecode_4 0.0127f
C89 a_n1352_n227# control_logic_rw_0.dff_buf_array_0.dout_bar_0 0.01112f
C90 w_2422_3679# bank_0.port_address_0.hierarchical_decoder_0.predecode_6 0.02963f
C91 bank_0.port_address_0.hierarchical_decoder_0.predecode_0 w_1141_7751# 0.16776f
C92 bank_0.replica_bitcell_array_0.dummy_array_3_0.dummy_cell_1rw_5.q bank_0.replica_bitcell_array_0.wl_0_11 0.04136f
C93 control_logic_rw_0.dff_buf_array_0.dff_buf_0_1.pinv_1_0.gnd control_logic_rw_0.dff_buf_array_0.dout_0 0.2285f
C94 control_logic_rw_0.pand2_0.Z a_n1510_123# 0.02276f
C95 control_logic_rw_0.dff_buf_array_0.dff_buf_0_0.dff_0.net3 control_logic_rw_0.dff_buf_array_0.dff_buf_0_0.dff_0.net1 0.14299f
C96 a_n3447_n689# control_logic_rw_0.dff_buf_array_0.dff_buf_0_1.pinv_1_0.vdd 0.02745f
C97 bank_0.replica_bitcell_array_0.wl_0_12 bank_0.replica_bitcell_array_0.wl_0_11 0.13236f
C98 a_1822_6883# bank_0.port_address_0.hierarchical_decoder_0.predecode_4 0.01431f
C99 bank_0.replica_bitcell_array_0.bitcell_array_0.cell_1rw_10.q bank_0.replica_bitcell_array_0.wl_0_5 0.04136f
C100 bank_0.replica_bitcell_array_0.dummy_array_1_0.dummy_cell_1rw_0.qb bank_0.replica_bitcell_array_0.dummy_array_3_0.dummy_cell_1rw_18.q 0.01651f
C101 a_n2515_151# control_logic_rw_0.dff_buf_array_0.dout_bar_0 0.02124f
C102 w_2422_5715# bank_0.replica_bitcell_array_0.wl_0_4 0.16398f
C103 bank_0.replica_bitcell_array_0.bitcell_array_0.cell_1rw_2.qb bank_0.replica_bitcell_array_0.wl_0_13 0.03696f
C104 bank_0.port_address_0.hierarchical_decoder_0.predecode_6 w_2422_8769# 0.34424f
C105 bank_0.replica_bitcell_array_0.wl_0_6 bank_0.replica_bitcell_array_0.replica_column_0.replica_cell_1rw_9.q 0.04211f
C106 bank_0.replica_bitcell_array_0.wl_0_1 bank_0.replica_bitcell_array_0.replica_column_0.replica_cell_1rw_14.q 0.04211f
C107 row_addr_dff_0.dff_2.net3 row_addr_dff_0.dff_2.clkb 0.14179f
C108 control_logic_rw_0.pdriver_1_0.pinv_6_0.A control_logic_rw_0.pdriver_1_0.gnd 0.16959f
C109 bank_0.replica_bitcell_array_0.replica_column_0.replica_cell_1rw_12.q bank_0.replica_bitcell_array_0.bitcell_array_0.cell_1rw_28.qb 0.02064f
C110 control_logic_rw_0.pand2_0.Z a_n1822_n107# 0.01255f
C111 bank_0.replica_bitcell_array_0.bitcell_array_0.cell_1rw_3.qb bank_0.replica_bitcell_array_0.bitcell_array_0.cell_1rw_19.q 0.02064f
C112 bank_0.replica_bitcell_array_0.replica_column_0.replica_cell_1rw_1.q bank_0.replica_bitcell_array_0.wl_0_14 0.04211f
C113 bank_0.replica_bitcell_array_0.bitcell_array_0.cell_1rw_3.q bank_0.replica_bitcell_array_0.bitcell_array_0.cell_1rw_19.qb 0.01651f
C114 bank_0.replica_bitcell_array_0.dummy_array_3_0.dummy_cell_1rw_6.q bank_0.replica_bitcell_array_0.bitcell_array_0.cell_1rw_5.qb 0.01651f
C115 bank_0.replica_bitcell_array_0.dummy_array_3_0.dummy_cell_1rw_6.qb bank_0.replica_bitcell_array_0.bitcell_array_0.cell_1rw_5.q 0.02064f
C116 control_logic_rw_0.delay_chain_0.out control_logic_rw_0.delay_chain_0.pinv_11_34.Z 0.10996f
C117 bank_0.port_address_0.hierarchical_decoder_0.predecode_5 bank_0.port_address_0.hierarchical_decoder_0.predecode_3 0.42912f
C118 bank_0.replica_bitcell_array_0.bitcell_array_0.cell_1rw_10.qb bank_0.replica_bitcell_array_0.bitcell_array_0.cell_1rw_10.q 0.28699f
C119 bank_0.replica_bitcell_array_0.wl_0_7 bank_0.replica_bitcell_array_0.bitcell_array_0.cell_1rw_24.qb 0.03704f
C120 row_addr_dff_0.dff_2.net2 row_addr_dff_0.dff_2.net1 0.12728f
C121 bank_0.replica_bitcell_array_0.bitcell_array_0.cell_1rw_20.qb bank_0.replica_bitcell_array_0.wl_0_11 0.03704f
C122 row_addr_dff_0.dff_3.net4 row_addr_dff_0.dff_3.net5 0.13677f
C123 control_logic_rw_0.delay_chain_0.pinv_11_30.Z control_logic_rw_0.delay_chain_0.pinv_11_31.Z 0.04321f
C124 a_n3447_n227# control_logic_rw_0.dff_buf_array_0.dff_buf_0_0.pinv_1_0.gnd 0.01798f
C125 a_n1196_n227# control_logic_rw_0.dff_buf_array_0.dout_bar_0 0.01136f
C126 a_4490_10637# bank_0.replica_bitcell_array_0.dummy_array_2_0.dummy_cell_1rw_2.qb 0.0163f
C127 control_logic_rw_0.dff_buf_array_0.dff_buf_0_1.pinv_0_0.A control_logic_rw_0.dff_buf_array_0.dff_buf_0_1.pinv_1_0.vdd 0.05616f
C128 control_logic_rw_0.delay_chain_0.pinv_11_35.Z control_logic_rw_0.delay_chain_0.pinv_11_36.Z 0.04321f
C129 a_n3839_n513# control_logic_rw_0.dff_buf_array_0.dff_buf_0_1.pinv_1_0.vdd 0.01602f
C130 control_logic_rw_0.delay_chain_0.pinv_11_10.Z control_logic_rw_0.delay_chain_0.pinv_11_11.Z 0.04321f
C131 bank_0.port_address_0.hierarchical_decoder_0.hierarchical_predecode2x4_0.pinv_0.Z row_addr_dff_0.dout_3 0.21555f
C132 bank_0.replica_bitcell_array_0.wl_0_8 bank_0.replica_bitcell_array_0.bitcell_array_0.cell_1rw_7.qb 0.03696f
C133 control_logic_rw_0.dff_buf_array_0.dout_1 control_logic_rw_0.pand3_0.B 0.1375f
C134 a_3797_9065# bank_0.replica_bitcell_array_0.wl_0_11 0.01304f
C135 control_logic_rw_0.dff_buf_array_0.dout_bar_0 a_n2402_963# 0.01452f
C136 control_logic_rw_0.pdriver_0_0.pinv_7_0.A control_logic_rw_0.dff_buf_array_0.dout_bar_0 0.39832f
C137 a_n1586_n227# control_logic_rw_0.dff_buf_array_0.dout_bar_0 0.02034f
C138 a_n4480_3141# control_logic_rw_0.delay_chain_0.pinv_11_43.Z 0.0129f
C139 row_addr_dff_0.dff_2.clkb addr0[1] 0.35334f
C140 bank_0.replica_bitcell_array_0.dummy_array_2_0.dummy_cell_1rw_6.qb bank_0.replica_bitcell_array_0.replica_column_0.replica_cell_1rw_5.q 0.01651f
C141 a_5461_6379# a_5530_6379# 0.06598f
C142 a_4490_6379# bank_0.replica_bitcell_array_0.dummy_array_2_0.dummy_cell_1rw_11.qb 0.0163f
C143 a_4421_5361# bank_0.replica_bitcell_array_0.dummy_array_2_0.dummy_cell_1rw_13.q 0.01645f
C144 control_logic_rw_0.delay_chain_0.pinv_11_1.Z control_logic_rw_0.delay_chain_0.pinv_11_2.Z 0.04321f
C145 a_n1377_298# control_logic_rw_0.dff_buf_array_0.dout_bar_0 0.02171f
C146 row_addr_dff_0.dff_2.net2 row_addr_dff_0.dff_2.net3 0.03271f
C147 w_n2769_44# control_logic_rw_0.dff_buf_array_0.dout_bar_0 1.71405f
C148 bank_0.replica_bitcell_array_0.rbl_wl_0_0 bank_0.replica_bitcell_array_0.replica_column_0.replica_cell_1rw_16.q 0.04211f
C149 bank_0.port_address_0.hierarchical_decoder_0.predecode_4 control_logic_rw_0.wl_en 0.01162f
C150 row_addr_dff_0.dout_1 row_addr_dff_0.dff_3.clk 0.02092f
C151 bank_0.port_address_0.wordline_driver_array_0.in_2 control_logic_rw_0.wl_en 0.18688f
C152 w_n2769_1669# control_logic_rw_0.pinv_3_0.vdd 0.6523f
C153 control_logic_rw_0.delay_chain_0.pinv_11_11.Z a_n5108_8181# 0.0129f
C154 bank_0.replica_bitcell_array_0.wl_0_1 a_4421_4343# 0.05228f
C155 bank_0.replica_bitcell_array_0.bitcell_array_0.cell_1rw_19.qb bank_0.replica_bitcell_array_0.replica_column_0.replica_cell_1rw_3.q 0.02064f
C156 control_logic_rw_0.delay_chain_0.pinv_11_11.Z control_logic_rw_0.delay_chain_0.pinv_11_12.Z 0.04321f
C157 row_addr_dff_0.dout_1 row_addr_dff_0.dff_2.net4 0.22508f
C158 a_n2515_2181# control_logic_rw_0.pand3_0_0.gnd 0.01544f
C159 a_n1221_298# control_logic_rw_0.wl_en 0.02963f
C160 data_dff_0.dff_1.clkb data_dff_0.dff_1.net1 0.1543f
C161 bank_0.replica_bitcell_array_0.replica_column_0.replica_cell_1rw_0.q bank_0.replica_bitcell_array_0.bitcell_array_0.cell_1rw_16.qb 0.02064f
C162 control_logic_rw_0.pand2_0.Z a_n2056_123# 0.03013f
C163 row_addr_dff_0.dout_1 w_1141_4697# 0.42366f
C164 bank_0.replica_bitcell_array_0.wl_0_9 bank_0.replica_bitcell_array_0.wl_0_8 0.03867f
C165 row_addr_dff_0.dff_1.net5 row_addr_dff_0.dff_1.net4 0.13677f
C166 a_n4794_3289# control_logic_rw_0.delay_chain_0.pinv_11_37.Z 0.0129f
C167 a_n1742_n513# control_logic_rw_0.dff_buf_array_0.dout_bar_0 0.0591f
C168 a_n1801_299# control_logic_rw_0.dff_buf_array_0.dout_bar_0 0.01772f
C169 bank_0.port_address_0.hierarchical_decoder_0.predecode_5 bank_0.port_address_0.hierarchical_decoder_0.predecode_4 5.22918f
C170 a_4421_3325# bank_0.replica_bitcell_array_0.dummy_array_2_0.dummy_cell_1rw_17.q 0.01645f
C171 a_5010_2493# a_4941_2493# 0.06598f
C172 bank_0.replica_bitcell_array_0.bitcell_array_0.cell_1rw_7.qb bank_0.replica_bitcell_array_0.bitcell_array_0.cell_1rw_7.q 0.28699f
C173 bank_0.replica_bitcell_array_0.wl_0_8 bank_0.replica_bitcell_array_0.bitcell_array_0.cell_1rw_23.qb 0.03704f
C174 row_addr_dff_0.dff_2.clkb row_addr_dff_0.dff_3.clk 0.83355f
C175 control_logic_rw_0.delay_chain_0.pinv_11_24.Z control_logic_rw_0.delay_chain_0.pinv_11_22.Z 0.14367f
C176 control_logic_rw_0.delay_chain_0.out w_n5644_2820# 0.33207f
C177 a_4490_11655# a_4421_11655# 0.06598f
C178 a_n1777_n681# control_logic_rw_0.dff_buf_array_0.dout_bar_0 0.01845f
C179 bank_0.port_address_0.hierarchical_decoder_0.predecode_2 w_1141_4697# 0.17575f
C180 row_addr_dff_0.dff_2.clkb row_addr_dff_0.dff_2.net4 0.08731f
C181 row_addr_dff_0.dff_1.clkb row_addr_dff_0.dff_1.net5 0.03696f
C182 control_logic_rw_0.pand3_0.B a_n2461_1775# 0.01615f
C183 bank_0.replica_bitcell_array_0.dummy_array_0_0.dummy_cell_1rw_1.q bank_0.replica_bitcell_array_0.replica_column_0.dummy_cell_1rw_0.qb 0.01651f
C184 a_5270_3325# bank_0.replica_bitcell_array_0.rbl_wl_0_0 0.04284f
C185 control_logic_rw_0.dff_buf_array_0.dff_buf_0_0.dff_0.clkb control_logic_rw_0.dff_buf_array_0.dff_buf_0_0.dff_0.net5 0.03696f
C186 row_addr_dff_0.dff_2.net5 row_addr_dff_0.dff_3.clk 0.03761f
C187 w_2422_4697# bank_0.port_address_0.hierarchical_decoder_0.predecode_7 0.14845f
C188 bank_0.replica_bitcell_array_0.dummy_array_0_0.dummy_cell_1rw_1.q bank_0.replica_bitcell_array_0.dummy_array_0_0.dummy_cell_1rw_1.qb 0.28699f
C189 a_4421_5361# bank_0.replica_bitcell_array_0.wl_0_3 0.05228f
C190 bank_0.port_address_0.wordline_driver_array_0.in_15 control_logic_rw_0.wl_en 0.18688f
C191 bank_0.port_address_0.wordline_driver_array_0.in_13 bank_0.port_address_0.wordline_driver_array_0.in_14 0.01362f
C192 a_3103_7901# bank_0.port_address_0.wordline_driver_array_0.in_8 0.01304f
C193 a_n2343_705# control_logic_rw_0.dff_buf_array_0.dout_bar_0 0.01675f
C194 bank_0.replica_bitcell_array_0.dummy_array_2_0.dummy_cell_1rw_6.qb bank_0.replica_bitcell_array_0.wl_0_10 0.03924f
C195 row_addr_dff_0.dff_2.net5 row_addr_dff_0.dff_2.net4 0.13677f
C196 control_logic_rw_0.pinv_3_1.gnd a_n1352_n227# 0.01788f
C197 bank_0.replica_bitcell_array_0.dummy_array_3_0.dummy_cell_1rw_9.qb bank_0.replica_bitcell_array_0.dummy_array_3_0.dummy_cell_1rw_9.q 0.28699f
C198 bank_0.replica_bitcell_array_0.dummy_array_3_0.dummy_cell_1rw_11.qb bank_0.replica_bitcell_array_0.dummy_array_3_0.dummy_cell_1rw_11.q 0.28699f
C199 control_logic_rw_0.dff_buf_array_0.dout_1 control_logic_rw_0.dff_buf_array_0.dout_bar_0 2.97961f
C200 bank_0.replica_bitcell_array_0.bitcell_array_0.cell_1rw_13.qb bank_0.replica_bitcell_array_0.wl_0_2 0.03696f
C201 a_5530_5361# a_5461_5361# 0.06598f
C202 bank_0.replica_bitcell_array_0.dummy_array_2_0.dummy_cell_1rw_13.qb a_4490_5361# 0.0163f
C203 bank_0.replica_bitcell_array_0.dummy_array_3_0.dummy_cell_1rw_3.q bank_0.replica_bitcell_array_0.wl_0_13 0.04136f
C204 bank_0.replica_bitcell_array_0.dummy_array_3_0.dummy_cell_1rw_18.qb bank_0.replica_bitcell_array_0.dummy_array_3_0.dummy_cell_1rw_18.q 0.28699f
C205 a_4490_8601# bank_0.replica_bitcell_array_0.wl_0_10 0.04284f
C206 a_n2402_206# control_logic_rw_0.dff_buf_array_0.dout_bar_0 0.0134f
C207 bank_0.replica_bitcell_array_0.bitcell_array_0.cell_1rw_17.q bank_0.replica_bitcell_array_0.wl_0_14 0.04155f
C208 a_5461_6565# a_5530_6565# 0.06598f
C209 bank_0.port_address_0.hierarchical_decoder_0.hierarchical_predecode2x4_0.pinv_1.Z w_431_6733# 0.41826f
C210 bank_0.replica_bitcell_array_0.bitcell_array_0.cell_1rw_23.qb bank_0.replica_bitcell_array_0.bitcell_array_0.cell_1rw_7.q 0.01651f
C211 bank_0.replica_bitcell_array_0.bitcell_array_0.cell_1rw_23.q bank_0.replica_bitcell_array_0.bitcell_array_0.cell_1rw_7.qb 0.02064f
C212 bank_0.replica_bitcell_array_0.bitcell_array_0.cell_1rw_11.q bank_0.replica_bitcell_array_0.wl_0_4 0.04136f
C213 bank_0.replica_bitcell_array_0.wl_0_0 bank_0.replica_bitcell_array_0.bitcell_array_0.cell_1rw_15.q 0.04136f
C214 bank_0.port_address_0.hierarchical_decoder_0.predecode_6 a_1822_7901# 0.01459f
C215 bank_0.replica_bitcell_array_0.dummy_array_2_0.dummy_cell_1rw_5.qb bank_0.replica_bitcell_array_0.wl_0_11 0.03923f
C216 bank_0.replica_bitcell_array_0.bitcell_array_0.cell_1rw_12.q bank_0.replica_bitcell_array_0.bitcell_array_0.cell_1rw_28.qb 0.01651f
C217 bank_0.replica_bitcell_array_0.dummy_array_3_0.dummy_cell_1rw_10.q a_5461_6565# 0.01645f
C218 a_n1997_705# control_logic_rw_0.pdriver_1_0.gnd 0.01184f
C219 bank_0.port_address_0.hierarchical_decoder_0.predecode_0 w_1141_4697# 0.15028f
C220 bank_0.replica_bitcell_array_0.rbl_wl_0_0 bank_0.replica_bitcell_array_0.dummy_array_3_0.dummy_cell_1rw_17.qb 0.03696f
C221 bank_0.replica_bitcell_array_0.replica_column_0.replica_cell_1rw_13.q bank_0.replica_bitcell_array_0.wl_0_2 0.04211f
C222 row_addr_dff_0.dff_2.clkb row_addr_dff_0.dff_3.clkb 0.01354f
C223 w_n4225_n767# control_logic_rw_0.dff_buf_array_0.dff_buf_0_1.pinv_1_0.vdd 0.66995f
C224 control_logic_rw_0.dff_buf_array_0.dff_buf_0_0.dff_0.net4 control_logic_rw_0.dff_buf_array_0.dff_buf_0_0.dff_0.net3 0.04611f
C225 w_2422_8769# bank_0.replica_bitcell_array_0.wl_0_11 0.16341f
C226 data_dff_0.dff_0.clkb data_dff_0.dff_0.net2 0.07662f
C227 bank_0.replica_bitcell_array_0.dummy_array_3_0.dummy_cell_1rw_16.qb bank_0.replica_bitcell_array_0.bitcell_array_0.cell_1rw_15.q 0.02064f
C228 bank_0.replica_bitcell_array_0.dummy_array_3_0.dummy_cell_1rw_16.q bank_0.replica_bitcell_array_0.bitcell_array_0.cell_1rw_15.qb 0.01651f
C229 control_logic_rw_0.dff_buf_array_0.dff_buf_0_0.dff_0.clkb control_logic_rw_0.dff_buf_array_0.dff_buf_0_0.dff_0.net2 0.07662f
C230 row_addr_dff_0.dff_2.net2 row_addr_dff_0.dff_3.clk 0.0716f
C231 a_n2147_n661# control_logic_rw_0.pdriver_0_0.pinv_6_0.A 0.01899f
C232 bank_0.replica_bitcell_array_0.dummy_array_3_0.dummy_cell_1rw_12.q a_5461_5547# 0.01645f
C233 a_n1919_1923# control_logic_rw_0.pinv_3_0.vdd 0.01602f
C234 a_n4794_4969# control_logic_rw_0.delay_chain_0.pinv_11_27.Z 0.0129f
C235 bank_0.replica_bitcell_array_0.wl_0_7 bank_0.replica_bitcell_array_0.bitcell_array_0.cell_1rw_8.qb 0.03696f
C236 control_logic_rw_0.dff_buf_array_0.dout_bar_0 control_logic_rw_0.wl_en 0.14581f
C237 control_logic_rw_0.delay_chain_0.pinv_11_36.Z control_logic_rw_0.delay_chain_0.pinv_11_37.Z 0.04321f
C238 a_n2461_n661# control_logic_rw_0.dff_buf_array_0.dout_bar_0 0.01103f
C239 w_n2769_n767# clk0 0.11126f
C240 a_5461_10637# a_5530_10637# 0.06598f
C241 w_n2769_n767# control_logic_rw_0.pdriver_0_0.pinv_4_0.A 0.1671f
C242 bank_0.replica_bitcell_array_0.dummy_array_2_0.dummy_cell_1rw_14.qb a_4490_4529# 0.0163f
C243 bank_0.replica_bitcell_array_0.bitcell_array_0.cell_1rw_5.q bank_0.replica_bitcell_array_0.wl_0_10 0.04136f
C244 control_logic_rw_0.delay_chain_0.pinv_11_34.Z w_n5644_4500# 1.168f
C245 a_n1529_927# control_logic_rw_0.delay_chain_0.out 0.01376f
C246 bank_0.replica_bitcell_array_0.dummy_array_3_0.dummy_cell_1rw_5.qb bank_0.replica_bitcell_array_0.dummy_array_3_0.dummy_cell_1rw_5.q 0.28699f
C247 control_logic_rw_0.pinv_3_1.gnd a_n1196_n227# 0.01796f
C248 a_5461_8415# a_5530_8415# 0.06598f
C249 a_4421_8601# bank_0.replica_bitcell_array_0.wl_0_10 0.05228f
C250 bank_0.replica_bitcell_array_0.dummy_array_3_0.dummy_cell_1rw_15.qb bank_0.replica_bitcell_array_0.dummy_array_3_0.dummy_cell_1rw_15.q 0.28699f
C251 control_logic_rw_0.delay_chain_0.out w_n5644_6180# 0.33207f
C252 bank_0.port_address_0.hierarchical_decoder_0.predecode_6 w_2422_5715# 0.02963f
C253 bank_0.replica_bitcell_array_0.bitcell_array_0.cell_1rw_23.qb bank_0.replica_bitcell_array_0.bitcell_array_0.cell_1rw_23.q 0.28699f
C254 control_logic_rw_0.delay_chain_0.pinv_11_13.Z a_n4480_8181# 0.0129f
C255 a_3797_2957# bank_0.replica_bitcell_array_0.rbl_wl_0_0 0.01304f
C256 w_2422_3679# bank_0.port_address_0.hierarchical_decoder_0.predecode_1 0.04371f
C257 bank_0.replica_bitcell_array_0.bitcell_array_0.cell_1rw_27.qb bank_0.replica_bitcell_array_0.wl_0_4 0.03704f
C258 bank_0.replica_bitcell_array_0.bitcell_array_0.cell_1rw_28.q bank_0.replica_bitcell_array_0.wl_0_3 0.04155f
C259 bank_0.port_address_0.wordline_driver_array_0.in_0 control_logic_rw_0.wl_en 0.20766f
C260 control_logic_rw_0.pand2_0.Z a_n1822_123# 0.02542f
C261 bank_0.replica_bitcell_array_0.dummy_array_2_0.dummy_cell_1rw_15.q a_4421_4343# 0.01645f
C262 bank_0.replica_bitcell_array_0.replica_column_0.replica_cell_1rw_8.q bank_0.replica_bitcell_array_0.wl_0_7 0.04211f
C263 bank_0.replica_bitcell_array_0.dummy_array_2_0.dummy_cell_1rw_13.qb bank_0.replica_bitcell_array_0.replica_column_0.replica_cell_1rw_12.q 0.01651f
C264 bank_0.replica_bitcell_array_0.dummy_array_2_0.dummy_cell_1rw_7.qb a_4490_8415# 0.0163f
C265 control_logic_rw_0.dff_buf_array_0.dff_buf_0_1.dff_0.clkb control_logic_rw_0.dff_buf_array_0.dff_buf_0_1.dff_0.net2 0.07662f
C266 w_1141_6733# bank_0.port_address_0.hierarchical_decoder_0.predecode_5 0.24006f
C267 control_logic_rw_0.pinv_3_1.gnd a_n1586_n227# 0.01066f
C268 a_n4794_3141# control_logic_rw_0.delay_chain_0.pinv_11_42.Z 0.0129f
C269 w_n5644_7860# control_logic_rw_0.delay_chain_0.pinv_11_14.Z 1.16826f
C270 w_n2769_44# control_logic_rw_0.pinv_3_1.gnd 0.07391f
C271 control_logic_rw_0.delay_chain_0.out control_logic_rw_0.pand2_0.Z 0.4098f
C272 data_dff_0.dff_1.net3 data_dff_0.dff_1.net2 0.03271f
C273 data_dff_0.dff_1.clkb data_dff_0.dff_1.net5 0.03696f
C274 bank_0.port_address_0.hierarchical_decoder_0.predecode_2 bank_0.port_address_0.hierarchical_decoder_0.predecode_5 0.42835f
C275 bank_0.replica_bitcell_array_0.dummy_array_2_0.dummy_cell_1rw_3.qb bank_0.replica_bitcell_array_0.replica_column_0.replica_cell_1rw_2.q 0.01651f
C276 control_logic_rw_0.dff_buf_array_0.dff_buf_0_0.pinv_1_0.gnd control_logic_rw_0.dff_buf_array_0.dff_buf_0_0.pinv_0_0.A 0.04884f
C277 bank_0.replica_bitcell_array_0.dummy_array_3_0.dummy_cell_1rw_12.qb bank_0.replica_bitcell_array_0.dummy_array_3_0.dummy_cell_1rw_12.q 0.28699f
C278 a_n519_n691# control_logic_rw_0.dff_buf_array_0.dout_bar_0 0.02257f
C279 w_1141_6733# row_addr_dff_0.dout_2 0.02155f
C280 row_addr_dff_0.dout_1 row_addr_dff_0.dout_2 4.60186f
C281 control_logic_rw_0.delay_chain_0.pinv_11_24.Z w_n5644_6180# 1.16289f
C282 bank_0.replica_bitcell_array_0.bitcell_array_0.cell_1rw_18.qb bank_0.replica_bitcell_array_0.bitcell_array_0.cell_1rw_18.q 0.28699f
C283 bank_0.replica_bitcell_array_0.wl_0_6 bank_0.replica_bitcell_array_0.dummy_array_3_0.dummy_cell_1rw_10.qb 0.03696f
C284 control_logic_rw_0.pand2_0.Z a_n1900_123# 0.03489f
C285 w_2422_9787# bank_0.port_address_0.wordline_driver_array_0.in_12 0.14989f
C286 control_logic_rw_0.delay_chain_0.pinv_11_23.Z control_logic_rw_0.delay_chain_0.pinv_11_24.Z 0.18902f
C287 control_logic_rw_0.delay_chain_0.pinv_11_25.Z control_logic_rw_0.delay_chain_0.pinv_11_26.Z 0.04321f
C288 a_n1645_n919# control_logic_rw_0.pdriver_0_0.gnd 0.01687f
C289 bank_0.replica_bitcell_array_0.dummy_array_2_0.dummy_cell_1rw_7.qb bank_0.replica_bitcell_array_0.replica_column_0.replica_cell_1rw_6.q 0.01651f
C290 a_n753_n919# control_logic_rw_0.pdriver_0_0.gnd 0.01807f
C291 a_n3917_n919# control_logic_rw_0.dff_buf_array_0.dout_bar_0 0.01142f
C292 w_n5644_4500# control_logic_rw_0.delay_chain_0.pinv_11_31.Z 0.20256f
C293 bank_0.replica_bitcell_array_0.wl_0_9 bank_0.replica_bitcell_array_0.dummy_array_3_0.dummy_cell_1rw_7.qb 0.03696f
C294 control_logic_rw_0.pand3_0_0.pnand3_0_0.nmos_m1_w0_840_sactive_dactive_0.D control_logic_rw_0.pand3_0_0.gnd 0.01146f
C295 a_4421_4529# a_4490_4529# 0.06598f
C296 bank_0.replica_bitcell_array_0.wl_0_12 bank_0.replica_bitcell_array_0.bitcell_array_0.cell_1rw_19.q 0.04155f
C297 control_logic_rw_0.delay_chain_0.out control_logic_rw_0.delay_chain_0.pinv_11_14.Z 0.10996f
C298 a_5461_2493# a_5530_2493# 0.06598f
C299 bank_0.replica_bitcell_array_0.dummy_array_3_0.dummy_cell_1rw_6.qb bank_0.replica_bitcell_array_0.dummy_array_3_0.dummy_cell_1rw_6.q 0.28699f
C300 control_logic_rw_0.pand2_0.Z a_n1666_n107# 0.01112f
C301 a_n2515_n513# control_logic_rw_0.dff_buf_array_0.dout_bar_0 0.01719f
C302 control_logic_rw_0.dff_buf_array_0.dff_buf_0_0.dff_0.clkb control_logic_rw_0.dff_buf_array_0.dff_buf_0_0.dff_0.net1 0.1543f
C303 control_logic_rw_0.pinv_3_1.Z control_logic_rw_0.dff_buf_array_0.dout_bar_0 0.20585f
C304 bank_0.replica_bitcell_array_0.bitcell_array_0.cell_1rw_27.qb bank_0.replica_bitcell_array_0.replica_column_0.replica_cell_1rw_11.q 0.02064f
C305 bank_0.replica_bitcell_array_0.dummy_array_0_0.dummy_cell_1rw_0.q bank_0.replica_bitcell_array_0.dummy_array_3_0.dummy_cell_1rw_0.qb 0.02064f
C306 control_logic_rw_0.delay_chain_0.out w_n2769_1669# 0.21448f
C307 w_2422_10805# bank_0.port_address_0.hierarchical_decoder_0.predecode_3 0.02796f
C308 bank_0.replica_bitcell_array_0.dummy_array_3_0.dummy_cell_1rw_5.qb bank_0.replica_bitcell_array_0.wl_0_11 0.03696f
C309 a_n5422_3141# control_logic_rw_0.delay_chain_0.pinv_11_40.Z 0.0129f
C310 a_3797_8047# bank_0.replica_bitcell_array_0.wl_0_9 0.01304f
C311 a_4421_7397# bank_0.replica_bitcell_array_0.dummy_array_2_0.dummy_cell_1rw_9.q 0.01645f
C312 a_n1645_n681# control_logic_rw_0.dff_buf_array_0.dout_bar_0 0.02823f
C313 bank_0.replica_bitcell_array_0.bitcell_array_0.cell_1rw_10.qb bank_0.replica_bitcell_array_0.wl_0_5 0.03696f
C314 bank_0.port_address_0.hierarchical_decoder_0.predecode_0 bank_0.port_address_0.hierarchical_decoder_0.predecode_5 0.49878f
C315 a_5530_11469# bank_0.replica_bitcell_array_0.dummy_array_3_0.dummy_cell_1rw_1.qb 0.0163f
C316 control_logic_rw_0.pand2_0.Z control_logic_rw_0.pdriver_1_0.pinv_8_0.Z 0.01198f
C317 bank_0.replica_bitcell_array_0.replica_column_0.replica_cell_1rw_15.q bank_0.replica_bitcell_array_0.bitcell_array_0.cell_1rw_31.qb 0.02064f
C318 bank_0.replica_bitcell_array_0.dummy_array_3_0.dummy_cell_1rw_7.qb bank_0.replica_bitcell_array_0.bitcell_array_0.cell_1rw_6.q 0.02064f
C319 bank_0.replica_bitcell_array_0.dummy_array_3_0.dummy_cell_1rw_7.q bank_0.replica_bitcell_array_0.bitcell_array_0.cell_1rw_6.qb 0.01651f
C320 control_logic_rw_0.delay_chain_0.out control_logic_rw_0.pinv_3_0.vdd 0.11108f
C321 control_logic_rw_0.dff_buf_array_0.dout_bar_0 a_n3525_n513# 0.01026f
C322 bank_0.port_address_0.hierarchical_decoder_0.predecode_6 bank_0.port_address_0.hierarchical_decoder_0.predecode_7 5.35956f
C323 bank_0.replica_bitcell_array_0.replica_column_0.replica_cell_1rw_8.q bank_0.replica_bitcell_array_0.dummy_array_2_0.dummy_cell_1rw_9.qb 0.01651f
C324 bank_0.replica_bitcell_array_0.bitcell_array_0.cell_1rw_29.q bank_0.replica_bitcell_array_0.bitcell_array_0.cell_1rw_13.qb 0.02064f
C325 data_dff_0.dff_1.net2 din0[0] 0.01061f
C326 bank_0.replica_bitcell_array_0.bitcell_array_0.cell_1rw_12.qb bank_0.replica_bitcell_array_0.dummy_array_3_0.dummy_cell_1rw_13.q 0.01651f
C327 bank_0.replica_bitcell_array_0.bitcell_array_0.cell_1rw_12.q bank_0.replica_bitcell_array_0.dummy_array_3_0.dummy_cell_1rw_13.qb 0.02064f
C328 bank_0.replica_bitcell_array_0.wl_0_1 bank_0.replica_bitcell_array_0.wl_0_0 0.03867f
C329 control_logic_rw_0.delay_chain_0.pinv_11_6.Z w_n5644_7860# 0.20256f
C330 bank_0.replica_bitcell_array_0.dummy_array_2_0.dummy_cell_1rw_2.q bank_0.replica_bitcell_array_0.wl_0_14 0.04741f
C331 control_logic_rw_0.delay_chain_0.pinv_11_43.Z control_logic_rw_0.delay_chain_0.pinv_11_42.Z 0.04321f
C332 a_n4794_9861# control_logic_rw_0.delay_chain_0.pinv_11_2.Z 0.0129f
C333 w_n2769_857# control_logic_rw_0.p_en_bar 0.24922f
C334 bank_0.replica_bitcell_array_0.dummy_array_1_0.dummy_cell_1rw_1.qb bank_0.replica_bitcell_array_0.dummy_array_1_0.dummy_cell_1rw_0.q 0.01651f
C335 control_logic_rw_0.delay_chain_0.pinv_11_28.Z control_logic_rw_0.delay_chain_0.pinv_11_27.Z 0.04321f
C336 w_n5644_9540# control_logic_rw_0.delay_chain_0.pinv_11_1.Z 0.20256f
C337 control_logic_rw_0.delay_chain_0.pinv_11_32.Z w_n5644_4500# 0.20256f
C338 a_n1841_705# control_logic_rw_0.pdriver_1_0.gnd 0.01158f
C339 bank_0.replica_bitcell_array_0.dummy_array_3_0.dummy_cell_1rw_10.q bank_0.replica_bitcell_array_0.bitcell_array_0.cell_1rw_9.qb 0.01651f
C340 bank_0.replica_bitcell_array_0.bitcell_array_0.cell_1rw_20.qb bank_0.replica_bitcell_array_0.replica_column_0.replica_cell_1rw_4.q 0.02064f
C341 control_logic_rw_0.dff_buf_array_0.dout_0 a_n3447_n919# 0.01532f
C342 a_4421_11655# bank_0.replica_bitcell_array_0.dummy_array_2_0.dummy_cell_1rw_0.q 0.01645f
C343 control_logic_rw_0.dff_buf_array_0.dff_buf_0_1.dff_0.clkb csb0 0.33766f
C344 a_n5108_9861# control_logic_rw_0.delay_chain_0.pinv_11_1.Z 0.0129f
C345 data_dff_0.dff_0.net1 data_dff_0.dff_0.net2 0.12728f
C346 control_logic_rw_0.delay_chain_0.out control_logic_rw_0.delay_chain_0.pinv_11_44.Z 0.11074f
C347 a_n519_n919# control_logic_rw_0.pdriver_0_0.gnd 0.01095f
C348 bank_0.replica_bitcell_array_0.replica_column_0.replica_cell_1rw_1.q bank_0.replica_bitcell_array_0.dummy_array_2_0.dummy_cell_1rw_2.qb 0.01651f
C349 control_logic_rw_0.delay_chain_0.pinv_11_12.Z control_logic_rw_0.delay_chain_0.pinv_11_13.Z 0.04321f
C350 control_logic_rw_0.wl_en w_2422_7751# 0.29624f
C351 bank_0.port_address_0.wordline_driver_array_0.in_4 bank_0.port_address_0.wordline_driver_array_0.in_5 0.01302f
C352 bank_0.replica_bitcell_array_0.dummy_array_3_0.dummy_cell_1rw_7.q a_5461_8415# 0.01645f
C353 a_n2147_n661# control_logic_rw_0.dff_buf_array_0.dout_bar_0 0.02493f
C354 control_logic_rw_0.dff_buf_array_0.dff_buf_0_0.dff_0.net1 control_logic_rw_0.dff_buf_array_0.dff_buf_0_0.dff_0.net2 0.12728f
C355 a_4941_3325# a_5010_3325# 0.06598f
C356 bank_0.port_address_0.hierarchical_decoder_0.hierarchical_predecode2x4_0.pinv_0.Z row_addr_dff_0.dout_2 1.57281f
C357 a_739_3975# bank_0.port_address_0.hierarchical_decoder_0.hierarchical_predecode2x4_1.pinv_0.Z 0.01343f
C358 w_n2769_44# control_logic_rw_0.pdriver_1_0.gnd 0.05881f
C359 w_2422_3679# bank_0.port_address_0.wordline_driver_array_0.in_1 0.14946f
C360 a_5270_2493# bank_0.replica_bitcell_array_0.dummy_array_1_0.dummy_cell_1rw_0.qb 0.0163f
C361 control_logic_rw_0.delay_chain_0.pinv_11_25.Z control_logic_rw_0.delay_chain_0.out 0.04231f
C362 w_2422_9787# control_logic_rw_0.wl_en 0.29624f
C363 control_logic_rw_0.delay_chain_0.out control_logic_rw_0.pand3_0.pnand3_0_0.nmos_m1_w0_840_sactive_dli_0.G 0.01835f
C364 control_logic_rw_0.pand2_0.Z control_logic_rw_0.pand3_0.B 0.06664f
C365 control_logic_rw_0.pand2_0.Z a_n1666_123# 0.02293f
C366 bank_0.replica_bitcell_array_0.replica_column_0.replica_cell_1rw_4.q bank_0.replica_bitcell_array_0.wl_0_11 0.04211f
C367 w_2422_6733# bank_0.replica_bitcell_array_0.wl_0_7 0.16341f
C368 row_addr_dff_0.dff_0.clkb addr0[3] 0.32288f
C369 a_n2110_123# control_logic_rw_0.dff_buf_array_0.dout_bar_0 0.02166f
C370 control_logic_rw_0.pdriver_0_0.gnd a_n1197_n919# 0.01117f
C371 a_5461_10637# bank_0.replica_bitcell_array_0.dummy_array_3_0.dummy_cell_1rw_2.q 0.01645f
C372 control_logic_rw_0.dff_buf_array_0.dout_0 control_logic_rw_0.dff_buf_array_0.dff_buf_0_1.pinv_1_0.vdd 0.15252f
C373 bank_0.replica_bitcell_array_0.dummy_array_2_0.dummy_cell_1rw_10.qb bank_0.replica_bitcell_array_0.replica_column_0.replica_cell_1rw_9.q 0.01651f
C374 a_4490_4343# bank_0.replica_bitcell_array_0.dummy_array_2_0.dummy_cell_1rw_15.qb 0.0163f
C375 a_5461_4343# a_5530_4343# 0.06598f
C376 bank_0.replica_bitcell_array_0.dummy_array_3_0.dummy_cell_1rw_2.qb bank_0.replica_bitcell_array_0.wl_0_14 0.03696f
C377 row_addr_dff_0.dff_3.net3 row_addr_dff_0.dff_3.net1 0.14299f
C378 bank_0.replica_bitcell_array_0.dummy_array_2_0.dummy_cell_1rw_0.q bank_0.replica_bitcell_array_0.replica_column_0.dummy_cell_1rw_0.qb 0.02064f
C379 control_logic_rw_0.delay_chain_0.out a_n2402_1369# 0.02325f
C380 a_1822_3829# bank_0.port_address_0.hierarchical_decoder_0.predecode_0 0.01565f
C381 bank_0.replica_bitcell_array_0.dummy_array_3_0.dummy_cell_1rw_14.qb bank_0.replica_bitcell_array_0.wl_0_2 0.03696f
C382 bank_0.replica_bitcell_array_0.replica_column_0.dummy_cell_1rw_0.q bank_0.replica_bitcell_array_0.replica_column_0.dummy_cell_1rw_0.qb 0.28699f
C383 a_n1430_n513# control_logic_rw_0.dff_buf_array_0.dout_bar_0 0.06887f
C384 a_n3917_n661# control_logic_rw_0.dff_buf_array_0.dff_buf_0_1.pinv_1_0.vdd 0.01857f
C385 control_logic_rw_0.delay_chain_0.pinv_11_12.Z a_n4794_8181# 0.0129f
C386 control_logic_rw_0.dff_buf_array_0.dff_buf_0_1.pinv_1_0.vdd a_n3447_n513# 0.02745f
C387 w_1141_3679# bank_0.port_address_0.hierarchical_decoder_0.predecode_4 0.0127f
C388 bank_0.replica_bitcell_array_0.bitcell_array_0.cell_1rw_26.q bank_0.replica_bitcell_array_0.wl_0_5 0.04155f
C389 bank_0.replica_bitcell_array_0.replica_column_0.dummy_cell_1rw_0.q bank_0.replica_bitcell_array_0.dummy_array_0_0.dummy_cell_1rw_1.qb 0.02064f
C390 a_5530_5361# bank_0.replica_bitcell_array_0.wl_0_3 0.04184f
C391 w_n5644_9540# control_logic_rw_0.delay_chain_0.pinv_11_0.Z 0.19711f
C392 a_n1586_n513# control_logic_rw_0.dff_buf_array_0.dout_bar_0 0.06363f
C393 bank_0.port_address_0.hierarchical_decoder_0.predecode_6 w_1141_7751# 0.18316f
C394 control_logic_rw_0.pdriver_0_0.gnd control_logic_rw_0.pdriver_0_0.pinv_6_0.A 0.17609f
C395 bank_0.replica_bitcell_array_0.replica_column_0.replica_cell_1rw_16.q bank_0.replica_bitcell_array_0.dummy_array_0.dummy_cell_1rw_1.qb 0.02064f
C396 bank_0.replica_bitcell_array_0.dummy_array_2_0.dummy_cell_1rw_3.q bank_0.replica_bitcell_array_0.wl_0_13 0.0474f
C397 control_logic_rw_0.pand3_0.B w_n2769_1669# 0.18857f
C398 a_n4166_4821# control_logic_rw_0.delay_chain_0.pinv_11_34.Z 0.01702f
C399 bank_0.port_address_0.wordline_driver_array_0.in_15 w_2422_10805# 0.14946f
C400 a_n1489_n919# control_logic_rw_0.pdriver_0_0.gnd 0.01014f
C401 a_n597_n919# control_logic_rw_0.pdriver_0_0.gnd 0.01807f
C402 w_2422_6733# bank_0.port_address_0.hierarchical_decoder_0.predecode_6 0.03401f
C403 control_logic_rw_0.pand3_0.B control_logic_rw_0.pinv_3_0.vdd 0.08704f
C404 bank_0.replica_bitcell_array_0.dummy_array_3_0.dummy_cell_1rw_6.qb a_5530_8601# 0.0163f
C405 control_logic_rw_0.delay_chain_0.pinv_11_26.Z control_logic_rw_0.delay_chain_0.pinv_11_27.Z 0.04321f
C406 w_n5644_2820# control_logic_rw_0.delay_chain_0.pinv_11_38.Z 0.20256f
C407 control_logic_rw_0.pand3_0.B control_logic_rw_0.dff_buf_array_0.dff_buf_0_0.pinv_1_0.gnd 0.01442f
C408 control_logic_rw_0.pand2_0.Z a_n1510_n107# 0.01136f
C409 bank_0.replica_bitcell_array_0.dummy_array_3_0.dummy_cell_1rw_14.q a_5461_4529# 0.01645f
C410 a_n2201_n513# control_logic_rw_0.dff_buf_array_0.dout_bar_0 0.02246f
C411 bank_0.replica_bitcell_array_0.bitcell_array_0.cell_1rw_10.q bank_0.replica_bitcell_array_0.bitcell_array_0.cell_1rw_26.qb 0.01651f
C412 bank_0.replica_bitcell_array_0.bitcell_array_0.cell_1rw_10.qb bank_0.replica_bitcell_array_0.bitcell_array_0.cell_1rw_26.q 0.02064f
C413 bank_0.port_address_0.hierarchical_decoder_0.predecode_1 w_2422_5715# 0.02155f
C414 bank_0.port_address_0.wordline_driver_array_0.in_13 a_3103_10083# 0.01304f
C415 bank_0.replica_bitcell_array_0.dummy_array_2_0.dummy_cell_1rw_1.qb bank_0.replica_bitcell_array_0.replica_column_0.replica_cell_1rw_0.q 0.01651f
C416 w_1141_3679# bank_0.port_address_0.hierarchical_decoder_0.hierarchical_predecode2x4_1.pinv_0.Z 0.29388f
C417 control_logic_rw_0.delay_chain_0.out control_logic_rw_0.delay_chain_0.pinv_11_30.Z 0.04231f
C418 bank_0.replica_bitcell_array_0.dummy_array_3_0.dummy_cell_1rw_17.q a_5461_3325# 0.01645f
C419 control_logic_rw_0.pdriver_0_0.pinv_7_0.A a_n1723_n681# 0.02596f
C420 control_logic_rw_0.pinv_3_1.gnd control_logic_rw_0.pinv_3_1.Z 0.18489f
C421 bank_0.replica_bitcell_array_0.dummy_array_0.dummy_cell_1rw_0.q bank_0.replica_bitcell_array_0.dummy_array_3_0.dummy_cell_1rw_17.qb 0.02064f
C422 bank_0.replica_bitcell_array_0.dummy_array_3_0.dummy_cell_1rw_6.q bank_0.replica_bitcell_array_0.wl_0_10 0.04136f
C423 a_3797_3829# bank_0.replica_bitcell_array_0.wl_0_0 0.01304f
C424 bank_0.replica_bitcell_array_0.wl_0_7 bank_0.replica_bitcell_array_0.wl_0_6 0.03867f
C425 bank_0.replica_bitcell_array_0.bitcell_array_0.cell_1rw_29.q bank_0.replica_bitcell_array_0.wl_0_2 0.04155f
C426 a_n1489_n681# control_logic_rw_0.dff_buf_array_0.dout_bar_0 0.01798f
C427 bank_0.replica_bitcell_array_0.bitcell_array_0.cell_1rw_30.q bank_0.replica_bitcell_array_0.bitcell_array_0.cell_1rw_30.qb 0.28699f
C428 row_addr_dff_0.dff_3.net3 row_addr_dff_0.dff_3.net4 0.04611f
C429 control_logic_rw_0.delay_chain_0.pinv_11_28.Z w_n5644_4500# 0.20256f
C430 bank_0.replica_bitcell_array_0.dummy_array_3_0.dummy_cell_1rw_3.qb bank_0.replica_bitcell_array_0.wl_0_13 0.03696f
C431 row_addr_dff_0.dff_0.net3 row_addr_dff_0.dff_0.net4 0.04611f
C432 control_logic_rw_0.delay_chain_0.pinv_11_34.Z control_logic_rw_0.delay_chain_0.pinv_11_29.Z 0.36098f
C433 control_logic_rw_0.dff_buf_array_0.dout_1 a_n3525_n227# 0.0212f
C434 bank_0.replica_bitcell_array_0.bitcell_array_0.cell_1rw_17.qb bank_0.replica_bitcell_array_0.wl_0_14 0.03704f
C435 control_logic_rw_0.dff_buf_array_0.dff_buf_0_1.pinv_0_0.A control_logic_rw_0.dff_buf_array_0.dff_buf_0_1.dff_0.clkb 0.01658f
C436 control_logic_rw_0.dff_buf_array_0.dff_buf_0_0.dff_0.net4 control_logic_rw_0.dff_buf_array_0.dff_buf_0_0.dff_0.clkb 0.08731f
C437 bank_0.replica_bitcell_array_0.bitcell_array_0.cell_1rw_11.qb bank_0.replica_bitcell_array_0.wl_0_4 0.03696f
C438 control_logic_rw_0.pand2_0.Z control_logic_rw_0.dff_buf_array_0.dout_bar_0 5.64107f
C439 bank_0.replica_bitcell_array_0.wl_0_0 bank_0.replica_bitcell_array_0.bitcell_array_0.cell_1rw_15.qb 0.03696f
C440 control_logic_rw_0.pdriver_1_0.gnd control_logic_rw_0.wl_en 0.1638f
C441 control_logic_rw_0.dff_buf_array_0.dout_1 a_n2402_1923# 0.01432f
C442 a_n4166_3141# control_logic_rw_0.delay_chain_0.pinv_11_44.Z 0.01702f
C443 a_n1510_123# control_logic_rw_0.dff_buf_array_0.dout_bar_0 0.02798f
C444 bank_0.replica_bitcell_array_0.dummy_array_2_0.dummy_cell_1rw_5.qb bank_0.replica_bitcell_array_0.replica_column_0.replica_cell_1rw_4.q 0.01651f
C445 a_n675_n691# control_logic_rw_0.dff_buf_array_0.dout_bar_0 0.02257f
C446 control_logic_rw_0.delay_chain_0.out w_n5644_7860# 0.33207f
C447 bank_0.replica_bitcell_array_0.dummy_array_2_0.dummy_cell_1rw_1.q bank_0.replica_bitcell_array_0.dummy_array_2_0.dummy_cell_1rw_1.qb 0.28699f
C448 control_logic_rw_0.pand2_0.Z a_n1978_n107# 0.01255f
C449 bank_0.replica_bitcell_array_0.dummy_array_0.dummy_cell_1rw_1.q a_4941_3325# 0.01645f
C450 bank_0.replica_bitcell_array_0.rbl_wl_0_0 bank_0.replica_bitcell_array_0.dummy_array_0.dummy_cell_1rw_0.q 0.04136f
C451 a_n1723_n919# control_logic_rw_0.pdriver_0_0.pinv_7_0.A 0.01546f
C452 control_logic_rw_0.delay_chain_0.out a_n1828_1111# 0.01466f
C453 bank_0.replica_bitcell_array_0.dummy_array_2_0.dummy_cell_1rw_14.q bank_0.replica_bitcell_array_0.wl_0_2 0.04741f
C454 control_logic_rw_0.delay_chain_0.pinv_11_6.Z a_n5108_8329# 0.0129f
C455 bank_0.replica_bitcell_array_0.wl_0_8 w_2422_7751# 0.16398f
C456 a_4421_9433# a_4490_9433# 0.06598f
C457 a_5461_4529# a_5530_4529# 0.06598f
C458 w_n4225_n767# control_logic_rw_0.dff_buf_array_0.dout_1 0.17609f
C459 control_logic_rw_0.delay_chain_0.pinv_11_33.Z w_n5644_4500# 0.20256f
C460 bank_0.replica_bitcell_array_0.wl_0_7 bank_0.replica_bitcell_array_0.bitcell_array_0.cell_1rw_24.q 0.04155f
C461 control_logic_rw_0.dff_buf_array_0.dff_buf_0_0.dff_0.net4 control_logic_rw_0.dff_buf_array_0.dff_buf_0_0.dff_0.net5 0.13677f
C462 addr0[2] addr0[1] 0.23703f
C463 control_logic_rw_0.delay_chain_0.pinv_11_41.Z control_logic_rw_0.delay_chain_0.pinv_11_42.Z 0.04321f
C464 bank_0.replica_bitcell_array_0.bitcell_array_0.cell_1rw_8.q bank_0.replica_bitcell_array_0.dummy_array_3_0.dummy_cell_1rw_9.qb 0.02064f
C465 a_5461_9619# a_5530_9619# 0.06598f
C466 bank_0.replica_bitcell_array_0.bitcell_array_0.cell_1rw_5.qb bank_0.replica_bitcell_array_0.wl_0_10 0.03696f
C467 bank_0.replica_bitcell_array_0.wl_0_11 bank_0.replica_bitcell_array_0.wl_0_10 0.03867f
C468 control_logic_rw_0.delay_chain_0.pinv_11_34.Z control_logic_rw_0.delay_chain_0.pinv_11_39.Z 0.4357f
C469 w_2422_10805# bank_0.port_address_0.hierarchical_decoder_0.predecode_2 0.02797f
C470 row_addr_dff_0.dff_0.clkb row_addr_dff_0.dff_0.net4 0.08731f
C471 a_3797_10955# bank_0.replica_bitcell_array_0.wl_0_14 0.01304f
C472 control_logic_rw_0.pand3_0.B control_logic_rw_0.pand3_0.pnand3_0_0.nmos_m1_w0_840_sactive_dli_0.G 0.09974f
C473 a_5461_2493# bank_0.replica_bitcell_array_0.dummy_array_3_0.dummy_cell_1rw_18.q 0.01645f
C474 w_n2769_1669# control_logic_rw_0.dff_buf_array_0.dout_bar_0 0.19997f
C475 bank_0.replica_bitcell_array_0.dummy_array_2_0.dummy_cell_1rw_16.qb a_4490_3511# 0.0163f
C476 control_logic_rw_0.pdriver_1_0.pinv_8_0.A control_logic_rw_0.pdriver_1_0.pinv_8_0.Z 0.0798f
C477 bank_0.port_address_0.hierarchical_decoder_0.hierarchical_predecode2x4_1.pinv_1.Z w_431_3679# 0.41826f
C478 bank_0.replica_bitcell_array_0.wl_0_0 bank_0.replica_bitcell_array_0.bitcell_array_0.cell_1rw_31.q 0.04155f
C479 a_n1774_1111# control_logic_rw_0.p_en_bar 0.01532f
C480 control_logic_rw_0.delay_chain_0.pinv_11_19.Z control_logic_rw_0.delay_chain_0.pinv_11_17.Z 0.14367f
C481 control_logic_rw_0.delay_chain_0.pinv_11_6.Z control_logic_rw_0.delay_chain_0.pinv_11_7.Z 0.04321f
C482 control_logic_rw_0.pinv_3_0.vdd control_logic_rw_0.dff_buf_array_0.dout_bar_0 0.02748f
C483 a_n1299_298# control_logic_rw_0.wl_en 0.02574f
C484 control_logic_rw_0.dff_buf_array_0.dff_buf_0_0.pinv_1_0.gnd control_logic_rw_0.dff_buf_array_0.dout_bar_0 0.18679f
C485 row_addr_dff_0.dout_1 w_1141_3679# 0.12164f
C486 control_logic_rw_0.delay_chain_0.pinv_11_5.Z control_logic_rw_0.delay_chain_0.pinv_11_6.Z 0.04321f
C487 control_logic_rw_0.dff_buf_array_0.dff_buf_0_1.pinv_1_0.gnd a_n3447_n919# 0.01798f
C488 bank_0.replica_bitcell_array_0.wl_0_9 bank_0.replica_bitcell_array_0.bitcell_array_0.cell_1rw_6.q 0.04136f
C489 a_4421_6565# bank_0.replica_bitcell_array_0.wl_0_6 0.05228f
C490 addr0[2] row_addr_dff_0.dff_3.clk 0.19194f
C491 w_2422_4697# control_logic_rw_0.wl_en 0.29624f
C492 bank_0.port_address_0.wordline_driver_array_0.in_14 control_logic_rw_0.wl_en 0.18688f
C493 a_4490_6565# bank_0.replica_bitcell_array_0.wl_0_6 0.04284f
C494 a_5530_11469# a_5461_11469# 0.06598f
C495 bank_0.replica_bitcell_array_0.dummy_array_2_0.dummy_cell_1rw_1.qb a_4490_11469# 0.0163f
C496 a_n3839_n661# control_logic_rw_0.dff_buf_array_0.dff_buf_0_1.pinv_1_0.vdd 0.01602f
C497 bank_0.port_address_0.hierarchical_decoder_0.predecode_1 bank_0.port_address_0.hierarchical_decoder_0.predecode_7 0.45915f
C498 bank_0.replica_bitcell_array_0.rbl_wl_0_0 bank_0.replica_bitcell_array_0.dummy_array_0.dummy_cell_1rw_1.qb 0.03704f
C499 control_logic_rw_0.pdriver_0_0.gnd a_n1065_n919# 0.01809f
C500 control_logic_rw_0.delay_chain_0.pinv_11_25.Z w_n5644_4500# 0.19711f
C501 w_2422_10805# bank_0.replica_bitcell_array_0.wl_0_15 0.16341f
C502 control_logic_rw_0.delay_chain_0.pinv_11_17.Z control_logic_rw_0.delay_chain_0.pinv_11_18.Z 0.04321f
C503 bank_0.replica_bitcell_array_0.bitcell_array_0.cell_1rw_1.q bank_0.replica_bitcell_array_0.dummy_array_3_0.dummy_cell_1rw_2.qb 0.02064f
C504 control_logic_rw_0.delay_chain_0.pinv_11_24.Z control_logic_rw_0.delay_chain_0.out 0.10996f
C505 w_n2769_857# control_logic_rw_0.pdriver_4_0.pinv_8_0.A 0.15114f
C506 bank_0.replica_bitcell_array_0.dummy_array_3_0.dummy_cell_1rw_5.q a_5461_9433# 0.01645f
C507 bank_0.replica_bitcell_array_0.wl_0_6 bank_0.replica_bitcell_array_0.bitcell_array_0.cell_1rw_9.q 0.04136f
C508 addr0[0] addr0[1] 0.30612f
C509 bank_0.replica_bitcell_array_0.bitcell_array_0.cell_1rw_13.qb bank_0.replica_bitcell_array_0.bitcell_array_0.cell_1rw_13.q 0.28699f
C510 a_n1274_n513# control_logic_rw_0.dff_buf_array_0.dout_bar_0 0.05932f
C511 a_n5108_3141# control_logic_rw_0.delay_chain_0.pinv_11_41.Z 0.0129f
C512 a_4490_6379# a_4421_6379# 0.06598f
C513 row_addr_dff_0.dff_1.clkb addr0[1] 0.02786f
C514 w_2422_3679# bank_0.port_address_0.hierarchical_decoder_0.predecode_7 0.14845f
C515 w_n5644_4500# control_logic_rw_0.delay_chain_0.pinv_11_26.Z 0.20256f
C516 bank_0.replica_bitcell_array_0.wl_0_1 a_5461_4343# 0.05176f
C517 bank_0.port_address_0.wordline_driver_array_0.in_8 control_logic_rw_0.wl_en 0.18688f
C518 bank_0.replica_bitcell_array_0.wl_0_3 bank_0.replica_bitcell_array_0.wl_0_2 0.03867f
C519 bank_0.replica_bitcell_array_0.wl_0_12 bank_0.replica_bitcell_array_0.bitcell_array_0.cell_1rw_19.qb 0.03704f
C520 bank_0.replica_bitcell_array_0.bitcell_array_0.cell_1rw_25.q bank_0.replica_bitcell_array_0.bitcell_array_0.cell_1rw_9.qb 0.02064f
C521 a_n5108_6501# control_logic_rw_0.delay_chain_0.pinv_11_21.Z 0.0129f
C522 a_n2056_123# control_logic_rw_0.dff_buf_array_0.dout_bar_0 0.02412f
C523 row_addr_dff_0.dff_1.net4 row_addr_dff_0.dff_3.clk 0.15111f
C524 control_logic_rw_0.pdriver_0_0.gnd control_logic_rw_0.dff_buf_array_0.dout_bar_0 0.03463f
C525 control_logic_rw_0.dff_buf_array_0.dff_buf_0_1.pinv_1_0.gnd control_logic_rw_0.dff_buf_array_0.dff_buf_0_1.pinv_1_0.vdd 0.0233f
C526 bank_0.replica_bitcell_array_0.bitcell_array_0.cell_1rw_0.q bank_0.replica_bitcell_array_0.dummy_array_3_0.dummy_cell_1rw_1.qb 0.02064f
C527 row_addr_dff_0.dff_0.clkb row_addr_dff_0.dff_0.net3 0.14179f
C528 a_n1299_589# control_logic_rw_0.wl_en 0.01232f
C529 w_2422_8769# bank_0.port_address_0.hierarchical_decoder_0.predecode_7 0.1498f
C530 control_logic_rw_0.delay_chain_0.pinv_11_8.Z a_n4480_8329# 0.0129f
C531 a_4941_11655# bank_0.replica_bitcell_array_0.dummy_array_0_0.dummy_cell_1rw_1.q 0.01645f
C532 data_dff_0.dff_0.clkb data_dff_0.dff_0.net5 0.03696f
C533 a_5461_5361# bank_0.replica_bitcell_array_0.wl_0_3 0.05176f
C534 bank_0.replica_bitcell_array_0.bitcell_array_0.cell_1rw_5.q bank_0.replica_bitcell_array_0.bitcell_array_0.cell_1rw_21.qb 0.01651f
C535 bank_0.replica_bitcell_array_0.bitcell_array_0.cell_1rw_5.qb bank_0.replica_bitcell_array_0.bitcell_array_0.cell_1rw_21.q 0.02064f
C536 w_n5644_2820# control_logic_rw_0.delay_chain_0.pinv_11_39.Z 0.75928f
C537 control_logic_rw_0.pand3_0.pnand3_0_0.nmos_m1_w0_840_sactive_dli_0.G control_logic_rw_0.dff_buf_array_0.dout_bar_0 0.08639f
C538 w_n5644_2820# control_logic_rw_0.delay_chain_0.pinv_11_40.Z 0.19711f
C539 a_n2461_299# control_logic_rw_0.pdriver_1_0.pinv_8_0.A 0.0132f
C540 addr0[0] row_addr_dff_0.dff_3.clk 0.2923f
C541 w_1141_3679# bank_0.port_address_0.hierarchical_decoder_0.predecode_0 0.31967f
C542 w_2422_8769# bank_0.replica_bitcell_array_0.wl_0_10 0.16398f
C543 row_addr_dff_0.dff_1.clkb row_addr_dff_0.dff_3.clk 0.83335f
C544 a_n3369_n689# control_logic_rw_0.dff_buf_array_0.dout_0 0.02156f
C545 a_5530_8601# bank_0.replica_bitcell_array_0.wl_0_10 0.04184f
C546 a_4421_6565# bank_0.replica_bitcell_array_0.dummy_array_2_0.dummy_cell_1rw_10.q 0.01645f
C547 control_logic_rw_0.delay_chain_0.pinv_11_30.Z w_n5644_4500# 0.19711f
C548 control_logic_rw_0.dff_buf_array_0.dff_buf_0_1.dff_0.net4 control_logic_rw_0.dff_buf_array_0.dff_buf_0_1.dff_0.net3 0.04611f
C549 bank_0.replica_bitcell_array_0.dummy_array_2_0.dummy_cell_1rw_12.qb bank_0.replica_bitcell_array_0.wl_0_4 0.03924f
C550 bank_0.replica_bitcell_array_0.bitcell_array_0.cell_1rw_1.q bank_0.replica_bitcell_array_0.bitcell_array_0.cell_1rw_17.qb 0.01651f
C551 bank_0.replica_bitcell_array_0.bitcell_array_0.cell_1rw_1.qb bank_0.replica_bitcell_array_0.bitcell_array_0.cell_1rw_17.q 0.02064f
C552 bank_0.replica_bitcell_array_0.replica_column_0.replica_cell_1rw_8.q bank_0.replica_bitcell_array_0.bitcell_array_0.cell_1rw_24.qb 0.02064f
C553 row_addr_dff_0.dout_3 w_431_6733# 0.2155f
C554 bank_0.replica_bitcell_array_0.wl_0_9 bank_0.replica_bitcell_array_0.dummy_array_2_0.dummy_cell_1rw_7.q 0.0474f
C555 control_logic_rw_0.pdriver_0_0.pinv_7_0.A a_n1567_n681# 0.02816f
C556 bank_0.replica_bitcell_array_0.wl_0_1 w_2422_3679# 0.16341f
C557 a_4681_11655# a_4750_11655# 0.06598f
C558 a_n2461_n661# control_logic_rw_0.pdriver_0_0.pinv_4_0.A 0.0132f
C559 control_logic_rw_0.pinv_3_1.gnd control_logic_rw_0.pand2_0.Z 0.50107f
C560 a_4421_3511# a_4490_3511# 0.06598f
C561 bank_0.replica_bitcell_array_0.bitcell_array_0.cell_1rw_25.q bank_0.replica_bitcell_array_0.bitcell_array_0.cell_1rw_25.qb 0.28699f
C562 control_logic_rw_0.delay_chain_0.out control_logic_rw_0.pand3_0.B 2.48633f
C563 bank_0.port_address_0.hierarchical_decoder_0.hierarchical_predecode2x4_1.pinv_1.Z a_739_3829# 0.01603f
C564 bank_0.replica_bitcell_array_0.replica_column_0.replica_cell_1rw_13.q bank_0.replica_bitcell_array_0.bitcell_array_0.cell_1rw_29.qb 0.02064f
C565 w_n5644_6180# control_logic_rw_0.delay_chain_0.pinv_11_29.Z 0.05137f
C566 control_logic_rw_0.delay_chain_0.pinv_11_7.Z w_n5644_7860# 0.20256f
C567 bank_0.replica_bitcell_array_0.wl_0_11 a_5461_9433# 0.05176f
C568 bank_0.replica_bitcell_array_0.dummy_array_2_0.dummy_cell_1rw_2.q bank_0.replica_bitcell_array_0.dummy_array_2_0.dummy_cell_1rw_2.qb 0.28699f
C569 bank_0.port_address_0.hierarchical_decoder_0.predecode_1 w_1141_7751# 0.02566f
C570 a_3103_7029# bank_0.port_address_0.wordline_driver_array_0.in_7 0.01304f
C571 control_logic_rw_0.delay_chain_0.pinv_11_5.Z w_n5644_7860# 0.19711f
C572 bank_0.port_address_0.hierarchical_decoder_0.predecode_3 bank_0.port_address_0.hierarchical_decoder_0.predecode_4 5.50661f
C573 control_logic_rw_0.pdriver_4_0.pinv_8_0.A control_logic_rw_0.p_en_bar 0.0875f
C574 a_5530_10637# bank_0.replica_bitcell_array_0.wl_0_14 0.04184f
C575 control_logic_rw_0.pinv_3_1.gnd a_n1822_n107# 0.01788f
C576 control_logic_rw_0.delay_chain_0.out a_n2402_1111# 0.01427f
C577 addr0[0] row_addr_dff_0.dff_3.clkb 0.30049f
C578 bank_0.replica_bitcell_array_0.dummy_array_2_0.dummy_cell_1rw_14.qb bank_0.replica_bitcell_array_0.replica_column_0.replica_cell_1rw_13.q 0.01651f
C579 control_logic_rw_0.dff_buf_array_0.dout_bar_0 control_logic_rw_0.dff_buf_array_0.dff_buf_0_0.pinv_0_0.A 0.14562f
C580 bank_0.replica_bitcell_array_0.dummy_array_3_0.dummy_cell_1rw_3.qb a_5530_10451# 0.0163f
C581 control_logic_rw_0.delay_chain_0.pinv_11_19.Z control_logic_rw_0.delay_chain_0.pinv_11_18.Z 0.18896f
C582 control_logic_rw_0.delay_chain_0.out w_n5644_4500# 0.33207f
C583 control_logic_rw_0.pdriver_1_0.pinv_8_0.A control_logic_rw_0.dff_buf_array_0.dout_bar_0 0.22563f
C584 bank_0.port_address_0.hierarchical_decoder_0.hierarchical_predecode2x4_0.pinv_1.Z w_1141_7751# 0.0212f
C585 a_4421_7397# bank_0.replica_bitcell_array_0.wl_0_7 0.05228f
C586 bank_0.replica_bitcell_array_0.wl_0_8 bank_0.replica_bitcell_array_0.dummy_array_3_0.dummy_cell_1rw_8.q 0.04136f
C587 control_logic_rw_0.delay_chain_0.pinv_11_5.Z control_logic_rw_0.delay_chain_0.out 0.04231f
C588 bank_0.replica_bitcell_array_0.dummy_array_2_0.dummy_cell_1rw_12.qb bank_0.replica_bitcell_array_0.replica_column_0.replica_cell_1rw_11.q 0.01651f
C589 bank_0.replica_bitcell_array_0.wl_0_15 bank_0.replica_bitcell_array_0.dummy_array_3_0.dummy_cell_1rw_1.qb 0.03696f
C590 control_logic_rw_0.delay_chain_0.out a_n2515_1111# 0.02086f
C591 control_logic_rw_0.delay_chain_0.pinv_11_35.Z a_n5422_3289# 0.0129f
C592 a_4421_7397# a_4490_7397# 0.06598f
C593 a_n2515_1923# control_logic_rw_0.pinv_3_0.vdd 0.01407f
C594 a_4421_4343# a_4490_4343# 0.06598f
C595 bank_0.replica_bitcell_array_0.replica_column_0.replica_cell_1rw_9.q bank_0.replica_bitcell_array_0.bitcell_array_0.cell_1rw_25.qb 0.02064f
C596 w_2422_10805# bank_0.replica_bitcell_array_0.wl_0_14 0.16398f
C597 a_5461_7397# a_5530_7397# 0.06598f
C598 a_n1685_705# control_logic_rw_0.pdriver_1_0.gnd 0.01158f
C599 control_logic_rw_0.dff_buf_array_0.dout_bar_0 a_n1822_123# 0.02719f
C600 control_logic_rw_0.delay_chain_0.pinv_11_19.Z control_logic_rw_0.delay_chain_0.pinv_11_15.Z 0.11884f
C601 bank_0.replica_bitcell_array_0.bitcell_array_0.cell_1rw_13.q bank_0.replica_bitcell_array_0.wl_0_2 0.04136f
C602 a_5270_3325# bank_0.replica_bitcell_array_0.dummy_array_0.dummy_cell_1rw_0.qb 0.0163f
C603 bank_0.port_address_0.hierarchical_decoder_0.predecode_6 control_logic_rw_0.wl_en 0.01162f
C604 a_5530_11469# bank_0.replica_bitcell_array_0.wl_0_15 0.04184f
C605 bank_0.replica_bitcell_array_0.bitcell_array_0.cell_1rw_26.qb bank_0.replica_bitcell_array_0.wl_0_5 0.03704f
C606 row_addr_dff_0.dff_1.net3 row_addr_dff_0.dff_1.net1 0.14299f
C607 a_4750_2493# bank_0.replica_bitcell_array_0.replica_column_0.dummy_cell_1rw_1.qb 0.0163f
C608 bank_0.port_address_0.hierarchical_decoder_0.hierarchical_predecode2x4_0.pinv_1.Z row_addr_dff_0.dout_3 0.55146f
C609 a_n987_n691# control_logic_rw_0.dff_buf_array_0.dout_bar_0 0.02257f
C610 bank_0.replica_bitcell_array_0.bitcell_array_0.cell_1rw_2.q bank_0.replica_bitcell_array_0.bitcell_array_0.cell_1rw_18.qb 0.01651f
C611 bank_0.replica_bitcell_array_0.bitcell_array_0.cell_1rw_2.qb bank_0.replica_bitcell_array_0.bitcell_array_0.cell_1rw_18.q 0.02064f
C612 control_logic_rw_0.dff_buf_array_0.dout_1 a_n3447_n513# 0.02363f
C613 control_logic_rw_0.delay_chain_0.pinv_11_28.Z control_logic_rw_0.delay_chain_0.pinv_11_29.Z 0.18896f
C614 a_5461_6379# bank_0.replica_bitcell_array_0.wl_0_5 0.05176f
C615 control_logic_rw_0.pinv_3_1.Z control_logic_rw_0.pdriver_0_0.pinv_4_0.A 0.01268f
C616 a_3103_10955# bank_0.port_address_0.wordline_driver_array_0.in_14 0.01304f
C617 w_n5644_4500# control_logic_rw_0.delay_chain_0.pinv_11_27.Z 0.20256f
C618 bank_0.replica_bitcell_array_0.rbl_wl_0_0 a_4490_3325# 0.04284f
C619 control_logic_rw_0.delay_chain_0.out control_logic_rw_0.dff_buf_array_0.dout_bar_0 3.43684f
C620 bank_0.port_address_0.wordline_driver_array_0.in_11 a_3103_9065# 0.01304f
C621 bank_0.replica_bitcell_array_0.wl_0_0 a_4490_3511# 0.04284f
C622 bank_0.replica_bitcell_array_0.dummy_array_2_0.dummy_cell_1rw_17.qb bank_0.replica_bitcell_array_0.replica_column_0.replica_cell_1rw_16.q 0.01651f
C623 bank_0.port_address_0.hierarchical_decoder_0.predecode_6 bank_0.port_address_0.hierarchical_decoder_0.predecode_5 5.31855f
C624 bank_0.replica_bitcell_array_0.bitcell_array_0.cell_1rw_4.qb bank_0.replica_bitcell_array_0.bitcell_array_0.cell_1rw_4.q 0.28699f
C625 a_4421_8415# a_4490_8415# 0.06598f
C626 a_n1900_123# control_logic_rw_0.dff_buf_array_0.dout_bar_0 0.02223f
C627 a_4490_10451# bank_0.replica_bitcell_array_0.wl_0_13 0.04284f
C628 bank_0.replica_bitcell_array_0.wl_0_4 a_4421_5547# 0.05228f
C629 web0 csb0 0.01007f
C630 bank_0.replica_bitcell_array_0.replica_column_0.replica_cell_1rw_10.q bank_0.replica_bitcell_array_0.wl_0_5 0.04211f
C631 row_addr_dff_0.dff_1.net4 row_addr_dff_0.dout_2 0.22531f
C632 bank_0.replica_bitcell_array_0.dummy_array_3_0.dummy_cell_1rw_6.qb bank_0.replica_bitcell_array_0.wl_0_10 0.03696f
C633 a_n909_n919# control_logic_rw_0.pdriver_0_0.gnd 0.01807f
C634 bank_0.replica_bitcell_array_0.bitcell_array_0.cell_1rw_29.qb bank_0.replica_bitcell_array_0.wl_0_2 0.03704f
C635 bank_0.port_address_0.wordline_driver_array_0.in_6 a_3103_6883# 0.01304f
C636 row_addr_dff_0.dff_1.net2 row_addr_dff_0.dff_3.clk 0.0716f
C637 a_4421_10637# bank_0.replica_bitcell_array_0.wl_0_14 0.05228f
C638 bank_0.replica_bitcell_array_0.dummy_array_1_0.dummy_cell_1rw_0.qb bank_0.replica_bitcell_array_0.dummy_array_1_0.dummy_cell_1rw_0.q 0.28699f
C639 bank_0.replica_bitcell_array_0.wl_0_7 a_5530_7397# 0.04184f
C640 row_addr_dff_0.dff_1.clkb row_addr_dff_0.dout_2 0.02004f
C641 a_n2515_299# control_logic_rw_0.dff_buf_array_0.dout_bar_0 0.0176f
C642 control_logic_rw_0.pinv_3_1.Z control_logic_rw_0.pand2_1.pnand2_0_0.nmos_m1_w0_840_sactive_dli_0.G 0.10256f
C643 bank_0.replica_bitcell_array_0.bitcell_array_0.cell_1rw_28.q bank_0.replica_bitcell_array_0.bitcell_array_0.cell_1rw_28.qb 0.28699f
C644 a_n5108_4821# control_logic_rw_0.delay_chain_0.pinv_11_31.Z 0.0129f
C645 bank_0.replica_bitcell_array_0.bitcell_array_0.cell_1rw_11.q bank_0.replica_bitcell_array_0.dummy_array_3_0.dummy_cell_1rw_12.qb 0.02064f
C646 bank_0.replica_bitcell_array_0.bitcell_array_0.cell_1rw_11.qb bank_0.replica_bitcell_array_0.dummy_array_3_0.dummy_cell_1rw_12.q 0.01651f
C647 bank_0.replica_bitcell_array_0.rbl_wl_0_0 bank_0.replica_bitcell_array_0.dummy_array_0.dummy_cell_1rw_0.qb 0.03696f
C648 a_5461_3325# a_5530_3325# 0.06598f
C649 bank_0.replica_bitcell_array_0.dummy_array_2_0.dummy_cell_1rw_14.qb bank_0.replica_bitcell_array_0.wl_0_2 0.03924f
C650 bank_0.replica_bitcell_array_0.bitcell_array_0.cell_1rw_0.qb bank_0.replica_bitcell_array_0.bitcell_array_0.cell_1rw_0.q 0.28699f
C651 control_logic_rw_0.pdriver_0_0.pinv_6_0.A control_logic_rw_0.dff_buf_array_0.dout_bar_0 0.22877f
C652 control_logic_rw_0.dff_buf_array_0.dout_bar_0 control_logic_rw_0.pdriver_1_0.pinv_8_0.Z 0.14361f
C653 w_2422_5715# bank_0.port_address_0.hierarchical_decoder_0.predecode_7 0.14845f
C654 bank_0.replica_bitcell_array_0.dummy_array_2_0.dummy_cell_1rw_13.q bank_0.replica_bitcell_array_0.wl_0_3 0.0474f
C655 bank_0.port_address_0.hierarchical_decoder_0.predecode_2 bank_0.port_address_0.hierarchical_decoder_0.predecode_3 5.37298f
C656 bank_0.replica_bitcell_array_0.wl_0_7 bank_0.replica_bitcell_array_0.wl_0_8 0.13236f
C657 control_logic_rw_0.pinv_3_1.gnd a_n2201_n255# 0.01604f
C658 a_3797_4847# bank_0.replica_bitcell_array_0.wl_0_2 0.01304f
C659 a_n4166_8181# control_logic_rw_0.delay_chain_0.pinv_11_14.Z 0.01702f
C660 control_logic_rw_0.delay_chain_0.pinv_11_8.Z w_n5644_7860# 0.20256f
C661 bank_0.replica_bitcell_array_0.dummy_array_0_0.dummy_cell_1rw_0.qb bank_0.replica_bitcell_array_0.dummy_array_3_0.dummy_cell_1rw_0.q 0.01651f
C662 control_logic_rw_0.delay_chain_0.pinv_11_25.Z control_logic_rw_0.delay_chain_0.pinv_11_29.Z 0.11884f
C663 bank_0.replica_bitcell_array_0.bitcell_array_0.cell_1rw_13.q bank_0.replica_bitcell_array_0.dummy_array_3_0.dummy_cell_1rw_14.qb 0.02064f
C664 bank_0.replica_bitcell_array_0.bitcell_array_0.cell_1rw_27.qb bank_0.replica_bitcell_array_0.bitcell_array_0.cell_1rw_27.q 0.28699f
C665 bank_0.replica_bitcell_array_0.dummy_array_0.dummy_cell_1rw_0.q bank_0.replica_bitcell_array_0.dummy_array_0.dummy_cell_1rw_1.qb 0.01651f
C666 control_logic_rw_0.dff_buf_array_0.dff_buf_0_1.pinv_0_0.A control_logic_rw_0.dff_buf_array_0.dff_buf_0_1.dff_0.net5 0.07645f
C667 bank_0.replica_bitcell_array_0.replica_column_0.replica_cell_1rw_7.q bank_0.replica_bitcell_array_0.wl_0_8 0.04211f
C668 bank_0.replica_bitcell_array_0.dummy_array_3_0.dummy_cell_1rw_8.qb a_5530_7583# 0.0163f
C669 w_2422_10805# bank_0.port_address_0.wordline_driver_array_0.in_14 0.14989f
C670 control_logic_rw_0.pinv_3_1.Z a_n2461_n513# 0.01319f
C671 control_logic_rw_0.delay_chain_0.pinv_11_44.Z control_logic_rw_0.delay_chain_0.pinv_11_39.Z 0.36079f
C672 control_logic_rw_0.delay_chain_0.pinv_11_40.Z control_logic_rw_0.delay_chain_0.pinv_11_44.Z 0.11884f
C673 control_logic_rw_0.delay_chain_0.pinv_11_29.Z control_logic_rw_0.delay_chain_0.pinv_11_26.Z 0.14222f
C674 bank_0.replica_bitcell_array_0.dummy_array_2_0.dummy_cell_1rw_11.qb bank_0.replica_bitcell_array_0.wl_0_5 0.03923f
C675 bank_0.replica_bitcell_array_0.wl_0_9 bank_0.replica_bitcell_array_0.bitcell_array_0.cell_1rw_6.qb 0.03696f
C676 bank_0.port_address_0.hierarchical_decoder_0.predecode_1 w_1141_4697# 0.02224f
C677 bank_0.replica_bitcell_array_0.wl_0_1 a_5530_4343# 0.04184f
C678 a_n3525_n227# control_logic_rw_0.dff_buf_array_0.dff_buf_0_0.pinv_1_0.gnd 0.011f
C679 bank_0.replica_bitcell_array_0.bitcell_array_0.cell_1rw_22.qb bank_0.replica_bitcell_array_0.bitcell_array_0.cell_1rw_22.q 0.28699f
C680 bank_0.replica_bitcell_array_0.dummy_array_3_0.dummy_cell_1rw_11.qb a_5530_6379# 0.0163f
C681 control_logic_rw_0.dff_buf_array_0.dout_1 control_logic_rw_0.pand3_0_0.pnand3_0_0.nmos_m1_w0_840_sactive_dli_0.G 0.08565f
C682 control_logic_rw_0.pinv_3_0.vdd a_n2515_1775# 0.01408f
C683 bank_0.port_address_0.wordline_driver_array_0.in_3 control_logic_rw_0.wl_en 0.18688f
C684 bank_0.port_address_0.hierarchical_decoder_0.predecode_0 bank_0.port_address_0.hierarchical_decoder_0.predecode_3 0.49995f
C685 a_n2402_1923# control_logic_rw_0.pinv_3_0.vdd 0.01484f
C686 bank_0.replica_bitcell_array_0.bitcell_array_0.cell_1rw_26.qb bank_0.replica_bitcell_array_0.bitcell_array_0.cell_1rw_26.q 0.28699f
C687 bank_0.replica_bitcell_array_0.rbl_wl_0_0 w_3116_2703# 0.16341f
C688 control_logic_rw_0.delay_chain_0.out a_n1919_927# 0.02856f
C689 w_1141_6733# bank_0.port_address_0.hierarchical_decoder_0.predecode_4 0.15163f
C690 bank_0.replica_bitcell_array_0.dummy_array_3_0.dummy_cell_1rw_2.q bank_0.replica_bitcell_array_0.wl_0_14 0.04136f
C691 bank_0.replica_bitcell_array_0.rbl_wl_0_0 bank_0.replica_bitcell_array_0.dummy_array_2_0.dummy_cell_1rw_17.qb 0.03923f
C692 a_n1221_298# control_logic_rw_0.dff_buf_array_0.dout_bar_0 0.02157f
C693 data_dff_0.dff_0.clkb data_dff_0.dff_0.net3 0.14179f
C694 bank_0.replica_bitcell_array_0.replica_column_0.replica_cell_1rw_5.q bank_0.replica_bitcell_array_0.wl_0_10 0.04211f
C695 a_4421_4529# bank_0.replica_bitcell_array_0.wl_0_2 0.05228f
C696 control_logic_rw_0.pand3_0.B control_logic_rw_0.dff_buf_array_0.dout_bar_0 1.12586f
C697 control_logic_rw_0.dff_buf_array_0.dout_bar_0 a_n1666_123# 0.02775f
C698 a_n1143_n691# control_logic_rw_0.dff_buf_array_0.dout_bar_0 0.02357f
C699 a_n2147_299# control_logic_rw_0.pdriver_1_0.pinv_8_0.Z 0.0132f
C700 control_logic_rw_0.pand3_0.pnand3_0_0.nmos_m1_w0_840_sactive_dactive_0.S control_logic_rw_0.pdriver_1_0.gnd 0.01436f
C701 a_n2461_299# control_logic_rw_0.dff_buf_array_0.dout_bar_0 0.01116f
C702 control_logic_rw_0.dff_buf_array_0.dout_1 a_n3369_n227# 0.01427f
C703 bank_0.replica_bitcell_array_0.bitcell_array_0.cell_1rw_6.qb bank_0.replica_bitcell_array_0.bitcell_array_0.cell_1rw_6.q 0.28699f
C704 control_logic_rw_0.delay_chain_0.pinv_11_10.Z a_n5422_8181# 0.0129f
C705 w_n4225_n767# control_logic_rw_0.dff_buf_array_0.dff_buf_0_0.pinv_1_0.gnd 0.0447f
C706 bank_0.replica_bitcell_array_0.dummy_array_2_0.dummy_cell_1rw_18.qb bank_0.replica_bitcell_array_0.dummy_array_2_0.dummy_cell_1rw_18.q 0.28699f
C707 bank_0.replica_bitcell_array_0.dummy_array_2_0.dummy_cell_1rw_5.q a_4421_9433# 0.01645f
C708 bank_0.port_address_0.hierarchical_decoder_0.predecode_2 bank_0.port_address_0.hierarchical_decoder_0.predecode_4 0.46735f
C709 w_n5644_9540# control_logic_rw_0.delay_chain_0.pinv_11_9.Z 0.05233f
C710 a_5461_11655# a_5530_11655# 0.06598f
C711 a_n831_n691# control_logic_rw_0.dff_buf_array_0.dout_bar_0 0.02257f
C712 control_logic_rw_0.dff_buf_array_0.dff_buf_0_1.pinv_0_0.A control_logic_rw_0.dff_buf_array_0.dff_buf_0_0.pinv_0_0.A 0.12486f
C713 bank_0.replica_bitcell_array_0.wl_0_9 a_5461_8415# 0.05176f
C714 a_n4794_6501# control_logic_rw_0.delay_chain_0.pinv_11_22.Z 0.0129f
C715 bank_0.port_address_0.wordline_driver_array_0.in_1 a_3103_3975# 0.01304f
C716 bank_0.replica_bitcell_array_0.wl_0_9 w_2422_7751# 0.16341f
C717 bank_0.replica_bitcell_array_0.rbl_wl_0_0 a_5010_3325# 0.04284f
C718 bank_0.replica_bitcell_array_0.bitcell_array_0.cell_1rw_0.qb bank_0.replica_bitcell_array_0.wl_0_15 0.03696f
C719 row_addr_dff_0.dout_1 bank_0.port_address_0.hierarchical_decoder_0.hierarchical_predecode2x4_1.pinv_0.Z 0.21541f
C720 bank_0.replica_bitcell_array_0.dummy_array_3_0.dummy_cell_1rw_6.q a_5461_8601# 0.01645f
C721 bank_0.replica_bitcell_array_0.bitcell_array_0.cell_1rw_24.qb bank_0.replica_bitcell_array_0.bitcell_array_0.cell_1rw_24.q 0.28699f
C722 a_3797_9937# bank_0.replica_bitcell_array_0.wl_0_12 0.01304f
C723 control_logic_rw_0.delay_chain_0.out a_n2461_963# 0.01216f
C724 w_n5644_9540# control_logic_rw_0.delay_chain_0.pinv_11_2.Z 0.20256f
C725 a_n2051_1923# control_logic_rw_0.pinv_3_0.vdd 0.01403f
C726 bank_0.replica_bitcell_array_0.wl_0_2 a_5461_4529# 0.05176f
C727 bank_0.replica_bitcell_array_0.bitcell_array_0.cell_1rw_29.qb bank_0.replica_bitcell_array_0.bitcell_array_0.cell_1rw_29.q 0.28699f
C728 a_4490_6565# bank_0.replica_bitcell_array_0.dummy_array_2_0.dummy_cell_1rw_10.qb 0.0163f
C729 control_logic_rw_0.dff_buf_array_0.dff_buf_0_1.dff_0.net4 control_logic_rw_0.dff_buf_array_0.dff_buf_0_1.dff_0.clkb 0.08731f
C730 control_logic_rw_0.dff_buf_array_0.dff_buf_0_1.dff_0.net1 control_logic_rw_0.dff_buf_array_0.dff_buf_0_1.dff_0.net3 0.14299f
C731 a_3797_4993# bank_0.replica_bitcell_array_0.wl_0_3 0.01304f
C732 bank_0.replica_bitcell_array_0.wl_0_4 bank_0.replica_bitcell_array_0.wl_0_5 0.03867f
C733 bank_0.replica_bitcell_array_0.wl_0_15 a_5461_11469# 0.05176f
C734 a_5461_10637# bank_0.replica_bitcell_array_0.wl_0_14 0.05176f
C735 a_5461_7397# bank_0.replica_bitcell_array_0.dummy_array_3_0.dummy_cell_1rw_9.q 0.01645f
C736 bank_0.replica_bitcell_array_0.dummy_array_3_0.dummy_cell_1rw_8.q a_5461_7583# 0.01645f
C737 control_logic_rw_0.pinv_3_1.gnd a_n1666_n107# 0.01788f
C738 bank_0.replica_bitcell_array_0.dummy_array_1_0.dummy_cell_1rw_0.q bank_0.replica_bitcell_array_0.dummy_array_3_0.dummy_cell_1rw_18.qb 0.02064f
C739 a_4421_5361# a_4490_5361# 0.06598f
C740 bank_0.port_address_0.hierarchical_decoder_0.predecode_0 bank_0.port_address_0.hierarchical_decoder_0.predecode_4 0.5146f
C741 a_5530_6565# bank_0.replica_bitcell_array_0.dummy_array_3_0.dummy_cell_1rw_10.qb 0.0163f
C742 row_addr_dff_0.dout_2 w_431_6733# 0.09792f
C743 a_3797_3975# bank_0.replica_bitcell_array_0.wl_0_1 0.01304f
C744 a_3103_4847# bank_0.port_address_0.wordline_driver_array_0.in_2 0.01304f
C745 bank_0.replica_bitcell_array_0.bitcell_array_0.cell_1rw_12.qb bank_0.replica_bitcell_array_0.bitcell_array_0.cell_1rw_12.q 0.28699f
C746 control_logic_rw_0.delay_chain_0.pinv_11_35.Z w_n5644_2820# 0.19711f
C747 bank_0.replica_bitcell_array_0.bitcell_array_0.cell_1rw_19.qb bank_0.replica_bitcell_array_0.bitcell_array_0.cell_1rw_19.q 0.28699f
C748 bank_0.replica_bitcell_array_0.wl_0_12 a_5530_9619# 0.04184f
C749 control_logic_rw_0.delay_chain_0.out control_logic_rw_0.delay_chain_0.pinv_11_29.Z 0.10996f
C750 bank_0.replica_bitcell_array_0.bitcell_array_0.cell_1rw_31.qb bank_0.replica_bitcell_array_0.wl_0_0 0.03704f
C751 bank_0.replica_bitcell_array_0.dummy_array_3_0.dummy_cell_1rw_10.q bank_0.replica_bitcell_array_0.dummy_array_3_0.dummy_cell_1rw_10.qb 0.28699f
C752 a_5530_9619# bank_0.replica_bitcell_array_0.dummy_array_3_0.dummy_cell_1rw_4.qb 0.0163f
C753 bank_0.replica_bitcell_array_0.replica_column_0.replica_cell_1rw_14.q bank_0.replica_bitcell_array_0.bitcell_array_0.cell_1rw_30.qb 0.02064f
C754 control_logic_rw_0.pdriver_1_0.pinv_8_0.A control_logic_rw_0.pdriver_1_0.gnd 0.16606f
C755 control_logic_rw_0.pinv_3_1.gnd a_n2110_n107# 0.01105f
C756 a_n1567_n919# control_logic_rw_0.pdriver_0_0.pinv_7_0.A 0.01641f
C757 a_4421_2493# bank_0.replica_bitcell_array_0.dummy_array_2_0.dummy_cell_1rw_18.q 0.01645f
C758 control_logic_rw_0.dff_buf_array_0.dff_buf_0_1.dff_0.clkb control_logic_rw_0.dff_buf_array_0.dff_buf_0_0.dff_0.clkb 0.01354f
C759 a_4490_2493# bank_0.replica_bitcell_array_0.dummy_array_2_0.dummy_cell_1rw_18.qb 0.0163f
C760 w_2422_3679# control_logic_rw_0.wl_en 0.29944f
C761 bank_0.port_address_0.hierarchical_decoder_0.predecode_5 bank_0.port_address_0.hierarchical_decoder_0.predecode_1 0.45309f
C762 w_2422_4697# bank_0.replica_bitcell_array_0.wl_0_2 0.16398f
C763 row_addr_dff_0.dff_1.net5 row_addr_dff_0.dff_3.clk 0.03761f
C764 bank_0.replica_bitcell_array_0.dummy_array_2_0.dummy_cell_1rw_14.qb bank_0.replica_bitcell_array_0.dummy_array_2_0.dummy_cell_1rw_14.q 0.28699f
C765 control_logic_rw_0.delay_chain_0.pinv_11_7.Z a_n4794_8329# 0.0129f
C766 a_n3525_n919# control_logic_rw_0.dff_buf_array_0.dout_0 0.01986f
C767 control_logic_rw_0.delay_chain_0.out control_logic_rw_0.pnand2_1_0.nmos_m1_w0_840_sactive_dli_0.S 0.02539f
C768 bank_0.replica_bitcell_array_0.replica_column_0.dummy_cell_1rw_1.q bank_0.replica_bitcell_array_0.dummy_array_2_0.dummy_cell_1rw_18.qb 0.01651f
C769 bank_0.port_address_0.wordline_driver_array_0.in_7 bank_0.port_address_0.wordline_driver_array_0.in_8 0.01362f
C770 bank_0.replica_bitcell_array_0.bitcell_array_0.cell_1rw_16.q bank_0.replica_bitcell_array_0.bitcell_array_0.cell_1rw_0.qb 0.02064f
C771 bank_0.replica_bitcell_array_0.wl_0_8 bank_0.replica_bitcell_array_0.dummy_array_3_0.dummy_cell_1rw_8.qb 0.03696f
C772 control_logic_rw_0.delay_chain_0.pinv_11_29.Z control_logic_rw_0.delay_chain_0.pinv_11_27.Z 0.14286f
C773 control_logic_rw_0.delay_chain_0.pinv_11_24.Z control_logic_rw_0.delay_chain_0.pinv_11_29.Z 0.4357f
C774 w_2422_8769# control_logic_rw_0.wl_en 0.29624f
C775 control_logic_rw_0.delay_chain_0.out control_logic_rw_0.delay_chain_0.pinv_11_39.Z 0.10996f
C776 control_logic_rw_0.delay_chain_0.pinv_11_20.Z w_n5644_6180# 0.19711f
C777 control_logic_rw_0.delay_chain_0.out control_logic_rw_0.delay_chain_0.pinv_11_40.Z 0.04231f
C778 data_dff_0.dff_0.clkb data_dff_0.dff_0.net4 0.08731f
C779 bank_0.replica_bitcell_array_0.dummy_array_2_0.dummy_cell_1rw_12.qb bank_0.replica_bitcell_array_0.dummy_array_2_0.dummy_cell_1rw_12.q 0.28699f
C780 control_logic_rw_0.delay_chain_0.pinv_11_43.Z w_n5644_2820# 0.20256f
C781 bank_0.replica_bitcell_array_0.wl_0_15 bank_0.replica_bitcell_array_0.bitcell_array_0.cell_1rw_0.q 0.04136f
C782 w_2422_8769# bank_0.port_address_0.wordline_driver_array_0.in_11 0.14946f
C783 a_5461_5361# bank_0.replica_bitcell_array_0.dummy_array_3_0.dummy_cell_1rw_13.q 0.01645f
C784 bank_0.replica_bitcell_array_0.wl_0_7 bank_0.replica_bitcell_array_0.dummy_array_3_0.dummy_cell_1rw_9.q 0.04136f
C785 w_2422_10805# bank_0.port_address_0.hierarchical_decoder_0.predecode_6 0.03007f
C786 bank_0.replica_bitcell_array_0.dummy_array_2_0.dummy_cell_1rw_12.qb a_4490_5547# 0.0163f
C787 control_logic_rw_0.pand2_0.pnand2_0_0.nmos_m1_w0_840_sactive_dli_0.S control_logic_rw_0.dff_buf_array_0.dout_bar_0 0.01236f
C788 control_logic_rw_0.delay_chain_0.pinv_11_32.Z a_n4794_4821# 0.0129f
C789 bank_0.port_address_0.hierarchical_decoder_0.predecode_7 w_1141_7751# 0.24541f
C790 a_n1196_n513# control_logic_rw_0.dff_buf_array_0.dout_bar_0 0.05297f
C791 a_n3579_n689# control_logic_rw_0.dff_buf_array_0.dff_buf_0_1.pinv_1_0.vdd 0.0184f
C792 bank_0.replica_bitcell_array_0.wl_0_8 a_4490_7583# 0.04284f
C793 a_4681_2493# a_4750_2493# 0.06598f
C794 bank_0.replica_bitcell_array_0.rbl_wl_0_0 bank_0.replica_bitcell_array_0.dummy_array_0.dummy_cell_1rw_1.q 0.04155f
C795 control_logic_rw_0.delay_chain_0.pinv_11_21.Z control_logic_rw_0.delay_chain_0.pinv_11_22.Z 0.04321f
C796 row_addr_dff_0.dout_1 row_addr_dff_0.dff_2.clkb 0.02004f
C797 a_5530_10451# bank_0.replica_bitcell_array_0.wl_0_13 0.04184f
C798 addr0[2] addr0[3] 0.98588f
C799 a_n4480_9861# control_logic_rw_0.delay_chain_0.pinv_11_3.Z 0.0129f
C800 w_n4225_n767# control_logic_rw_0.dff_buf_array_0.dff_buf_0_0.pinv_0_0.A 0.13968f
C801 control_logic_rw_0.delay_chain_0.pinv_11_7.Z control_logic_rw_0.delay_chain_0.pinv_11_8.Z 0.04321f
C802 control_logic_rw_0.delay_chain_0.out control_logic_rw_0.pdriver_1_0.gnd 0.02258f
C803 w_2422_6733# bank_0.port_address_0.hierarchical_decoder_0.predecode_7 0.14917f
C804 control_logic_rw_0.pand2_0.pnand2_0_0.nmos_m1_w0_840_sactive_dli_0.G control_logic_rw_0.dff_buf_array_0.dout_bar_0 0.10769f
C805 data_dff_0.dff_0.net3 data_dff_0.dff_0.net1 0.14299f
C806 a_3797_7901# bank_0.replica_bitcell_array_0.wl_0_8 0.01304f
C807 bank_0.replica_bitcell_array_0.bitcell_array_0.cell_1rw_15.qb bank_0.replica_bitcell_array_0.bitcell_array_0.cell_1rw_15.q 0.28699f
C808 bank_0.replica_bitcell_array_0.bitcell_array_0.cell_1rw_21.q bank_0.replica_bitcell_array_0.wl_0_10 0.04155f
C809 control_logic_rw_0.delay_chain_0.out a_n1763_927# 0.02847f
C810 bank_0.port_address_0.hierarchical_decoder_0.hierarchical_predecode2x4_0.pinv_1.Z row_addr_dff_0.dout_2 0.28914f
C811 a_3797_8919# bank_0.replica_bitcell_array_0.wl_0_10 0.01304f
C812 clk0 control_logic_rw_0.pdriver_0_0.gnd 0.04984f
C813 control_logic_rw_0.pinv_3_1.gnd a_n1796_n227# 0.01105f
C814 control_logic_rw_0.pdriver_0_0.gnd control_logic_rw_0.pdriver_0_0.pinv_4_0.A 0.18155f
C815 bank_0.replica_bitcell_array_0.replica_column_0.replica_cell_1rw_15.q bank_0.replica_bitcell_array_0.dummy_array_2_0.dummy_cell_1rw_16.qb 0.01651f
C816 row_addr_dff_0.dout_1 row_addr_dff_0.dff_2.net5 0.08478f
C817 a_n1430_n227# control_logic_rw_0.dff_buf_array_0.dout_bar_0 0.023f
C818 bank_0.replica_bitcell_array_0.wl_0_9 bank_0.replica_bitcell_array_0.dummy_array_2_0.dummy_cell_1rw_7.qb 0.03923f
C819 bank_0.replica_bitcell_array_0.dummy_array_3_0.dummy_cell_1rw_8.q bank_0.replica_bitcell_array_0.bitcell_array_0.cell_1rw_7.qb 0.01651f
C820 bank_0.replica_bitcell_array_0.dummy_array_3_0.dummy_cell_1rw_8.qb bank_0.replica_bitcell_array_0.bitcell_array_0.cell_1rw_7.q 0.02064f
C821 bank_0.replica_bitcell_array_0.wl_0_7 bank_0.replica_bitcell_array_0.dummy_array_3_0.dummy_cell_1rw_9.qb 0.03696f
C822 control_logic_rw_0.pand2_0.Z a_n1588_123# 0.03184f
C823 bank_0.replica_bitcell_array_0.replica_column_0.replica_cell_1rw_14.q bank_0.replica_bitcell_array_0.dummy_array_2_0.dummy_cell_1rw_15.qb 0.01651f
C824 a_4421_4529# bank_0.replica_bitcell_array_0.dummy_array_2_0.dummy_cell_1rw_14.q 0.01645f
C825 w_1141_6733# bank_0.port_address_0.hierarchical_decoder_0.predecode_0 0.15028f
C826 bank_0.replica_bitcell_array_0.bitcell_array_0.cell_1rw_24.q bank_0.replica_bitcell_array_0.bitcell_array_0.cell_1rw_8.qb 0.02064f
C827 a_5461_8601# a_5530_8601# 0.06598f
C828 w_2422_9787# bank_0.replica_bitcell_array_0.wl_0_13 0.16341f
C829 bank_0.replica_bitcell_array_0.dummy_array_0.dummy_cell_1rw_0.qb bank_0.replica_bitcell_array_0.dummy_array_0.dummy_cell_1rw_0.q 0.28699f
C830 control_logic_rw_0.p_en_bar control_logic_rw_0.wl_en 1.36682f
C831 a_4421_2493# a_4490_2493# 0.06598f
C832 row_addr_dff_0.dff_2.net5 row_addr_dff_0.dff_2.clkb 0.03696f
C833 bank_0.replica_bitcell_array_0.bitcell_array_0.cell_1rw_27.qb bank_0.replica_bitcell_array_0.bitcell_array_0.cell_1rw_11.q 0.01651f
C834 bank_0.replica_bitcell_array_0.bitcell_array_0.cell_1rw_27.q bank_0.replica_bitcell_array_0.bitcell_array_0.cell_1rw_11.qb 0.02064f
C835 control_logic_rw_0.dff_buf_array_0.dout_1 control_logic_rw_0.pand3_0_0.gnd 0.11187f
C836 bank_0.port_address_0.wordline_driver_array_0.in_9 control_logic_rw_0.wl_en 0.18688f
C837 control_logic_rw_0.delay_chain_0.pinv_11_2.Z control_logic_rw_0.delay_chain_0.pinv_11_3.Z 0.04321f
C838 bank_0.port_address_0.hierarchical_decoder_0.predecode_2 bank_0.port_address_0.hierarchical_decoder_0.predecode_0 0.22779f
C839 bank_0.port_address_0.wordline_driver_array_0.in_12 a_3103_9937# 0.01304f
C840 w_n4225_n767# control_logic_rw_0.delay_chain_0.out 0.053f
C841 control_logic_rw_0.pand2_0.Z a_n1900_n107# 0.02082f
C842 control_logic_rw_0.pdriver_1_0.gnd control_logic_rw_0.pdriver_1_0.pinv_8_0.Z 0.12549f
C843 addr0[0] addr0[3] 0.01778f
C844 bank_0.replica_bitcell_array_0.dummy_array_2_0.dummy_cell_1rw_8.qb bank_0.replica_bitcell_array_0.replica_column_0.replica_cell_1rw_7.q 0.01651f
C845 bank_0.replica_bitcell_array_0.replica_column_0.replica_cell_1rw_2.q bank_0.replica_bitcell_array_0.wl_0_13 0.04211f
C846 w_n5644_2820# control_logic_rw_0.delay_chain_0.pinv_11_37.Z 0.20256f
C847 bank_0.replica_bitcell_array_0.dummy_array_2_0.dummy_cell_1rw_11.q bank_0.replica_bitcell_array_0.wl_0_5 0.0474f
C848 a_1822_4847# bank_0.port_address_0.hierarchical_decoder_0.predecode_2 0.01459f
C849 bank_0.replica_bitcell_array_0.wl_0_4 a_5530_5547# 0.04184f
C850 w_1141_6733# bank_0.port_address_0.hierarchical_decoder_0.hierarchical_predecode2x4_0.pinv_0.Z 0.29388f
C851 a_4421_7583# a_4490_7583# 0.06598f
C852 bank_0.replica_bitcell_array_0.dummy_array_2_0.dummy_cell_1rw_4.qb a_4490_9619# 0.0163f
C853 control_logic_rw_0.pinv_3_1.gnd a_n1510_n107# 0.01796f
C854 bank_0.port_address_0.wordline_driver_array_0.in_1 control_logic_rw_0.wl_en 0.18735f
C855 bank_0.replica_bitcell_array_0.wl_0_14 bank_0.replica_bitcell_array_0.wl_0_13 0.13236f
C856 control_logic_rw_0.delay_chain_0.out a_n4166_9861# 0.0141f
C857 control_logic_rw_0.delay_chain_0.pinv_11_36.Z w_n5644_2820# 0.20256f
C858 a_n3917_n513# control_logic_rw_0.dff_buf_array_0.dff_buf_0_1.pinv_1_0.vdd 0.01857f
C859 a_5201_3325# a_5270_3325# 0.06598f
C860 row_addr_dff_0.dff_2.net2 row_addr_dff_0.dff_2.clkb 0.07662f
C861 bank_0.port_address_0.hierarchical_decoder_0.predecode_3 w_2422_4697# 0.0453f
C862 w_n5644_4500# control_logic_rw_0.delay_chain_0.pinv_11_29.Z 0.75262f
C863 control_logic_rw_0.pinv_3_1.gnd control_logic_rw_0.dff_buf_array_0.dout_bar_0 1.00887f
C864 bank_0.replica_bitcell_array_0.dummy_array_2_0.dummy_cell_1rw_12.q a_4421_5547# 0.01645f
C865 a_5530_5361# bank_0.replica_bitcell_array_0.dummy_array_3_0.dummy_cell_1rw_13.qb 0.0163f
C866 control_logic_rw_0.dff_buf_array_0.dout_bar_0 a_n2461_963# 0.021f
C867 control_logic_rw_0.delay_chain_0.pinv_11_11.Z control_logic_rw_0.delay_chain_0.pinv_11_14.Z 0.14303f
C868 a_n1664_n227# control_logic_rw_0.dff_buf_array_0.dout_bar_0 0.01211f
C869 control_logic_rw_0.pinv_3_1.gnd a_n1978_n107# 0.0179f
C870 a_4421_5547# a_4490_5547# 0.06598f
C871 w_n2769_44# control_logic_rw_0.pdriver_1_0.pinv_6_0.A 0.20256f
C872 bank_0.replica_bitcell_array_0.dummy_array_2_0.dummy_cell_1rw_8.q bank_0.replica_bitcell_array_0.wl_0_8 0.04741f
C873 a_4421_9433# bank_0.replica_bitcell_array_0.wl_0_11 0.05228f
C874 a_n1431_298# control_logic_rw_0.dff_buf_array_0.dout_bar_0 0.01757f
C875 control_logic_rw_0.delay_chain_0.out control_logic_rw_0.delay_chain_0.pinv_11_1.Z 0.14475f
C876 w_n2769_n767# control_logic_rw_0.pdriver_0_0.pinv_7_0.A 0.27988f
C877 row_addr_dff_0.dff_1.net5 row_addr_dff_0.dout_2 0.08417f
C878 a_n4480_6649# control_logic_rw_0.delay_chain_0.pinv_11_18.Z 0.0129f
C879 row_addr_dff_0.dout_3 w_1141_7751# 0.42366f
C880 control_logic_rw_0.pand3_0.B control_logic_rw_0.pdriver_1_0.gnd 0.01541f
C881 bank_0.replica_bitcell_array_0.dummy_array_3_0.dummy_cell_1rw_15.q a_5461_4343# 0.01645f
C882 control_logic_rw_0.delay_chain_0.pinv_11_21.Z w_n5644_6180# 0.20256f
C883 data_dff_0.dff_1.clkb data_dff_0.dff_1.net3 0.14179f
C884 bank_0.replica_bitcell_array_0.wl_0_1 bank_0.replica_bitcell_array_0.dummy_array_2_0.dummy_cell_1rw_15.q 0.0474f
C885 control_logic_rw_0.pdriver_1_0.pinv_6_0.A a_n1801_299# 0.01899f
C886 a_n4166_6501# control_logic_rw_0.delay_chain_0.pinv_11_24.Z 0.01702f
C887 bank_0.replica_bitcell_array_0.wl_0_12 a_4490_9619# 0.04284f
C888 a_n1796_n513# control_logic_rw_0.dff_buf_array_0.dout_bar_0 0.02729f
C889 control_logic_rw_0.dff_buf_array_0.dff_buf_0_1.pinv_0_0.A control_logic_rw_0.dff_buf_array_0.dout_bar_0 0.14549f
C890 a_n1855_299# control_logic_rw_0.dff_buf_array_0.dout_bar_0 0.01403f
C891 w_n5644_4500# control_logic_rw_0.delay_chain_0.pinv_11_39.Z 0.05137f
C892 w_n5644_2820# control_logic_rw_0.delay_chain_0.pinv_11_41.Z 0.20256f
C893 bank_0.replica_bitcell_array_0.wl_0_1 bank_0.replica_bitcell_array_0.bitcell_array_0.cell_1rw_14.q 0.04136f
C894 control_logic_rw_0.pand2_0.pnand2_0_0.nmos_m1_w0_840_sactive_dli_0.S control_logic_rw_0.pinv_3_1.gnd 0.01443f
C895 bank_0.replica_bitcell_array_0.dummy_array_2_0.dummy_cell_1rw_7.qb bank_0.replica_bitcell_array_0.dummy_array_2_0.dummy_cell_1rw_7.q 0.28699f
C896 a_n2069_n661# control_logic_rw_0.dff_buf_array_0.dout_bar_0 0.01481f
C897 a_n3525_n919# control_logic_rw_0.dff_buf_array_0.dff_buf_0_1.pinv_1_0.gnd 0.011f
C898 bank_0.replica_bitcell_array_0.bitcell_array_0.cell_1rw_29.qb bank_0.replica_bitcell_array_0.bitcell_array_0.cell_1rw_13.q 0.01651f
C899 bank_0.port_address_0.wordline_driver_array_0.in_12 bank_0.port_address_0.wordline_driver_array_0.in_13 0.01302f
C900 bank_0.replica_bitcell_array_0.bitcell_array_0.cell_1rw_2.qb bank_0.replica_bitcell_array_0.bitcell_array_0.cell_1rw_2.q 0.28699f
C901 control_logic_rw_0.delay_chain_0.out a_n1607_927# 0.0288f
C902 control_logic_rw_0.pinv_3_1.gnd control_logic_rw_0.pand2_0.pnand2_0_0.nmos_m1_w0_840_sactive_dli_0.G 0.01024f
C903 control_logic_rw_0.delay_chain_0.pinv_11_16.Z control_logic_rw_0.delay_chain_0.pinv_11_17.Z 0.04321f
C904 addr0[0] row_addr_dff_0.dff_3.net1 0.08197f
C905 a_5201_3325# bank_0.replica_bitcell_array_0.rbl_wl_0_0 0.05224f
C906 bank_0.replica_bitcell_array_0.bitcell_array_0.cell_1rw_22.qb bank_0.replica_bitcell_array_0.replica_column_0.replica_cell_1rw_6.q 0.02064f
C907 control_logic_rw_0.delay_chain_0.pinv_11_9.Z a_n4166_8329# 0.01414f
C908 bank_0.replica_bitcell_array_0.dummy_array_3_0.dummy_cell_1rw_11.q bank_0.replica_bitcell_array_0.wl_0_5 0.04136f
C909 a_4421_9619# a_4490_9619# 0.06598f
C910 bank_0.replica_bitcell_array_0.bitcell_array_0.cell_1rw_9.qb bank_0.replica_bitcell_array_0.bitcell_array_0.cell_1rw_9.q 0.28699f
C911 w_2422_4697# bank_0.port_address_0.hierarchical_decoder_0.predecode_4 0.29931f
C912 bank_0.replica_bitcell_array_0.bitcell_array_0.cell_1rw_16.q bank_0.replica_bitcell_array_0.wl_0_15 0.04155f
C913 w_2422_5715# control_logic_rw_0.wl_en 0.29624f
C914 a_n1274_n227# control_logic_rw_0.dff_buf_array_0.dout_bar_0 0.01931f
C915 row_addr_dff_0.dff_2.net3 row_addr_dff_0.dff_2.net1 0.14299f
C916 bank_0.port_address_0.hierarchical_decoder_0.predecode_0 w_2422_7751# 0.0212f
C917 bank_0.replica_bitcell_array_0.replica_column_0.replica_cell_1rw_10.q bank_0.replica_bitcell_array_0.bitcell_array_0.cell_1rw_26.qb 0.02064f
C918 bank_0.port_address_0.wordline_driver_array_0.in_2 w_2422_4697# 0.14989f
C919 control_logic_rw_0.pinv_3_1.gnd a_n1430_n227# 0.01066f
C920 control_logic_rw_0.delay_chain_0.pinv_11_15.Z a_n5422_6649# 0.0129f
C921 control_logic_rw_0.pand2_0.Z a_n1432_123# 0.01862f
C922 w_n4225_n767# control_logic_rw_0.pand3_0.B 0.11916f
C923 a_n3369_n689# control_logic_rw_0.dff_buf_array_0.dff_buf_0_1.pinv_1_0.vdd 0.01281f
C924 bank_0.replica_bitcell_array_0.dummy_array_0_0.dummy_cell_1rw_0.qb bank_0.replica_bitcell_array_0.dummy_array_0_0.dummy_cell_1rw_0.q 0.28699f
C925 a_n4166_6649# control_logic_rw_0.delay_chain_0.pinv_11_19.Z 0.01414f
C926 w_2422_6733# bank_0.replica_bitcell_array_0.wl_0_6 0.16398f
C927 control_logic_rw_0.pand3_0.pnand3_0_0.nmos_m1_w0_840_sactive_dactive_0.D control_logic_rw_0.dff_buf_array_0.dout_bar_0 0.01001f
C928 bank_0.replica_bitcell_array_0.dummy_array_2_0.dummy_cell_1rw_8.q a_4421_7583# 0.01645f
C929 a_n2461_151# control_logic_rw_0.dff_buf_array_0.dout_bar_0 0.02303f
C930 data_dff_0.dff_1.clkb din0[0] 0.31952f
C931 control_logic_rw_0.delay_chain_0.out control_logic_rw_0.delay_chain_0.pinv_11_0.Z 0.14124f
C932 bank_0.replica_bitcell_array_0.wl_0_3 bank_0.replica_bitcell_array_0.wl_0_4 0.13236f
C933 bank_0.replica_bitcell_array_0.dummy_array_2_0.dummy_cell_1rw_3.q a_4421_10451# 0.01645f
C934 bank_0.port_address_0.hierarchical_decoder_0.predecode_5 w_2422_5715# 0.30344f
C935 bank_0.replica_bitcell_array_0.bitcell_array_0.cell_1rw_10.qb bank_0.replica_bitcell_array_0.dummy_array_3_0.dummy_cell_1rw_11.q 0.01651f
C936 bank_0.replica_bitcell_array_0.bitcell_array_0.cell_1rw_10.q bank_0.replica_bitcell_array_0.dummy_array_3_0.dummy_cell_1rw_11.qb 0.02064f
C937 control_logic_rw_0.delay_chain_0.pinv_11_43.Z control_logic_rw_0.delay_chain_0.pinv_11_44.Z 0.18902f
C938 a_5530_9433# bank_0.replica_bitcell_array_0.wl_0_11 0.04184f
C939 w_2422_9787# bank_0.port_address_0.hierarchical_decoder_0.predecode_0 0.02797f
C940 bank_0.replica_bitcell_array_0.dummy_array_0.dummy_cell_1rw_1.qb a_5010_3325# 0.0163f
C941 control_logic_rw_0.pand3_0_0.pnand3_0_0.nmos_m1_w0_840_sactive_dli_0.G control_logic_rw_0.pinv_3_0.vdd 0.01769f
C942 control_logic_rw_0.dff_buf_array_0.dff_buf_0_1.dff_0.net1 control_logic_rw_0.dff_buf_array_0.dff_buf_0_1.dff_0.clkb 0.1543f
C943 bank_0.replica_bitcell_array_0.replica_column_0.replica_cell_1rw_7.q bank_0.replica_bitcell_array_0.bitcell_array_0.cell_1rw_23.qb 0.02064f
C944 control_logic_rw_0.pdriver_0_0.pinv_4_0.A control_logic_rw_0.pdriver_0_0.pinv_6_0.A 0.11616f
C945 control_logic_rw_0.pand2_0.Z a_n1744_n107# 0.02356f
C946 control_logic_rw_0.pdriver_1_0.pinv_6_0.A control_logic_rw_0.wl_en 0.21901f
C947 control_logic_rw_0.pdriver_1_0.gnd control_logic_rw_0.dff_buf_array_0.dout_bar_0 0.31251f
C948 row_addr_dff_0.dff_0.net5 row_addr_dff_0.dout_3 0.08416f
C949 control_logic_rw_0.pand2_0.Z w_n2769_857# 0.06323f
C950 control_logic_rw_0.pand2_0.Z a_n1432_n107# 0.01142f
C951 a_n1997_1923# control_logic_rw_0.pinv_3_0.vdd 0.01857f
C952 control_logic_rw_0.delay_chain_0.pinv_11_10.Z control_logic_rw_0.delay_chain_0.pinv_11_14.Z 0.11884f
C953 bank_0.replica_bitcell_array_0.replica_column_0.replica_cell_1rw_15.q bank_0.replica_bitcell_array_0.wl_0_0 0.04211f
C954 bank_0.replica_bitcell_array_0.wl_0_14 bank_0.replica_bitcell_array_0.wl_0_15 0.03867f
C955 bank_0.replica_bitcell_array_0.bitcell_array_0.cell_1rw_25.qb bank_0.replica_bitcell_array_0.bitcell_array_0.cell_1rw_9.q 0.01651f
C956 bank_0.port_address_0.wordline_driver_array_0.in_15 bank_0.port_address_0.wordline_driver_array_0.in_14 0.01302f
C957 bank_0.replica_bitcell_array_0.wl_0_3 w_2422_4697# 0.16341f
C958 a_n1118_n227# control_logic_rw_0.dff_buf_array_0.dout_bar_0 0.01142f
C959 control_logic_rw_0.dff_buf_array_0.dout_1 a_n2343_2181# 0.01624f
C960 bank_0.replica_bitcell_array_0.replica_column_0.replica_cell_1rw_5.q bank_0.replica_bitcell_array_0.bitcell_array_0.cell_1rw_21.qb 0.02064f
C961 bank_0.replica_bitcell_array_0.dummy_array_3_0.dummy_cell_1rw_13.q bank_0.replica_bitcell_array_0.wl_0_3 0.04136f
C962 a_4421_3325# bank_0.replica_bitcell_array_0.rbl_wl_0_0 0.05228f
C963 a_n4794_6649# control_logic_rw_0.delay_chain_0.pinv_11_17.Z 0.0129f
C964 row_addr_dff_0.dff_2.net1 addr0[1] 0.0963f
C965 a_n3579_n513# control_logic_rw_0.dff_buf_array_0.dff_buf_0_1.pinv_1_0.vdd 0.0184f
C966 bank_0.replica_bitcell_array_0.dummy_array_2_0.dummy_cell_1rw_8.qb a_4490_7583# 0.0163f
C967 a_n2515_n661# control_logic_rw_0.dff_buf_array_0.dout_bar_0 0.01597f
C968 w_1141_3679# bank_0.port_address_0.hierarchical_decoder_0.predecode_1 0.25677f
C969 addr0[2] row_addr_dff_0.dff_1.net1 0.08005f
C970 control_logic_rw_0.pand2_0.Z control_logic_rw_0.pnand2_1_0.nmos_m1_w0_840_sactive_dli_0.G 0.10321f
C971 control_logic_rw_0.dff_buf_array_0.dff_buf_0_1.dff_0.net4 control_logic_rw_0.dff_buf_array_0.dff_buf_0_1.dff_0.net5 0.13677f
C972 bank_0.replica_bitcell_array_0.dummy_array_1_0.dummy_cell_1rw_1.q bank_0.replica_bitcell_array_0.replica_column_0.dummy_cell_1rw_1.qb 0.01651f
C973 control_logic_rw_0.delay_chain_0.pinv_11_12.Z control_logic_rw_0.delay_chain_0.pinv_11_14.Z 0.14367f
C974 a_n1508_n227# control_logic_rw_0.dff_buf_array_0.dout_bar_0 0.01211f
C975 control_logic_rw_0.delay_chain_0.pinv_11_17.Z w_n5644_6180# 0.20256f
C976 bank_0.port_address_0.hierarchical_decoder_0.predecode_6 bank_0.port_address_0.hierarchical_decoder_0.predecode_3 0.41908f
C977 control_logic_rw_0.delay_chain_0.out control_logic_rw_0.delay_chain_0.pinv_11_20.Z 0.04231f
C978 control_logic_rw_0.pinv_3_1.gnd a_n1664_n227# 0.0179f
C979 a_4421_11469# bank_0.replica_bitcell_array_0.wl_0_15 0.05228f
C980 a_n1299_298# control_logic_rw_0.dff_buf_array_0.dout_bar_0 0.02601f
C981 control_logic_rw_0.wl_en bank_0.port_address_0.hierarchical_decoder_0.predecode_7 0.01162f
C982 w_n4225_n767# control_logic_rw_0.dff_buf_array_0.dout_bar_0 0.75943f
C983 bank_0.port_address_0.wordline_driver_array_0.in_13 control_logic_rw_0.wl_en 0.18688f
C984 data_dff_0.dff_1.clkb data_dff_0.dff_1.net2 0.07662f
C985 row_addr_dff_0.dff_2.net1 row_addr_dff_0.dff_3.clk 0.31285f
C986 control_logic_rw_0.dff_buf_array_0.dout_1 control_logic_rw_0.dff_buf_array_0.dff_buf_0_1.pinv_1_0.vdd 0.1541f
C987 control_logic_rw_0.pand3_0_0.pnand3_0_0.nmos_m1_w0_840_sactive_dactive_0.S control_logic_rw_0.pand3_0_0.gnd 0.01436f
C988 data_dff_0.dff_1.net3 data_dff_0.dff_1.net1 0.14299f
C989 control_logic_rw_0.delay_chain_0.pinv_11_16.Z control_logic_rw_0.delay_chain_0.pinv_11_19.Z 0.14232f
C990 control_logic_rw_0.pand2_0.Z a_n1978_123# 0.02492f
C991 control_logic_rw_0.delay_chain_0.pinv_11_38.Z control_logic_rw_0.delay_chain_0.pinv_11_39.Z 0.18896f
C992 bank_0.replica_bitcell_array_0.bitcell_array_0.cell_1rw_11.qb bank_0.replica_bitcell_array_0.bitcell_array_0.cell_1rw_11.q 0.28699f
C993 bank_0.replica_bitcell_array_0.dummy_array_2_0.dummy_cell_1rw_6.qb bank_0.replica_bitcell_array_0.dummy_array_2_0.dummy_cell_1rw_6.q 0.28699f
C994 row_addr_dff_0.dout_3 row_addr_dff_0.dff_3.clk 0.02069f
C995 bank_0.port_address_0.hierarchical_decoder_0.predecode_5 bank_0.port_address_0.hierarchical_decoder_0.predecode_7 0.17274f
C996 bank_0.replica_bitcell_array_0.bitcell_array_0.cell_1rw_1.qb bank_0.replica_bitcell_array_0.dummy_array_3_0.dummy_cell_1rw_2.q 0.01651f
C997 bank_0.replica_bitcell_array_0.replica_column_0.replica_cell_1rw_10.q bank_0.replica_bitcell_array_0.dummy_array_2_0.dummy_cell_1rw_11.qb 0.01651f
C998 a_n1723_299# control_logic_rw_0.dff_buf_array_0.dout_bar_0 0.01374f
C999 w_n5644_7860# control_logic_rw_0.delay_chain_0.pinv_11_11.Z 0.20256f
C1000 bank_0.replica_bitcell_array_0.rbl_wl_0_0 bank_0.replica_bitcell_array_0.dummy_array_2_0.dummy_cell_1rw_17.q 0.0474f
C1001 w_n5644_2820# control_logic_rw_0.delay_chain_0.pinv_11_42.Z 0.20256f
C1002 a_4421_6379# bank_0.replica_bitcell_array_0.wl_0_5 0.05228f
C1003 bank_0.port_address_0.hierarchical_decoder_0.hierarchical_predecode2x4_1.pinv_1.Z w_1141_4697# 0.0212f
C1004 bank_0.replica_bitcell_array_0.bitcell_array_0.cell_1rw_21.qb bank_0.replica_bitcell_array_0.wl_0_10 0.03704f
C1005 addr0[1] row_addr_dff_0.dff_0.net1 0.01849f
C1006 a_739_6883# bank_0.port_address_0.hierarchical_decoder_0.hierarchical_predecode2x4_0.pinv_1.Z 0.01603f
C1007 bank_0.replica_bitcell_array_0.dummy_array_3_0.dummy_cell_1rw_3.q a_5461_10451# 0.01645f
C1008 w_n5644_9540# control_logic_rw_0.delay_chain_0.pinv_11_3.Z 0.20256f
C1009 a_n1723_n681# control_logic_rw_0.dff_buf_array_0.dout_bar_0 0.02469f
C1010 control_logic_rw_0.delay_chain_0.out control_logic_rw_0.delay_chain_0.pinv_11_35.Z 0.04231f
C1011 row_addr_dff_0.dff_1.clkb row_addr_dff_0.dff_0.clkb 0.01354f
C1012 bank_0.replica_bitcell_array_0.dummy_array_2_0.dummy_cell_1rw_16.q bank_0.replica_bitcell_array_0.dummy_array_2_0.dummy_cell_1rw_16.qb 0.28699f
C1013 bank_0.port_address_0.hierarchical_decoder_0.predecode_2 w_2422_4697# 0.02587f
C1014 control_logic_rw_0.delay_chain_0.pinv_11_23.Z a_n4480_6501# 0.0129f
C1015 row_addr_dff_0.dff_0.net2 row_addr_dff_0.dff_0.net1 0.12728f
C1016 control_logic_rw_0.delay_chain_0.pinv_11_24.Z control_logic_rw_0.delay_chain_0.pinv_11_20.Z 0.11884f
C1017 bank_0.replica_bitcell_array_0.dummy_array_3_0.dummy_cell_1rw_0.qb a_5530_11655# 0.0163f
C1018 a_5461_3325# bank_0.replica_bitcell_array_0.rbl_wl_0_0 0.05176f
C1019 bank_0.replica_bitcell_array_0.dummy_array_0.dummy_cell_1rw_1.qb bank_0.replica_bitcell_array_0.dummy_array_0.dummy_cell_1rw_1.q 0.28699f
C1020 bank_0.replica_bitcell_array_0.bitcell_array_0.cell_1rw_4.qb bank_0.replica_bitcell_array_0.bitcell_array_0.cell_1rw_20.q 0.02064f
C1021 bank_0.replica_bitcell_array_0.bitcell_array_0.cell_1rw_4.q bank_0.replica_bitcell_array_0.bitcell_array_0.cell_1rw_20.qb 0.01651f
C1022 bank_0.replica_bitcell_array_0.wl_0_7 bank_0.replica_bitcell_array_0.bitcell_array_0.cell_1rw_8.q 0.04136f
C1023 row_addr_dff_0.dff_1.clkb row_addr_dff_0.dff_1.net1 0.1543f
C1024 row_addr_dff_0.dff_2.net3 row_addr_dff_0.dff_3.clk 0.09335f
C1025 a_n3971_n513# control_logic_rw_0.dff_buf_array_0.dff_buf_0_1.pinv_1_0.vdd 0.01403f
C1026 w_n2769_n767# control_logic_rw_0.pinv_3_1.Z 0.1823f
C1027 a_4421_10637# a_4490_10637# 0.06598f
C1028 row_addr_dff_0.dff_2.net3 row_addr_dff_0.dff_2.net4 0.04611f
C1029 bank_0.replica_bitcell_array_0.replica_column_0.replica_cell_1rw_1.q bank_0.replica_bitcell_array_0.bitcell_array_0.cell_1rw_17.qb 0.02064f
C1030 control_logic_rw_0.pinv_3_1.gnd a_n1274_n227# 0.01066f
C1031 bank_0.replica_bitcell_array_0.wl_0_6 bank_0.replica_bitcell_array_0.dummy_array_2_0.dummy_cell_1rw_10.q 0.04741f
C1032 bank_0.port_address_0.hierarchical_decoder_0.predecode_6 bank_0.port_address_0.hierarchical_decoder_0.predecode_4 0.14601f
C1033 row_addr_dff_0.dff_0.net1 row_addr_dff_0.dff_3.clk 0.3125f
C1034 bank_0.replica_bitcell_array_0.bitcell_array_0.cell_1rw_3.qb bank_0.replica_bitcell_array_0.bitcell_array_0.cell_1rw_3.q 0.28699f
C1035 control_logic_rw_0.delay_chain_0.pinv_11_16.Z control_logic_rw_0.delay_chain_0.pinv_11_15.Z 0.04321f
C1036 bank_0.replica_bitcell_array_0.bitcell_array_0.cell_1rw_31.q bank_0.replica_bitcell_array_0.bitcell_array_0.cell_1rw_15.qb 0.02064f
C1037 a_5461_8601# bank_0.replica_bitcell_array_0.wl_0_10 0.05176f
C1038 row_addr_dff_0.dff_0.net5 row_addr_dff_0.dff_3.clk 0.03761f
C1039 row_addr_dff_0.dff_1.net4 row_addr_dff_0.dff_1.net3 0.04611f
C1040 data_dff_0.dff_1.net1 din0[0] 0.0923f
C1041 web0 control_logic_rw_0.dff_buf_array_0.dff_buf_0_0.dff_0.clkb 0.34002f
C1042 w_2422_8769# bank_0.port_address_0.wordline_driver_array_0.in_10 0.14989f
C1043 bank_0.port_address_0.wordline_driver_array_0.in_4 bank_0.port_address_0.wordline_driver_array_0.in_3 0.01362f
C1044 control_logic_rw_0.delay_chain_0.pinv_11_14.Z control_logic_rw_0.delay_chain_0.pinv_11_13.Z 0.18902f
C1045 w_n2769_1669# control_logic_rw_0.p_en_bar 0.01149f
C1046 control_logic_rw_0.dff_buf_array_0.dff_buf_0_0.dff_0.clkb control_logic_rw_0.dff_buf_array_0.dff_buf_0_0.pinv_0_0.A 0.01658f
C1047 bank_0.replica_bitcell_array_0.dummy_array_2_0.dummy_cell_1rw_17.qb a_4490_3325# 0.0163f
C1048 bank_0.replica_bitcell_array_0.dummy_array_2_0.dummy_cell_1rw_6.q a_4421_8601# 0.01645f
C1049 a_n3917_n213# control_logic_rw_0.dff_buf_array_0.dout_bar_0 0.01142f
C1050 bank_0.replica_bitcell_array_0.dummy_array_2_0.dummy_cell_1rw_8.qb bank_0.replica_bitcell_array_0.dummy_array_2_0.dummy_cell_1rw_8.q 0.28699f
C1051 bank_0.replica_bitcell_array_0.dummy_array_1_0.dummy_cell_1rw_1.qb bank_0.replica_bitcell_array_0.dummy_array_1_0.dummy_cell_1rw_1.q 0.28699f
C1052 a_n1919_705# control_logic_rw_0.pdriver_1_0.gnd 0.01894f
C1053 bank_0.replica_bitcell_array_0.bitcell_array_0.cell_1rw_4.q bank_0.replica_bitcell_array_0.wl_0_11 0.04136f
C1054 clk0 control_logic_rw_0.dff_buf_array_0.dout_bar_0 0.11384f
C1055 control_logic_rw_0.delay_chain_0.pinv_11_41.Z control_logic_rw_0.delay_chain_0.pinv_11_44.Z 0.14222f
C1056 data_dff_0.dff_0.net3 data_dff_0.dff_0.net2 0.03271f
C1057 control_logic_rw_0.pdriver_0_0.pinv_4_0.A control_logic_rw_0.dff_buf_array_0.dout_bar_0 0.18502f
C1058 row_addr_dff_0.dff_1.clkb row_addr_dff_0.dff_1.net3 0.14179f
C1059 a_n2201_n661# control_logic_rw_0.dff_buf_array_0.dout_bar_0 0.01587f
C1060 control_logic_rw_0.dff_buf_array_0.dff_buf_0_0.dff_0.net5 control_logic_rw_0.dff_buf_array_0.dff_buf_0_0.pinv_0_0.A 0.07645f
C1061 addr0[1] row_addr_dff_0.dff_3.clk 0.24101f
C1062 control_logic_rw_0.delay_chain_0.pinv_11_19.Z w_n5644_6180# 0.75898f
C1063 bank_0.replica_bitcell_array_0.bitcell_array_0.cell_1rw_21.qb bank_0.replica_bitcell_array_0.bitcell_array_0.cell_1rw_21.q 0.28699f
C1064 w_2422_6733# control_logic_rw_0.wl_en 0.29624f
C1065 control_logic_rw_0.dff_buf_array_0.dout_0 control_logic_rw_0.pand3_0.B 0.03374f
C1066 bank_0.replica_bitcell_array_0.bitcell_array_0.cell_1rw_28.qb bank_0.replica_bitcell_array_0.wl_0_3 0.03704f
C1067 control_logic_rw_0.delay_chain_0.out a_n2142_1111# 0.0169f
C1068 row_addr_dff_0.dff_0.net2 row_addr_dff_0.dff_3.clk 0.0716f
C1069 w_n2769_1669# control_logic_rw_0.pand3_0_0.gnd 0.04344f
C1070 a_3797_6011# bank_0.replica_bitcell_array_0.wl_0_5 0.01304f
C1071 control_logic_rw_0.pand2_0.Z a_n1744_123# 0.04117f
C1072 bank_0.replica_bitcell_array_0.dummy_array_3_0.dummy_cell_1rw_5.qb a_5530_9433# 0.0163f
C1073 control_logic_rw_0.delay_chain_0.pinv_11_10.Z w_n5644_7860# 0.19711f
C1074 w_2422_6733# bank_0.port_address_0.hierarchical_decoder_0.predecode_5 0.32887f
C1075 control_logic_rw_0.delay_chain_0.pinv_11_18.Z w_n5644_6180# 0.20256f
C1076 a_3103_8047# bank_0.port_address_0.wordline_driver_array_0.in_9 0.01304f
C1077 control_logic_rw_0.pinv_3_0.vdd control_logic_rw_0.pand3_0_0.gnd 0.02784f
C1078 control_logic_rw_0.pinv_3_1.gnd a_n1508_n227# 0.01788f
C1079 control_logic_rw_0.pand2_1.pnand2_0_0.nmos_m1_w0_840_sactive_dli_0.G control_logic_rw_0.dff_buf_array_0.dout_bar_0 0.12009f
C1080 bank_0.port_address_0.hierarchical_decoder_0.predecode_5 a_1822_7029# 0.01558f
C1081 control_logic_rw_0.delay_chain_0.pinv_11_9.Z control_logic_rw_0.delay_chain_0.pinv_11_14.Z 0.361f
C1082 row_addr_dff_0.dout_2 w_1141_7751# 0.0212f
C1083 bank_0.replica_bitcell_array_0.dummy_array_2_0.dummy_cell_1rw_16.q a_4421_3511# 0.01645f
C1084 row_addr_dff_0.dff_3.net2 row_addr_dff_0.dff_3.clk 0.07175f
C1085 control_logic_rw_0.delay_chain_0.pinv_11_33.Z a_n4480_4821# 0.0129f
C1086 a_5461_9619# bank_0.replica_bitcell_array_0.dummy_array_3_0.dummy_cell_1rw_4.q 0.01645f
C1087 bank_0.port_address_0.wordline_driver_array_0.in_10 bank_0.port_address_0.wordline_driver_array_0.in_9 0.01362f
C1088 a_n1801_599# control_logic_rw_0.pdriver_1_0.pinv_6_0.A 0.01144f
C1089 row_addr_dff_0.dff_2.net4 row_addr_dff_0.dff_3.clk 0.15111f
C1090 data_dff_0.dff_1.net1 data_dff_0.dff_1.net2 0.12728f
C1091 a_5201_3325# bank_0.replica_bitcell_array_0.dummy_array_0.dummy_cell_1rw_0.q 0.01645f
C1092 a_n3971_n661# control_logic_rw_0.dff_buf_array_0.dff_buf_0_1.pinv_1_0.vdd 0.01403f
C1093 control_logic_rw_0.dff_buf_array_0.dff_buf_0_1.pinv_1_0.vdd a_n3525_n513# 0.02305f
C1094 a_n441_n691# control_logic_rw_0.dff_buf_array_0.dout_bar_0 0.02684f
C1095 bank_0.replica_bitcell_array_0.wl_0_1 bank_0.replica_bitcell_array_0.bitcell_array_0.cell_1rw_14.qb 0.03696f
C1096 a_n1664_n513# control_logic_rw_0.dff_buf_array_0.dout_bar_0 0.05646f
C1097 control_logic_rw_0.delay_chain_0.pinv_11_15.Z w_n5644_6180# 0.19711f
C1098 control_logic_rw_0.delay_chain_0.pinv_11_10.Z control_logic_rw_0.delay_chain_0.out 0.04231f
C1099 w_2422_6733# bank_0.port_address_0.wordline_driver_array_0.in_6 0.14989f
C1100 bank_0.replica_bitcell_array_0.bitcell_array_0.cell_1rw_16.qb bank_0.replica_bitcell_array_0.bitcell_array_0.cell_1rw_0.q 0.01651f
C1101 bank_0.replica_bitcell_array_0.wl_0_0 a_5530_3511# 0.04184f
C1102 w_431_3679# bank_0.port_address_0.hierarchical_decoder_0.hierarchical_predecode2x4_1.pinv_0.Z 0.19953f
C1103 w_n5644_7860# control_logic_rw_0.delay_chain_0.pinv_11_12.Z 0.20256f
C1104 control_logic_rw_0.delay_chain_0.pinv_11_19.Z control_logic_rw_0.delay_chain_0.pinv_11_14.Z 0.4357f
C1105 a_5201_2493# a_5270_2493# 0.06598f
C1106 bank_0.replica_bitcell_array_0.dummy_array_0_0.dummy_cell_1rw_0.q bank_0.replica_bitcell_array_0.dummy_array_0_0.dummy_cell_1rw_1.qb 0.01651f
C1107 a_n675_n919# control_logic_rw_0.pdriver_0_0.gnd 0.01095f
C1108 bank_0.replica_bitcell_array_0.wl_0_12 bank_0.replica_bitcell_array_0.wl_0_13 0.03867f
C1109 row_addr_dff_0.dout_3 row_addr_dff_0.dout_2 8.55516f
C1110 bank_0.replica_bitcell_array_0.dummy_array_3_0.dummy_cell_1rw_16.qb a_5530_3511# 0.0163f
C1111 bank_0.replica_bitcell_array_0.bitcell_array_0.cell_1rw_31.qb bank_0.replica_bitcell_array_0.bitcell_array_0.cell_1rw_15.q 0.01651f
C1112 control_logic_rw_0.delay_chain_0.pinv_11_24.Z control_logic_rw_0.delay_chain_0.pinv_11_21.Z 0.14223f
C1113 bank_0.replica_bitcell_array_0.dummy_array_3_0.dummy_cell_1rw_11.qb bank_0.replica_bitcell_array_0.wl_0_5 0.03696f
C1114 control_logic_rw_0.pand2_0.Z a_n1588_n107# 0.01931f
C1115 bank_0.port_address_0.wordline_driver_array_0.in_8 w_2422_7751# 0.14989f
C1116 a_n2461_n513# control_logic_rw_0.dff_buf_array_0.dout_bar_0 0.01235f
C1117 control_logic_rw_0.pand3_0.pnand3_0_0.nmos_m1_w0_840_sactive_dactive_0.D control_logic_rw_0.pdriver_1_0.gnd 0.01146f
C1118 bank_0.replica_bitcell_array_0.bitcell_array_0.cell_1rw_17.qb bank_0.replica_bitcell_array_0.bitcell_array_0.cell_1rw_17.q 0.28699f
C1119 a_5270_11655# bank_0.replica_bitcell_array_0.dummy_array_0_0.dummy_cell_1rw_0.qb 0.0163f
C1120 control_logic_rw_0.delay_chain_0.out w_n2769_857# 1.23302f
C1121 w_n4225_n767# control_logic_rw_0.dff_buf_array_0.dff_buf_0_1.pinv_0_0.A 0.13968f
C1122 bank_0.port_address_0.hierarchical_decoder_0.predecode_2 bank_0.port_address_0.hierarchical_decoder_0.predecode_6 0.41211f
C1123 control_logic_rw_0.dff_buf_array_0.dout_0 control_logic_rw_0.dff_buf_array_0.dout_bar_0 0.20301f
C1124 row_addr_dff_0.dff_1.net2 row_addr_dff_0.dff_1.net1 0.12728f
C1125 bank_0.replica_bitcell_array_0.bitcell_array_0.cell_1rw_18.q bank_0.replica_bitcell_array_0.wl_0_13 0.04155f
C1126 bank_0.port_address_0.wordline_driver_array_0.in_3 bank_0.port_address_0.wordline_driver_array_0.in_2 0.01302f
C1127 bank_0.replica_bitcell_array_0.wl_0_7 bank_0.replica_bitcell_array_0.dummy_array_2_0.dummy_cell_1rw_9.q 0.0474f
C1128 a_n1567_n681# control_logic_rw_0.dff_buf_array_0.dout_bar_0 0.02474f
C1129 row_addr_dff_0.dff_3.clkb row_addr_dff_0.dff_3.net2 0.07662f
C1130 row_addr_dff_0.dff_3.clkb row_addr_dff_0.dff_3.clk 0.83719f
C1131 bank_0.port_address_0.hierarchical_decoder_0.predecode_1 bank_0.port_address_0.hierarchical_decoder_0.predecode_3 0.18468f
C1132 bank_0.replica_bitcell_array_0.dummy_array_3_0.dummy_cell_1rw_1.q bank_0.replica_bitcell_array_0.dummy_array_3_0.dummy_cell_1rw_1.qb 0.28699f
C1133 a_n3917_n661# control_logic_rw_0.dff_buf_array_0.dout_bar_0 0.02309f
C1134 control_logic_rw_0.delay_chain_0.pinv_11_6.Z control_logic_rw_0.delay_chain_0.pinv_11_9.Z 0.14223f
C1135 control_logic_rw_0.dff_buf_array_0.dff_buf_0_1.dff_0.clkb control_logic_rw_0.dff_buf_array_0.dff_buf_0_1.dff_0.net3 0.14179f
C1136 control_logic_rw_0.dff_buf_array_0.dout_1 a_n2461_1923# 0.0204f
C1137 a_n1588_123# control_logic_rw_0.dff_buf_array_0.dout_bar_0 0.02284f
C1138 a_n753_n691# control_logic_rw_0.dff_buf_array_0.dout_bar_0 0.02761f
C1139 control_logic_rw_0.pand2_0.Z a_n2056_n107# 0.01803f
C1140 addr0[0] row_addr_dff_0.dff_2.clkb 0.01212f
C1141 row_addr_dff_0.dff_1.clkb row_addr_dff_0.dff_2.clkb 0.01308f
C1142 w_n2769_n767# control_logic_rw_0.pand2_0.Z 0.04511f
C1143 a_5461_3511# a_5530_3511# 0.06598f
C1144 control_logic_rw_0.delay_chain_0.out control_logic_rw_0.pnand2_1_0.nmos_m1_w0_840_sactive_dli_0.G 0.12293f
C1145 bank_0.replica_bitcell_array_0.bitcell_array_0.cell_1rw_28.q bank_0.replica_bitcell_array_0.bitcell_array_0.cell_1rw_12.qb 0.02064f
C1146 bank_0.replica_bitcell_array_0.dummy_array_3_0.dummy_cell_1rw_17.q bank_0.replica_bitcell_array_0.dummy_array_3_0.dummy_cell_1rw_17.qb 0.28699f
C1147 a_4490_10451# a_4421_10451# 0.06598f
C1148 bank_0.replica_bitcell_array_0.dummy_array_2_0.dummy_cell_1rw_16.q bank_0.replica_bitcell_array_0.wl_0_0 0.04741f
C1149 control_logic_rw_0.dff_buf_array_0.dout_0 a_n3369_n919# 0.01406f
C1150 control_logic_rw_0.delay_chain_0.out a_n2051_927# 0.01962f
C1151 web0 control_logic_rw_0.dff_buf_array_0.dff_buf_0_0.dff_0.net1 0.07965f
C1152 control_logic_rw_0.delay_chain_0.pinv_11_42.Z control_logic_rw_0.delay_chain_0.pinv_11_44.Z 0.14324f
C1153 bank_0.replica_bitcell_array_0.bitcell_array_0.cell_1rw_1.q bank_0.replica_bitcell_array_0.wl_0_14 0.04136f
C1154 a_4421_8415# bank_0.replica_bitcell_array_0.wl_0_9 0.05228f
C1155 row_addr_dff_0.dff_1.net2 row_addr_dff_0.dff_1.net3 0.03271f
C1156 bank_0.replica_bitcell_array_0.bitcell_array_0.cell_1rw_8.qb bank_0.replica_bitcell_array_0.dummy_array_3_0.dummy_cell_1rw_9.q 0.01651f
C1157 a_n441_n919# control_logic_rw_0.pdriver_0_0.gnd 0.01784f
C1158 bank_0.replica_bitcell_array_0.dummy_array_3_0.dummy_cell_1rw_13.qb bank_0.replica_bitcell_array_0.wl_0_3 0.03696f
C1159 bank_0.port_address_0.hierarchical_decoder_0.predecode_0 bank_0.port_address_0.hierarchical_decoder_0.predecode_6 0.5242f
C1160 control_logic_rw_0.delay_chain_0.pinv_11_5.Z a_n5422_8329# 0.0129f
C1161 w_2422_8769# bank_0.port_address_0.hierarchical_decoder_0.predecode_3 0.0212f
C1162 row_addr_dff_0.dout_1 w_431_3679# 0.2155f
C1163 bank_0.replica_bitcell_array_0.dummy_array_2_0.dummy_cell_1rw_13.qb bank_0.replica_bitcell_array_0.dummy_array_2_0.dummy_cell_1rw_13.q 0.28699f
C1164 bank_0.replica_bitcell_array_0.dummy_array_3_0.dummy_cell_1rw_17.q bank_0.replica_bitcell_array_0.rbl_wl_0_0 0.04136f
C1165 w_n5644_7860# control_logic_rw_0.delay_chain_0.pinv_11_13.Z 0.20256f
C1166 bank_0.port_address_0.wordline_driver_array_0.in_12 control_logic_rw_0.wl_en 0.18688f
C1167 w_2422_10805# bank_0.port_address_0.hierarchical_decoder_0.predecode_7 0.44085f
C1168 bank_0.replica_bitcell_array_0.bitcell_array_0.cell_1rw_16.qb bank_0.replica_bitcell_array_0.wl_0_15 0.03704f
C1169 a_n1377_298# control_logic_rw_0.wl_en 0.02596f
C1170 bank_0.port_address_0.wordline_driver_array_0.in_12 bank_0.port_address_0.wordline_driver_array_0.in_11 0.01362f
C1171 bank_0.port_address_0.wordline_driver_array_0.in_5 w_2422_5715# 0.14946f
C1172 w_n2769_44# control_logic_rw_0.wl_en 0.2879f
C1173 bank_0.replica_bitcell_array_0.dummy_array_0.dummy_cell_1rw_0.qb bank_0.replica_bitcell_array_0.dummy_array_0.dummy_cell_1rw_1.q 0.02064f
C1174 a_4421_10451# bank_0.replica_bitcell_array_0.wl_0_13 0.05228f
C1175 bank_0.replica_bitcell_array_0.dummy_array_3_0.dummy_cell_1rw_15.q bank_0.replica_bitcell_array_0.wl_0_1 0.04136f
C1176 a_5010_11655# bank_0.replica_bitcell_array_0.dummy_array_0_0.dummy_cell_1rw_1.qb 0.0163f
C1177 bank_0.replica_bitcell_array_0.wl_0_0 bank_0.replica_bitcell_array_0.dummy_array_3_0.dummy_cell_1rw_16.q 0.04136f
C1178 bank_0.port_address_0.hierarchical_decoder_0.predecode_1 bank_0.port_address_0.hierarchical_decoder_0.predecode_4 0.4859f
C1179 control_logic_rw_0.delay_chain_0.out control_logic_rw_0.p_en_bar 0.10449f
C1180 bank_0.replica_bitcell_array_0.dummy_array_2_0.dummy_cell_1rw_9.q bank_0.replica_bitcell_array_0.dummy_array_2_0.dummy_cell_1rw_9.qb 0.28699f
C1181 control_logic_rw_0.pdriver_0_0.gnd a_n1143_n919# 0.01119f
C1182 w_3116_2703# control_logic_rw_0.wl_en 0.25053f
C1183 bank_0.replica_bitcell_array_0.dummy_array_3_0.dummy_cell_1rw_5.qb bank_0.replica_bitcell_array_0.bitcell_array_0.cell_1rw_4.q 0.02064f
C1184 bank_0.replica_bitcell_array_0.dummy_array_3_0.dummy_cell_1rw_5.q bank_0.replica_bitcell_array_0.bitcell_array_0.cell_1rw_4.qb 0.01651f
C1185 a_4750_11655# bank_0.replica_bitcell_array_0.replica_column_0.dummy_cell_1rw_0.qb 0.0163f
C1186 bank_0.replica_bitcell_array_0.dummy_array_3_0.dummy_cell_1rw_16.qb bank_0.replica_bitcell_array_0.dummy_array_3_0.dummy_cell_1rw_16.q 0.28699f
C1187 bank_0.replica_bitcell_array_0.bitcell_array_0.cell_1rw_14.qb bank_0.replica_bitcell_array_0.bitcell_array_0.cell_1rw_14.q 0.28699f
C1188 control_logic_rw_0.dff_buf_array_0.dff_buf_0_1.pinv_1_0.gnd control_logic_rw_0.pand3_0.B 0.01282f
C1189 control_logic_rw_0.pinv_3_1.gnd control_logic_rw_0.pand2_1.pnand2_0_0.nmos_m1_w0_840_sactive_dli_0.G 0.01199f
C1190 w_2422_5715# bank_0.replica_bitcell_array_0.wl_0_5 0.16341f
C1191 a_n1352_n513# control_logic_rw_0.dff_buf_array_0.dout_bar_0 0.05479f
C1192 a_n3525_n689# control_logic_rw_0.dff_buf_array_0.dout_0 0.02737f
C1193 control_logic_rw_0.dff_buf_array_0.dff_buf_0_1.pinv_1_0.vdd a_n3369_n513# 0.01281f
C1194 bank_0.replica_bitcell_array_0.dummy_array_2_0.dummy_cell_1rw_4.qb bank_0.replica_bitcell_array_0.replica_column_0.replica_cell_1rw_3.q 0.01651f
C1195 bank_0.replica_bitcell_array_0.wl_0_12 bank_0.replica_bitcell_array_0.bitcell_array_0.cell_1rw_3.q 0.04136f
C1196 w_2422_3679# bank_0.port_address_0.hierarchical_decoder_0.predecode_4 0.29931f
C1197 bank_0.replica_bitcell_array_0.wl_0_1 a_4490_4343# 0.04284f
C1198 row_addr_dff_0.dout_2 row_addr_dff_0.dff_3.clk 0.02068f
C1199 a_n1508_n513# control_logic_rw_0.dff_buf_array_0.dout_bar_0 0.05789f
C1200 bank_0.replica_bitcell_array_0.dummy_array_2_0.dummy_cell_1rw_13.qb bank_0.replica_bitcell_array_0.wl_0_3 0.03923f
C1201 bank_0.port_address_0.hierarchical_decoder_0.predecode_6 w_2422_7751# 0.34963f
C1202 a_n1299_589# control_logic_rw_0.pdriver_1_0.gnd 0.01687f
C1203 bank_0.port_address_0.wordline_driver_array_0.in_0 a_3103_3829# 0.01304f
C1204 control_logic_rw_0.pand3_0.B w_n2769_857# 0.09247f
C1205 bank_0.replica_bitcell_array_0.dummy_array_3_0.dummy_cell_1rw_3.qb bank_0.replica_bitcell_array_0.bitcell_array_0.cell_1rw_2.q 0.02064f
C1206 bank_0.replica_bitcell_array_0.dummy_array_3_0.dummy_cell_1rw_3.q bank_0.replica_bitcell_array_0.bitcell_array_0.cell_1rw_2.qb 0.01651f
C1207 a_4490_8601# bank_0.replica_bitcell_array_0.dummy_array_2_0.dummy_cell_1rw_6.qb 0.0163f
C1208 a_n2051_705# control_logic_rw_0.pdriver_1_0.gnd 0.01171f
C1209 a_5461_5547# a_5530_5547# 0.06598f
C1210 bank_0.replica_bitcell_array_0.bitcell_array_0.cell_1rw_3.q bank_0.replica_bitcell_array_0.dummy_array_3_0.dummy_cell_1rw_4.qb 0.02064f
C1211 bank_0.replica_bitcell_array_0.bitcell_array_0.cell_1rw_3.qb bank_0.replica_bitcell_array_0.dummy_array_3_0.dummy_cell_1rw_4.q 0.01651f
C1212 a_3103_8919# bank_0.port_address_0.wordline_driver_array_0.in_10 0.01304f
C1213 bank_0.replica_bitcell_array_0.dummy_array_3_0.dummy_cell_1rw_11.q a_5461_6379# 0.01645f
C1214 control_logic_rw_0.delay_chain_0.out control_logic_rw_0.pand3_0_0.gnd 0.04442f
C1215 a_4490_5361# bank_0.replica_bitcell_array_0.wl_0_3 0.04284f
C1216 control_logic_rw_0.delay_chain_0.pinv_11_9.Z w_n5644_7860# 0.75229f
C1217 bank_0.replica_bitcell_array_0.dummy_array_2_0.dummy_cell_1rw_11.qb bank_0.replica_bitcell_array_0.dummy_array_2_0.dummy_cell_1rw_11.q 0.28699f
C1218 control_logic_rw_0.pand3_0_0.pnand3_0_0.nmos_m1_w0_840_sactive_dli_0.G control_logic_rw_0.dff_buf_array_0.dout_bar_0 0.10127f
C1219 bank_0.replica_bitcell_array_0.replica_column_0.replica_cell_1rw_11.q bank_0.replica_bitcell_array_0.wl_0_4 0.04211f
C1220 w_n2769_n767# control_logic_rw_0.pdriver_0_0.gnd 0.06324f
C1221 bank_0.replica_bitcell_array_0.bitcell_array_0.cell_1rw_22.q bank_0.replica_bitcell_array_0.wl_0_9 0.04155f
C1222 bank_0.replica_bitcell_array_0.dummy_array_3_0.dummy_cell_1rw_16.q a_5461_3511# 0.01645f
C1223 row_addr_dff_0.dff_3.net5 row_addr_dff_0.dff_3.clk 0.03761f
C1224 a_n2088_n255# control_logic_rw_0.dff_buf_array_0.dout_bar_0 0.01751f
C1225 w_2422_9787# bank_0.port_address_0.hierarchical_decoder_0.predecode_6 0.03094f
C1226 a_n3447_n689# control_logic_rw_0.dff_buf_array_0.dout_0 0.02363f
C1227 bank_0.replica_bitcell_array_0.dummy_array_2_0.dummy_cell_1rw_16.qb bank_0.replica_bitcell_array_0.wl_0_0 0.03924f
C1228 bank_0.replica_bitcell_array_0.wl_0_6 bank_0.replica_bitcell_array_0.dummy_array_2_0.dummy_cell_1rw_10.qb 0.03924f
C1229 a_739_7029# bank_0.port_address_0.hierarchical_decoder_0.hierarchical_predecode2x4_0.pinv_0.Z 0.01343f
C1230 control_logic_rw_0.pand3_0.B control_logic_rw_0.pnand2_1_0.nmos_m1_w0_840_sactive_dli_0.G 0.01569f
C1231 a_3797_5865# bank_0.replica_bitcell_array_0.wl_0_4 0.01304f
C1232 bank_0.replica_bitcell_array_0.bitcell_array_0.cell_1rw_16.q bank_0.replica_bitcell_array_0.bitcell_array_0.cell_1rw_16.qb 0.28699f
C1233 control_logic_rw_0.delay_chain_0.pinv_11_9.Z control_logic_rw_0.delay_chain_0.out 0.48138f
C1234 w_n5644_7860# control_logic_rw_0.delay_chain_0.pinv_11_19.Z 0.05137f
C1235 control_logic_rw_0.dff_buf_array_0.dff_buf_0_0.pinv_1_0.gnd control_logic_rw_0.dff_buf_array_0.dff_buf_0_1.pinv_1_0.vdd 0.0233f
C1236 control_logic_rw_0.pdriver_0_0.pinv_7_0.A a_n1645_n681# 0.02183f
C1237 a_4421_8415# bank_0.replica_bitcell_array_0.dummy_array_2_0.dummy_cell_1rw_7.q 0.01645f
C1238 control_logic_rw_0.pdriver_4_0.pinv_8_0.A a_n2088_1111# 0.0132f
C1239 bank_0.replica_bitcell_array_0.wl_0_7 a_3797_7029# 0.01304f
C1240 a_n1432_123# control_logic_rw_0.dff_buf_array_0.dout_bar_0 0.01371f
C1241 a_n597_n691# control_logic_rw_0.dff_buf_array_0.dout_bar_0 0.02761f
C1242 bank_0.replica_bitcell_array_0.wl_0_12 bank_0.replica_bitcell_array_0.replica_column_0.replica_cell_1rw_3.q 0.04211f
C1243 bank_0.replica_bitcell_array_0.bitcell_array_0.cell_1rw_4.qb bank_0.replica_bitcell_array_0.wl_0_11 0.03696f
C1244 a_4681_11655# bank_0.replica_bitcell_array_0.replica_column_0.dummy_cell_1rw_0.q 0.01645f
C1245 a_5461_11655# bank_0.replica_bitcell_array_0.dummy_array_3_0.dummy_cell_1rw_0.q 0.01645f
C1246 bank_0.port_address_0.wordline_driver_array_0.in_11 control_logic_rw_0.wl_en 0.18688f
C1247 control_logic_rw_0.dff_buf_array_0.dff_buf_0_1.pinv_1_0.gnd control_logic_rw_0.dff_buf_array_0.dout_bar_0 0.18862f
C1248 bank_0.replica_bitcell_array_0.dummy_array_3_0.dummy_cell_1rw_12.qb a_5530_5547# 0.0163f
C1249 bank_0.replica_bitcell_array_0.wl_0_11 a_4490_9433# 0.04284f
C1250 a_4490_8601# a_4421_8601# 0.06598f
C1251 control_logic_rw_0.delay_chain_0.out control_logic_rw_0.delay_chain_0.pinv_11_19.Z 0.10996f
C1252 control_logic_rw_0.delay_chain_0.out control_logic_rw_0.delay_chain_0.pinv_11_2.Z 0.14262f
C1253 w_1141_6733# bank_0.port_address_0.hierarchical_decoder_0.predecode_1 0.02221f
C1254 control_logic_rw_0.pinv_3_1.gnd a_n1900_n107# 0.01066f
C1255 bank_0.replica_bitcell_array_0.replica_column_0.replica_cell_1rw_12.q bank_0.replica_bitcell_array_0.wl_0_3 0.04211f
C1256 bank_0.port_address_0.hierarchical_decoder_0.predecode_5 control_logic_rw_0.wl_en 0.01162f
C1257 bank_0.replica_bitcell_array_0.dummy_array_3_0.dummy_cell_1rw_1.q bank_0.replica_bitcell_array_0.bitcell_array_0.cell_1rw_0.qb 0.01651f
C1258 bank_0.replica_bitcell_array_0.dummy_array_2_0.dummy_cell_1rw_2.qb bank_0.replica_bitcell_array_0.wl_0_14 0.03924f
C1259 bank_0.replica_bitcell_array_0.dummy_array_3_0.dummy_cell_1rw_15.qb a_5530_4343# 0.0163f
C1260 w_n2769_857# control_logic_rw_0.dff_buf_array_0.dout_bar_0 0.48049f
C1261 row_addr_dff_0.dff_3.clkb row_addr_dff_0.dff_3.net5 0.03696f
C1262 bank_0.port_address_0.wordline_driver_array_0.in_4 w_2422_5715# 0.14989f
C1263 a_4941_2493# bank_0.replica_bitcell_array_0.dummy_array_1_0.dummy_cell_1rw_1.q 0.01645f
C1264 bank_0.port_address_0.hierarchical_decoder_0.predecode_2 bank_0.port_address_0.hierarchical_decoder_0.predecode_1 5.71068f
C1265 bank_0.replica_bitcell_array_0.wl_0_12 a_5461_9619# 0.05176f
C1266 control_logic_rw_0.dff_buf_array_0.dff_buf_0_0.dff_0.net4 control_logic_rw_0.dff_buf_array_0.dff_buf_0_0.pinv_0_0.A 0.23158f
C1267 control_logic_rw_0.pdriver_1_0.gnd a_n1431_589# 0.01038f
C1268 bank_0.replica_bitcell_array_0.dummy_array_2_0.dummy_cell_1rw_10.qb bank_0.replica_bitcell_array_0.dummy_array_2_0.dummy_cell_1rw_10.q 0.28699f
C1269 w_1141_6733# bank_0.port_address_0.hierarchical_decoder_0.hierarchical_predecode2x4_0.pinv_1.Z 0.0452f
C1270 bank_0.replica_bitcell_array_0.bitcell_array_0.cell_1rw_8.q bank_0.replica_bitcell_array_0.bitcell_array_0.cell_1rw_24.qb 0.01651f
C1271 a_4490_11655# bank_0.replica_bitcell_array_0.dummy_array_2_0.dummy_cell_1rw_0.qb 0.0163f
C1272 w_1141_3679# bank_0.port_address_0.hierarchical_decoder_0.hierarchical_predecode2x4_1.pinv_1.Z 0.0452f
C1273 a_5461_6565# bank_0.replica_bitcell_array_0.wl_0_6 0.05176f
C1274 w_2422_9787# bank_0.replica_bitcell_array_0.wl_0_12 0.16398f
C1275 bank_0.port_address_0.wordline_driver_array_0.in_1 bank_0.port_address_0.wordline_driver_array_0.in_2 0.01362f
C1276 bank_0.port_address_0.wordline_driver_array_0.in_6 control_logic_rw_0.wl_en 0.18688f
C1277 a_n1763_705# control_logic_rw_0.pdriver_1_0.gnd 0.01891f
C1278 control_logic_rw_0.delay_chain_0.pinv_11_24.Z control_logic_rw_0.delay_chain_0.pinv_11_19.Z 0.36079f
C1279 bank_0.replica_bitcell_array_0.dummy_array_3_0.dummy_cell_1rw_1.q a_5461_11469# 0.01645f
C1280 bank_0.port_address_0.wordline_driver_array_0.in_0 w_2422_3679# 0.14989f
C1281 a_3797_6883# bank_0.replica_bitcell_array_0.wl_0_6 0.01304f
C1282 bank_0.port_address_0.hierarchical_decoder_0.hierarchical_predecode2x4_0.pinv_0.Z w_431_6733# 0.19953f
C1283 control_logic_rw_0.delay_chain_0.out control_logic_rw_0.delay_chain_0.pinv_11_15.Z 0.04231f
C1284 bank_0.replica_bitcell_array_0.wl_0_1 bank_0.replica_bitcell_array_0.bitcell_array_0.cell_1rw_30.q 0.04155f
C1285 control_logic_rw_0.dff_buf_array_0.dout_1 a_n3525_n513# 0.02737f
C1286 control_logic_rw_0.delay_chain_0.out a_n2515_1369# 0.01779f
C1287 a_4490_6379# bank_0.replica_bitcell_array_0.wl_0_5 0.04284f
C1288 bank_0.port_address_0.hierarchical_decoder_0.predecode_2 w_2422_8769# 0.0212f
C1289 a_4421_3325# a_4490_3325# 0.06598f
C1290 bank_0.replica_bitcell_array_0.dummy_array_2_0.dummy_cell_1rw_18.q bank_0.replica_bitcell_array_0.replica_column_0.dummy_cell_1rw_1.qb 0.02064f
C1291 bank_0.replica_bitcell_array_0.wl_0_0 a_4421_3511# 0.05228f
C1292 bank_0.replica_bitcell_array_0.wl_0_1 bank_0.replica_bitcell_array_0.wl_0_2 0.13236f
C1293 bank_0.port_address_0.hierarchical_decoder_0.predecode_0 bank_0.port_address_0.hierarchical_decoder_0.predecode_1 5.43708f
C1294 a_n1143_589# control_logic_rw_0.pdriver_1_0.gnd 0.01011f
C1295 a_n1978_123# control_logic_rw_0.dff_buf_array_0.dout_bar_0 0.02754f
C1296 a_5530_9433# a_5461_9433# 0.06598f
C1297 bank_0.replica_bitcell_array_0.dummy_array_2_0.dummy_cell_1rw_5.qb a_4490_9433# 0.0163f
C1298 control_logic_rw_0.delay_chain_0.pinv_11_38.Z control_logic_rw_0.delay_chain_0.pinv_11_37.Z 0.04321f
C1299 a_n1221_589# control_logic_rw_0.wl_en 0.0171f
C1300 bank_0.replica_bitcell_array_0.bitcell_array_0.cell_1rw_9.q bank_0.replica_bitcell_array_0.dummy_array_3_0.dummy_cell_1rw_10.qb 0.02064f
C1301 bank_0.replica_bitcell_array_0.wl_0_8 a_5530_7583# 0.04184f
C1302 bank_0.replica_bitcell_array_0.bitcell_array_0.cell_1rw_18.qb bank_0.replica_bitcell_array_0.wl_0_13 0.03704f
C1303 control_logic_rw_0.delay_chain_0.pinv_11_35.Z control_logic_rw_0.delay_chain_0.pinv_11_39.Z 0.11884f
C1304 a_n987_n919# control_logic_rw_0.pdriver_0_0.gnd 0.01095f
C1305 bank_0.port_address_0.wordline_driver_array_0.in_5 a_3103_6011# 0.01304f
C1306 a_n5422_9861# control_logic_rw_0.delay_chain_0.pinv_11_0.Z 0.0129f
C1307 w_2422_3679# bank_0.port_address_0.hierarchical_decoder_0.predecode_0 0.02587f
C1308 w_2422_6733# bank_0.port_address_0.wordline_driver_array_0.in_7 0.14946f
C1309 control_logic_rw_0.dff_buf_array_0.dff_buf_0_1.pinv_1_0.vdd control_logic_rw_0.dff_buf_array_0.dff_buf_0_0.pinv_0_0.A 0.05616f
C1310 bank_0.port_address_0.hierarchical_decoder_0.predecode_6 w_2422_4697# 0.02963f
C1311 bank_0.replica_bitcell_array_0.wl_0_7 a_5461_7397# 0.05176f
C1312 control_logic_rw_0.dff_buf_array_0.dff_buf_0_1.pinv_0_0.A control_logic_rw_0.dff_buf_array_0.dff_buf_0_1.dff_0.net4 0.23158f
C1313 bank_0.replica_bitcell_array_0.dummy_array_1_0.dummy_cell_1rw_1.q bank_0.replica_bitcell_array_0.dummy_array_1_0.dummy_cell_1rw_0.qb 0.02064f
C1314 control_logic_rw_0.delay_chain_0.out control_logic_rw_0.pdriver_4_0.pinv_8_0.A 0.42515f
C1315 control_logic_rw_0.pdriver_1_0.pinv_6_0.A control_logic_rw_0.pdriver_1_0.pinv_8_0.Z 0.12401f
C1316 clk0 control_logic_rw_0.pdriver_0_0.pinv_4_0.A 0.1132f
C1317 addr0[3] row_addr_dff_0.dff_0.net1 0.08098f
C1318 bank_0.replica_bitcell_array_0.bitcell_array_0.cell_1rw_31.qb bank_0.replica_bitcell_array_0.bitcell_array_0.cell_1rw_31.q 0.28699f
C1319 control_logic_rw_0.delay_chain_0.pinv_11_0.Z control_logic_rw_0.delay_chain_0.pinv_11_1.Z 0.04321f
C1320 w_n4225_n767# control_logic_rw_0.dff_buf_array_0.dout_0 0.15657f
C1321 bank_0.replica_bitcell_array_0.wl_0_9 bank_0.replica_bitcell_array_0.wl_0_10 0.13236f
C1322 a_n2147_n513# control_logic_rw_0.dff_buf_array_0.dout_bar_0 0.02416f
C1323 control_logic_rw_0.pand2_1.pnand2_0_0.nmos_m1_w0_840_sactive_dli_0.S control_logic_rw_0.dff_buf_array_0.dout_bar_0 0.01213f
C1324 control_logic_rw_0.delay_chain_0.pinv_11_9.Z control_logic_rw_0.delay_chain_0.pinv_11_7.Z 0.14287f
C1325 bank_0.replica_bitcell_array_0.dummy_array_2_0.dummy_cell_1rw_3.qb bank_0.replica_bitcell_array_0.dummy_array_2_0.dummy_cell_1rw_3.q 0.28699f
C1326 w_n2769_n767# control_logic_rw_0.pdriver_0_0.pinv_6_0.A 0.20248f
C1327 bank_0.port_address_0.hierarchical_decoder_0.hierarchical_predecode2x4_0.pinv_0.Z bank_0.port_address_0.hierarchical_decoder_0.hierarchical_predecode2x4_0.pinv_1.Z 1.6708f
C1328 bank_0.replica_bitcell_array_0.bitcell_array_0.cell_1rw_1.qb bank_0.replica_bitcell_array_0.wl_0_14 0.03696f
C1329 control_logic_rw_0.delay_chain_0.pinv_11_5.Z control_logic_rw_0.delay_chain_0.pinv_11_9.Z 0.11884f
C1330 bank_0.port_address_0.hierarchical_decoder_0.predecode_1 w_2422_7751# 0.0212f
C1331 w_n2769_44# control_logic_rw_0.pand2_0.Z 0.57707f
C1332 bank_0.replica_bitcell_array_0.dummy_array_3_0.dummy_cell_1rw_7.qb a_5530_8415# 0.0163f
C1333 bank_0.port_address_0.hierarchical_decoder_0.predecode_3 bank_0.port_address_0.hierarchical_decoder_0.predecode_7 0.42359f
C1334 control_logic_rw_0.pand3_0_0.gnd control_logic_rw_0.dff_buf_array_0.dout_bar_0 0.0202f
C1335 bank_0.replica_bitcell_array_0.bitcell_array_0.cell_1rw_12.q bank_0.replica_bitcell_array_0.wl_0_3 0.04136f
C1336 control_logic_rw_0.pinv_3_1.gnd a_n1744_n107# 0.01066f
C1337 bank_0.replica_bitcell_array_0.replica_column_0.replica_cell_1rw_0.q bank_0.replica_bitcell_array_0.wl_0_15 0.04211f
C1338 bank_0.replica_bitcell_array_0.dummy_array_3_0.dummy_cell_1rw_17.qb a_5530_3325# 0.0163f
C1339 control_logic_rw_0.delay_chain_0.pinv_11_34.Z control_logic_rw_0.delay_chain_0.pinv_11_31.Z 0.14303f
C1340 bank_0.port_address_0.wordline_driver_array_0.in_0 bank_0.port_address_0.wordline_driver_array_0.in_1 0.01302f
C1341 a_5201_2493# bank_0.replica_bitcell_array_0.dummy_array_1_0.dummy_cell_1rw_0.q 0.01645f
C1342 addr0[3] addr0[1] 0.80605f
C1343 bank_0.replica_bitcell_array_0.replica_column_0.dummy_cell_1rw_1.q bank_0.replica_bitcell_array_0.replica_column_0.dummy_cell_1rw_1.qb 0.28699f
C1344 a_5530_6379# bank_0.replica_bitcell_array_0.wl_0_5 0.04184f
C1345 a_n5108_6649# control_logic_rw_0.delay_chain_0.pinv_11_16.Z 0.0129f
C1346 w_2422_9787# bank_0.port_address_0.hierarchical_decoder_0.predecode_1 0.02796f
C1347 control_logic_rw_0.dff_buf_array_0.dff_buf_0_1.dff_0.net1 control_logic_rw_0.dff_buf_array_0.dff_buf_0_1.dff_0.net2 0.12728f
C1348 a_1822_8047# bank_0.port_address_0.hierarchical_decoder_0.predecode_7 0.01558f
C1349 bank_0.replica_bitcell_array_0.wl_0_12 bank_0.replica_bitcell_array_0.dummy_array_3_0.dummy_cell_1rw_4.q 0.04136f
C1350 a_n3579_n227# control_logic_rw_0.dff_buf_array_0.dff_buf_0_0.pinv_1_0.gnd 0.01131f
C1351 bank_0.replica_bitcell_array_0.dummy_array_3_0.dummy_cell_1rw_15.qb bank_0.replica_bitcell_array_0.wl_0_1 0.03696f
C1352 bank_0.replica_bitcell_array_0.wl_0_0 bank_0.replica_bitcell_array_0.dummy_array_3_0.dummy_cell_1rw_16.qb 0.03696f
C1353 bank_0.replica_bitcell_array_0.dummy_array_3_0.dummy_cell_1rw_12.q bank_0.replica_bitcell_array_0.wl_0_4 0.04136f
C1354 a_3103_4993# bank_0.port_address_0.wordline_driver_array_0.in_3 0.01304f
C1355 control_logic_rw_0.delay_chain_0.out a_n2461_1111# 0.0224f
C1356 bank_0.replica_bitcell_array_0.wl_0_7 a_4490_7397# 0.04284f
C1357 a_n2461_1923# control_logic_rw_0.pinv_3_0.vdd 0.01072f
C1358 bank_0.replica_bitcell_array_0.bitcell_array_0.cell_1rw_8.q bank_0.replica_bitcell_array_0.bitcell_array_0.cell_1rw_8.qb 0.28699f
C1359 bank_0.replica_bitcell_array_0.wl_0_6 bank_0.replica_bitcell_array_0.wl_0_5 0.13236f
C1360 control_logic_rw_0.delay_chain_0.out a_n1997_927# 0.02463f
C1361 control_logic_rw_0.dff_buf_array_0.dff_buf_0_1.pinv_0_0.A control_logic_rw_0.dff_buf_array_0.dff_buf_0_1.pinv_1_0.gnd 0.04878f
C1362 a_n1377_589# control_logic_rw_0.wl_en 0.01546f
C1363 bank_0.replica_bitcell_array_0.rbl_wl_0_0 a_5530_3325# 0.04184f
C1364 bank_0.replica_bitcell_array_0.bitcell_array_0.cell_1rw_9.qb bank_0.replica_bitcell_array_0.wl_0_6 0.03696f
C1365 bank_0.replica_bitcell_array_0.dummy_array_2_0.dummy_cell_1rw_1.q bank_0.replica_bitcell_array_0.wl_0_15 0.0474f
C1366 row_addr_dff_0.dout_3 row_addr_dff_0.dff_0.net4 0.22447f
C1367 a_n1607_705# control_logic_rw_0.pdriver_1_0.gnd 0.01901f
C1368 a_5201_11655# bank_0.replica_bitcell_array_0.dummy_array_0_0.dummy_cell_1rw_0.q 0.01645f
C1369 control_logic_rw_0.dff_buf_array_0.dout_bar_0 a_n1744_123# 0.02225f
C1370 bank_0.replica_bitcell_array_0.dummy_array_3_0.dummy_cell_1rw_4.qb bank_0.replica_bitcell_array_0.dummy_array_3_0.dummy_cell_1rw_4.q 0.28699f
C1371 a_n1197_n691# control_logic_rw_0.dff_buf_array_0.dout_bar_0 0.01881f
C1372 a_n2515_705# control_logic_rw_0.pdriver_1_0.gnd 0.01544f
C1373 control_logic_rw_0.dff_buf_array_0.dout_1 a_n3447_n227# 0.01662f
C1374 bank_0.replica_bitcell_array_0.dummy_array_2_0.dummy_cell_1rw_4.qb bank_0.replica_bitcell_array_0.dummy_array_2_0.dummy_cell_1rw_4.q 0.28699f
C1375 bank_0.replica_bitcell_array_0.wl_0_12 bank_0.replica_bitcell_array_0.bitcell_array_0.cell_1rw_3.qb 0.03696f
C1376 bank_0.replica_bitcell_array_0.dummy_array_2_0.dummy_cell_1rw_1.qb bank_0.replica_bitcell_array_0.wl_0_15 0.03923f
C1377 addr0[3] row_addr_dff_0.dff_3.clk 0.16643f
C1378 bank_0.replica_bitcell_array_0.dummy_array_3_0.dummy_cell_1rw_1.q bank_0.replica_bitcell_array_0.wl_0_15 0.04136f
C1379 a_5530_10637# bank_0.replica_bitcell_array_0.dummy_array_3_0.dummy_cell_1rw_2.qb 0.0163f
C1380 a_n909_n691# control_logic_rw_0.dff_buf_array_0.dout_bar_0 0.02761f
C1381 control_logic_rw_0.dff_buf_array_0.dout_1 a_n3369_n513# 0.02197f
C1382 control_logic_rw_0.dff_buf_array_0.dout_1 control_logic_rw_0.pand2_0.Z 0.14938f
C1383 data_dff_0.dff_0.net5 data_dff_0.dff_0.net4 0.13677f
C1384 bank_0.replica_bitcell_array_0.bitcell_array_0.cell_1rw_13.qb bank_0.replica_bitcell_array_0.dummy_array_3_0.dummy_cell_1rw_14.q 0.01651f
C1385 bank_0.replica_bitcell_array_0.rbl_wl_0_0 a_4941_3325# 0.05224f
C1386 control_logic_rw_0.delay_chain_0.pinv_11_32.Z control_logic_rw_0.delay_chain_0.pinv_11_34.Z 0.14367f
C1387 bank_0.replica_bitcell_array_0.wl_0_0 a_5461_3511# 0.05176f
C1388 bank_0.port_address_0.hierarchical_decoder_0.predecode_4 bank_0.port_address_0.hierarchical_decoder_0.predecode_7 0.17032f
C1389 bank_0.replica_bitcell_array_0.bitcell_array_0.cell_1rw_20.qb bank_0.replica_bitcell_array_0.bitcell_array_0.cell_1rw_20.q 0.28699f
C1390 control_logic_rw_0.delay_chain_0.out a_n2515_963# 0.01437f
C1391 addr0[0] addr0[2] 1.07497f
C1392 bank_0.replica_bitcell_array_0.dummy_array_2_0.dummy_cell_1rw_12.q bank_0.replica_bitcell_array_0.wl_0_4 0.04741f
C1393 bank_0.replica_bitcell_array_0.wl_0_9 a_4490_8415# 0.04284f
C1394 a_n4480_3289# control_logic_rw_0.delay_chain_0.pinv_11_38.Z 0.0129f
C1395 control_logic_rw_0.delay_chain_0.pinv_11_37.Z control_logic_rw_0.delay_chain_0.pinv_11_39.Z 0.14367f
C1396 a_n2402_n107# control_logic_rw_0.dff_buf_array_0.dout_bar_0 0.01675f
C1397 bank_0.replica_bitcell_array_0.bitcell_array_0.cell_1rw_22.qb bank_0.replica_bitcell_array_0.wl_0_9 0.03704f
C1398 row_addr_dff_0.dff_1.clkb addr0[2] 0.31679f
C1399 bank_0.replica_bitcell_array_0.wl_0_6 a_5530_6565# 0.04184f
C1400 bank_0.port_address_0.wordline_driver_array_0.in_3 w_2422_4697# 0.14946f
C1401 a_5461_10451# bank_0.replica_bitcell_array_0.wl_0_13 0.05176f
C1402 bank_0.replica_bitcell_array_0.wl_0_4 a_4490_5547# 0.04284f
C1403 a_n5422_4821# control_logic_rw_0.delay_chain_0.pinv_11_30.Z 0.0129f
C1404 bank_0.replica_bitcell_array_0.dummy_array_2_0.dummy_cell_1rw_2.q a_4421_10637# 0.01645f
C1405 bank_0.replica_bitcell_array_0.dummy_array_3_0.dummy_cell_1rw_13.qb bank_0.replica_bitcell_array_0.dummy_array_3_0.dummy_cell_1rw_13.q 0.28699f
C1406 bank_0.replica_bitcell_array_0.dummy_array_3_0.dummy_cell_1rw_8.qb bank_0.replica_bitcell_array_0.dummy_array_3_0.dummy_cell_1rw_8.q 0.28699f
C1407 control_logic_rw_0.pdriver_0_0.pinv_7_0.A control_logic_rw_0.pdriver_0_0.gnd 0.37095f
C1408 bank_0.replica_bitcell_array_0.bitcell_array_0.cell_1rw_2.q bank_0.replica_bitcell_array_0.wl_0_13 0.04136f
C1409 a_3103_5865# bank_0.port_address_0.wordline_driver_array_0.in_4 0.01304f
C1410 w_n5644_9540# control_logic_rw_0.delay_chain_0.out 0.7248f
C1411 row_addr_dff_0.dff_0.net5 row_addr_dff_0.dff_0.net4 0.13677f
C1412 control_logic_rw_0.delay_chain_0.pinv_11_36.Z a_n5108_3289# 0.0129f
C1413 control_logic_rw_0.delay_chain_0.pinv_11_36.Z control_logic_rw_0.delay_chain_0.pinv_11_39.Z 0.1423f
C1414 bank_0.replica_bitcell_array_0.wl_0_6 bank_0.replica_bitcell_array_0.bitcell_array_0.cell_1rw_25.qb 0.03704f
C1415 a_n831_n919# control_logic_rw_0.pdriver_0_0.gnd 0.01095f
C1416 bank_0.replica_bitcell_array_0.dummy_array_3_0.dummy_cell_1rw_10.q bank_0.replica_bitcell_array_0.wl_0_6 0.04136f
C1417 bank_0.replica_bitcell_array_0.wl_0_1 bank_0.replica_bitcell_array_0.bitcell_array_0.cell_1rw_30.qb 0.03704f
C1418 bank_0.replica_bitcell_array_0.dummy_array_2_0.dummy_cell_1rw_0.qb bank_0.replica_bitcell_array_0.dummy_array_2_0.dummy_cell_1rw_0.q 0.28699f
C1419 bank_0.replica_bitcell_array_0.wl_0_2 a_4490_4529# 0.04284f
C1420 bank_0.replica_bitcell_array_0.dummy_array_2_0.dummy_cell_1rw_17.qb bank_0.replica_bitcell_array_0.dummy_array_2_0.dummy_cell_1rw_17.q 0.28699f
C1421 control_logic_rw_0.dff_buf_array_0.dout_1 w_n2769_1669# 0.34999f
C1422 bank_0.replica_bitcell_array_0.wl_0_15 a_4490_11469# 0.04284f
C1423 a_4490_10637# bank_0.replica_bitcell_array_0.wl_0_14 0.04284f
C1424 w_2422_10805# control_logic_rw_0.wl_en 0.29587f
C1425 bank_0.replica_bitcell_array_0.dummy_array_2_0.dummy_cell_1rw_0.qb bank_0.replica_bitcell_array_0.replica_column_0.dummy_cell_1rw_0.q 0.01651f
C1426 bank_0.replica_bitcell_array_0.wl_0_7 bank_0.replica_bitcell_array_0.dummy_array_2_0.dummy_cell_1rw_9.qb 0.03923f
C1427 bank_0.port_address_0.wordline_driver_array_0.in_9 w_2422_7751# 0.14946f
C1428 w_2422_6733# bank_0.port_address_0.hierarchical_decoder_0.predecode_3 0.02155f
C1429 bank_0.replica_bitcell_array_0.bitcell_array_0.cell_1rw_22.q bank_0.replica_bitcell_array_0.bitcell_array_0.cell_1rw_6.qb 0.02064f
C1430 bank_0.replica_bitcell_array_0.bitcell_array_0.cell_1rw_22.qb bank_0.replica_bitcell_array_0.bitcell_array_0.cell_1rw_6.q 0.01651f
C1431 bank_0.replica_bitcell_array_0.replica_column_0.dummy_cell_1rw_1.q bank_0.replica_bitcell_array_0.dummy_array_1_0.dummy_cell_1rw_1.qb 0.02064f
C1432 bank_0.replica_bitcell_array_0.wl_0_12 bank_0.replica_bitcell_array_0.dummy_array_2_0.dummy_cell_1rw_4.q 0.04741f
C1433 control_logic_rw_0.dff_buf_array_0.dout_1 control_logic_rw_0.pinv_3_0.vdd 0.27437f
C1434 control_logic_rw_0.dff_buf_array_0.dout_1 control_logic_rw_0.dff_buf_array_0.dff_buf_0_0.pinv_1_0.gnd 0.24675f
C1435 bank_0.replica_bitcell_array_0.bitcell_array_0.cell_1rw_20.q bank_0.replica_bitcell_array_0.wl_0_11 0.04155f
C1436 a_4490_7397# bank_0.replica_bitcell_array_0.dummy_array_2_0.dummy_cell_1rw_9.qb 0.0163f
C1437 control_logic_rw_0.pdriver_1_0.pinv_6_0.A control_logic_rw_0.dff_buf_array_0.dout_bar_0 0.18327f
C1438 bank_0.replica_bitcell_array_0.wl_0_9 bank_0.replica_bitcell_array_0.replica_column_0.replica_cell_1rw_6.q 0.04211f
C1439 row_addr_dff_0.dff_1.clkb row_addr_dff_0.dff_1.net4 0.08731f
C1440 control_logic_rw_0.dff_buf_array_0.dff_buf_0_1.dff_0.net1 csb0 0.08177f
C1441 w_n2769_857# control_logic_rw_0.pdriver_1_0.gnd 0.0658f
C1442 bank_0.replica_bitcell_array_0.dummy_array_3_0.dummy_cell_1rw_7.qb bank_0.replica_bitcell_array_0.dummy_array_3_0.dummy_cell_1rw_7.q 0.28699f
C1443 control_logic_rw_0.delay_chain_0.pinv_11_9.Z control_logic_rw_0.delay_chain_0.pinv_11_8.Z 0.18896f
C1444 control_logic_rw_0.pand3_0.B control_logic_rw_0.dff_buf_array_0.dff_buf_0_1.pinv_1_0.vdd 0.02965f
C1445 a_3797_10083# bank_0.replica_bitcell_array_0.wl_0_13 0.01304f
C1446 control_logic_rw_0.pinv_3_1.gnd control_logic_rw_0.pand2_1.pnand2_0_0.nmos_m1_w0_840_sactive_dli_0.S 0.01486f
C1447 bank_0.replica_bitcell_array_0.bitcell_array_0.cell_1rw_1.qb bank_0.replica_bitcell_array_0.bitcell_array_0.cell_1rw_1.q 0.28699f
C1448 control_logic_rw_0.delay_chain_0.pinv_11_32.Z control_logic_rw_0.delay_chain_0.pinv_11_31.Z 0.04321f
C1449 a_n1645_n919# control_logic_rw_0.pdriver_0_0.pinv_7_0.A 0.0101f
C1450 w_n2769_n767# control_logic_rw_0.dff_buf_array_0.dout_bar_0 2.59234f
C1451 bank_0.replica_bitcell_array_0.wl_0_8 bank_0.replica_bitcell_array_0.bitcell_array_0.cell_1rw_7.q 0.04136f
C1452 a_4421_9619# bank_0.replica_bitcell_array_0.dummy_array_2_0.dummy_cell_1rw_4.q 0.01645f
C1453 row_addr_dff_0.dff_3.net1 row_addr_dff_0.dff_3.net2 0.12728f
C1454 a_5010_2493# bank_0.replica_bitcell_array_0.dummy_array_1_0.dummy_cell_1rw_1.qb 0.0163f
C1455 row_addr_dff_0.dff_3.net1 row_addr_dff_0.dff_3.clk 0.31285f
C1456 bank_0.port_address_0.and2_dec_0_0.pnand2_0.nmos_m1_w0_840_sactive_dli_0.S control_logic_rw_0.wl_en 0.01244f
C1457 control_logic_rw_0.delay_chain_0.pinv_11_22.Z w_n5644_6180# 0.20256f
C1458 bank_0.replica_bitcell_array_0.bitcell_array_0.cell_1rw_5.qb bank_0.replica_bitcell_array_0.bitcell_array_0.cell_1rw_5.q 0.28699f
C1459 control_logic_rw_0.delay_chain_0.pinv_11_41.Z control_logic_rw_0.delay_chain_0.pinv_11_40.Z 0.04321f
C1460 row_addr_dff_0.dff_0.clkb row_addr_dff_0.dout_3 0.0198f
C1461 row_addr_dff_0.dff_0.net3 row_addr_dff_0.dff_0.net1 0.14299f
C1462 control_logic_rw_0.delay_chain_0.pinv_11_23.Z control_logic_rw_0.delay_chain_0.pinv_11_22.Z 0.04321f
C1463 bank_0.replica_bitcell_array_0.dummy_array_3_0.dummy_cell_1rw_15.qb bank_0.replica_bitcell_array_0.bitcell_array_0.cell_1rw_14.q 0.02064f
C1464 bank_0.replica_bitcell_array_0.dummy_array_3_0.dummy_cell_1rw_15.q bank_0.replica_bitcell_array_0.bitcell_array_0.cell_1rw_14.qb 0.01651f
C1465 bank_0.port_address_0.hierarchical_decoder_0.predecode_0 w_2422_5715# 0.02155f
C1466 w_n4225_n767# control_logic_rw_0.dff_buf_array_0.dff_buf_0_1.pinv_1_0.gnd 0.0447f
C1467 a_4941_11655# a_5010_11655# 0.06598f
C1468 a_n1777_n919# control_logic_rw_0.pdriver_0_0.gnd 0.01038f
C1469 row_addr_dff_0.dff_0.net4 row_addr_dff_0.dff_3.clk 0.15111f
C1470 a_5530_7583# a_5461_7583# 0.06598f
C1471 bank_0.replica_bitcell_array_0.wl_0_1 bank_0.replica_bitcell_array_0.dummy_array_2_0.dummy_cell_1rw_15.qb 0.03923f
C1472 bank_0.replica_bitcell_array_0.wl_0_8 a_4421_7583# 0.05228f
C1473 a_4490_6565# a_4421_6565# 0.06598f
C1474 control_logic_rw_0.delay_chain_0.out a_n1841_927# 0.02356f
C1475 a_n1143_298# control_logic_rw_0.dff_buf_array_0.dout_bar_0 0.01681f
C1476 data_dff_0.dff_0.clkb data_dff_0.dff_0.net1 0.1543f
C1477 a_n1742_n227# control_logic_rw_0.dff_buf_array_0.dout_bar_0 0.01778f
C1478 bank_0.replica_bitcell_array_0.wl_0_8 bank_0.replica_bitcell_array_0.bitcell_array_0.cell_1rw_23.q 0.04155f
C1479 control_logic_rw_0.delay_chain_0.pinv_11_16.Z w_n5644_6180# 0.20256f
C1480 w_n2769_44# control_logic_rw_0.pdriver_1_0.pinv_8_0.A 0.16641f
C1481 a_n1065_n691# control_logic_rw_0.dff_buf_array_0.dout_bar_0 0.0277f
C1482 a_n4166_4969# control_logic_rw_0.delay_chain_0.pinv_11_29.Z 0.01414f
C1483 row_addr_dff_0.dff_3.net3 row_addr_dff_0.dff_3.net2 0.03271f
C1484 row_addr_dff_0.dff_3.net3 row_addr_dff_0.dff_3.clk 0.09344f
C1485 bank_0.port_address_0.wordline_driver_array_0.in_10 control_logic_rw_0.wl_en 0.18688f
C1486 bank_0.replica_bitcell_array_0.wl_0_2 bank_0.replica_bitcell_array_0.dummy_array_3_0.dummy_cell_1rw_14.q 0.04136f
C1487 a_n2201_299# control_logic_rw_0.dff_buf_array_0.dout_bar_0 0.01465f
C1488 bank_0.port_address_0.wordline_driver_array_0.in_5 control_logic_rw_0.wl_en 0.18688f
C1489 bank_0.port_address_0.hierarchical_decoder_0.predecode_2 bank_0.port_address_0.hierarchical_decoder_0.predecode_7 0.42769f
C1490 a_n4166_3289# control_logic_rw_0.delay_chain_0.pinv_11_39.Z 0.01414f
C1491 bank_0.port_address_0.wordline_driver_array_0.in_10 bank_0.port_address_0.wordline_driver_array_0.in_11 0.01302f
C1492 control_logic_rw_0.dff_buf_array_0.dff_buf_0_0.dff_0.clkb control_logic_rw_0.dff_buf_array_0.dff_buf_0_0.dff_0.net3 0.14179f
C1493 bank_0.replica_bitcell_array_0.dummy_array_2_0.dummy_cell_1rw_5.q bank_0.replica_bitcell_array_0.wl_0_11 0.0474f
C1494 bank_0.replica_bitcell_array_0.dummy_array_3_0.dummy_cell_1rw_3.qb bank_0.replica_bitcell_array_0.dummy_array_3_0.dummy_cell_1rw_3.q 0.28699f
C1495 row_addr_dff_0.dff_0.clkb row_addr_dff_0.dff_0.net1 0.1543f
C1496 bank_0.replica_bitcell_array_0.wl_0_9 a_5530_8415# 0.04184f
C1497 row_addr_dff_0.dff_3.net4 row_addr_dff_0.dff_3.clk 0.15119f
C1498 row_addr_dff_0.dff_0.net3 row_addr_dff_0.dff_0.net2 0.03271f
C1499 row_addr_dff_0.dff_0.clkb row_addr_dff_0.dff_0.net5 0.03696f
C1500 row_addr_dff_0.dff_3.net1 row_addr_dff_0.dff_3.clkb 0.1543f
C1501 bank_0.port_address_0.wordline_driver_array_0.in_7 control_logic_rw_0.wl_en 0.18688f
C1502 bank_0.replica_bitcell_array_0.bitcell_array_0.cell_1rw_18.qb bank_0.replica_bitcell_array_0.replica_column_0.replica_cell_1rw_2.q 0.02064f
C1503 control_logic_rw_0.dff_buf_array_0.dout_bar_0 control_logic_rw_0.dff_buf_array_0.dff_buf_0_1.pinv_1_0.vdd 0.63232f
C1504 bank_0.replica_bitcell_array_0.dummy_array_2_0.dummy_cell_1rw_6.q bank_0.replica_bitcell_array_0.wl_0_10 0.04741f
C1505 control_logic_rw_0.delay_chain_0.pinv_11_33.Z control_logic_rw_0.delay_chain_0.pinv_11_34.Z 0.18902f
C1506 control_logic_rw_0.delay_chain_0.pinv_11_28.Z a_n4480_4969# 0.0129f
C1507 bank_0.replica_bitcell_array_0.dummy_array_2_0.dummy_cell_1rw_1.q a_4421_11469# 0.01645f
C1508 a_3797_11101# bank_0.replica_bitcell_array_0.wl_0_15 0.01304f
C1509 bank_0.replica_bitcell_array_0.dummy_array_2_0.dummy_cell_1rw_4.qb bank_0.replica_bitcell_array_0.wl_0_12 0.03924f
C1510 control_logic_rw_0.delay_chain_0.out a_n2402_963# 0.0151f
C1511 bank_0.port_address_0.hierarchical_decoder_0.hierarchical_predecode2x4_1.pinv_1.Z bank_0.port_address_0.hierarchical_decoder_0.hierarchical_predecode2x4_1.pinv_0.Z 1.6708f
C1512 bank_0.replica_bitcell_array_0.bitcell_array_0.cell_1rw_14.q bank_0.replica_bitcell_array_0.bitcell_array_0.cell_1rw_30.qb 0.01651f
C1513 control_logic_rw_0.pdriver_0_0.gnd din0[1] 2.38411f ; **FLOATING
C1514 control_logic_rw_0.dff_buf_array_0.dff_buf_0_1.pinv_1_0.gnd din0[1] 1.0974f ; **FLOATING
C1515 control_logic_rw_0.dff_buf_array_0.dout_0 din0[1] 0.20046f ; **FLOATING
C1516 control_logic_rw_0.dff_buf_array_0.dff_buf_0_1.pinv_1_0.vdd din0[1] 0.58836f ; **FLOATING
C1517 control_logic_rw_0.dff_buf_array_0.dff_buf_0_0.pinv_1_0.gnd din0[1] 1.0905f ; **FLOATING
C1518 control_logic_rw_0.pinv_3_1.gnd din0[1] 1.01165f ; **FLOATING
C1519 control_logic_rw_0.pdriver_1_0.gnd din0[1] 1.45682f ; **FLOATING
C1520 control_logic_rw_0.pinv_3_0.vdd din0[1] 0.19083f ; **FLOATING
C1521 control_logic_rw_0.pand3_0_0.gnd din0[1] 0.77904f ; **FLOATING
C1522 control_logic_rw_0.delay_chain_0.pinv_11_43.Z din0[1] 0.40811f ; **FLOATING
C1523 control_logic_rw_0.delay_chain_0.pinv_11_42.Z din0[1] 0.4185f ; **FLOATING
C1524 control_logic_rw_0.delay_chain_0.pinv_11_41.Z din0[1] 0.42398f ; **FLOATING
C1525 control_logic_rw_0.delay_chain_0.pinv_11_40.Z din0[1] 0.47516f ; **FLOATING
C1526 control_logic_rw_0.delay_chain_0.pinv_11_38.Z din0[1] 0.41008f ; **FLOATING
C1527 control_logic_rw_0.delay_chain_0.pinv_11_37.Z din0[1] 0.41993f ; **FLOATING
C1528 control_logic_rw_0.delay_chain_0.pinv_11_36.Z din0[1] 0.41516f ; **FLOATING
C1529 control_logic_rw_0.delay_chain_0.pinv_11_35.Z din0[1] 0.46689f ; **FLOATING
C1530 control_logic_rw_0.delay_chain_0.pinv_11_33.Z din0[1] 0.40257f ; **FLOATING
C1531 control_logic_rw_0.delay_chain_0.pinv_11_32.Z din0[1] 0.41922f ; **FLOATING
C1532 control_logic_rw_0.delay_chain_0.pinv_11_31.Z din0[1] 0.42454f ; **FLOATING
C1533 control_logic_rw_0.delay_chain_0.pinv_11_30.Z din0[1] 0.4698f ; **FLOATING
C1534 control_logic_rw_0.delay_chain_0.pinv_11_28.Z din0[1] 0.39693f ; **FLOATING
C1535 control_logic_rw_0.delay_chain_0.pinv_11_27.Z din0[1] 0.41291f ; **FLOATING
C1536 control_logic_rw_0.delay_chain_0.pinv_11_26.Z din0[1] 0.43038f ; **FLOATING
C1537 control_logic_rw_0.delay_chain_0.pinv_11_25.Z din0[1] 0.4757f ; **FLOATING
C1538 control_logic_rw_0.delay_chain_0.pinv_11_23.Z din0[1] 0.40655f ; **FLOATING
C1539 control_logic_rw_0.delay_chain_0.pinv_11_22.Z din0[1] 0.41716f ; **FLOATING
C1540 control_logic_rw_0.delay_chain_0.pinv_11_21.Z din0[1] 0.42389f ; **FLOATING
C1541 control_logic_rw_0.delay_chain_0.pinv_11_20.Z din0[1] 0.47515f ; **FLOATING
C1542 control_logic_rw_0.delay_chain_0.pinv_11_18.Z din0[1] 0.406f ; **FLOATING
C1543 control_logic_rw_0.delay_chain_0.pinv_11_17.Z din0[1] 0.41918f ; **FLOATING
C1544 control_logic_rw_0.delay_chain_0.pinv_11_16.Z din0[1] 0.42064f ; **FLOATING
C1545 control_logic_rw_0.delay_chain_0.pinv_11_15.Z din0[1] 0.47504f ; **FLOATING
C1546 control_logic_rw_0.delay_chain_0.pinv_11_13.Z din0[1] 0.40383f ; **FLOATING
C1547 control_logic_rw_0.delay_chain_0.pinv_11_12.Z din0[1] 0.41473f ; **FLOATING
C1548 control_logic_rw_0.delay_chain_0.pinv_11_11.Z din0[1] 0.41763f ; **FLOATING
C1549 control_logic_rw_0.delay_chain_0.pinv_11_10.Z din0[1] 0.47384f ; **FLOATING
C1550 control_logic_rw_0.delay_chain_0.pinv_11_8.Z din0[1] 0.41507f ; **FLOATING
C1551 control_logic_rw_0.delay_chain_0.pinv_11_7.Z din0[1] 0.42017f ; **FLOATING
C1552 control_logic_rw_0.delay_chain_0.pinv_11_6.Z din0[1] 0.41044f ; **FLOATING
C1553 control_logic_rw_0.delay_chain_0.pinv_11_5.Z din0[1] 0.46686f ; **FLOATING
C1554 control_logic_rw_0.delay_chain_0.pinv_11_3.Z din0[1] 0.41738f ; **FLOATING
C1555 control_logic_rw_0.delay_chain_0.pinv_11_2.Z din0[1] 0.42449f ; **FLOATING
C1556 control_logic_rw_0.delay_chain_0.pinv_11_1.Z din0[1] 0.4175f ; **FLOATING
C1557 control_logic_rw_0.delay_chain_0.pinv_11_0.Z din0[1] 0.4675f ; **FLOATING
C1558 a_n363_n919# din0[1] 0.01274f
C1559 a_n441_n919# din0[1] 0.01462f
C1560 a_n519_n919# din0[1] 0.02329f
C1561 a_n597_n919# din0[1] 0.01525f
C1562 a_n675_n919# din0[1] 0.02433f
C1563 a_n753_n919# din0[1] 0.9839f
C1564 a_n831_n919# din0[1] 0.98936f
C1565 a_n909_n919# din0[1] 0.01502f
C1566 a_n987_n919# din0[1] 0.02311f
C1567 a_n1065_n919# din0[1] 0.01422f
C1568 a_n1143_n919# din0[1] 0.01961f
C1569 a_n1567_n919# din0[1] 0.29995f
C1570 a_n1645_n919# din0[1] 0.29951f
C1571 a_n2461_n919# din0[1] 0.33055f
C1572 a_n2515_n919# din0[1] 0.33041f
C1573 data_dff_0.dff_0.net5 din0[1] 2.30867f
C1574 data_dff_0.dff_0.net2 din0[1] 6.64566f
C1575 data_dff_0.dff_1.net5 din0[1] 2.51497f
C1576 data_dff_0.dff_1.net2 din0[1] 4.70123f
C1577 din0[0] din0[1] 0.995f
C1578 data_dff_0.dff_0.net4 din0[1] 1.1185f
C1579 data_dff_0.dff_1.net3 din0[1] 4.30278f
C1580 a_n363_n691# din0[1] 0.02216f
C1581 a_n441_n691# din0[1] 0.02783f
C1582 a_n519_n691# din0[1] 0.03759f
C1583 a_n597_n691# din0[1] 0.0272f
C1584 a_n675_n691# din0[1] 0.03768f
C1585 a_n753_n691# din0[1] 0.03092f
C1586 a_n831_n691# din0[1] 0.03586f
C1587 a_n909_n691# din0[1] 0.02528f
C1588 a_n987_n691# din0[1] 0.03465f
C1589 a_n1065_n691# din0[1] 0.02483f
C1590 a_n1143_n691# din0[1] 0.02968f
C1591 a_n2147_n661# din0[1] 0.20466f
C1592 a_n2201_n661# din0[1] 0.20361f
C1593 a_n3839_n661# din0[1] 0.66288f
C1594 a_n3917_n661# din0[1] 1.06104f
C1595 a_n3971_n661# din0[1] 0.3952f
C1596 control_logic_rw_0.dff_buf_array_0.dff_buf_0_1.dff_0.net5 din0[1] 0.3904f
C1597 control_logic_rw_0.dff_buf_array_0.dff_buf_0_1.dff_0.net2 din0[1] 4.32999f
C1598 csb0 din0[1] 0.91214f
C1599 a_n2461_n513# din0[1] 2.36763f
C1600 a_n2515_n513# din0[1] 2.36947f
C1601 a_n2088_n255# din0[1] 0.03459f
C1602 control_logic_rw_0.pand2_1.pnand2_0_0.nmos_m1_w0_840_sactive_dli_0.S din0[1] 0.17718f
C1603 a_n2201_n255# din0[1] 0.14259f
C1604 a_n2461_n213# din0[1] 0.53827f
C1605 a_n2515_n213# din0[1] 0.53863f
C1606 a_n3369_n227# din0[1] 5.94459f
C1607 a_n3447_n227# din0[1] 5.94859f
C1608 control_logic_rw_0.dff_buf_array_0.dff_buf_0_0.dff_0.net5 din0[1] 3.0395f
C1609 control_logic_rw_0.dff_buf_array_0.dff_buf_0_0.dff_0.net2 din0[1] 2.35144f
C1610 web0 din0[1] 2.54842f
C1611 control_logic_rw_0.dff_buf_array_0.dff_buf_0_0.dff_0.net4 din0[1] 0.11865f
C1612 control_logic_rw_0.dff_buf_array_0.dff_buf_0_0.dff_0.net1 din0[1] 0.21548f
C1613 control_logic_rw_0.dff_buf_array_0.dff_buf_0_0.dff_0.clkb din0[1] 0.05887f
C1614 a_n2402_n107# din0[1] 0.08697f
C1615 control_logic_rw_0.pand2_0.pnand2_0_0.nmos_m1_w0_840_sactive_dli_0.S din0[1] 0.20423f
C1616 a_n2515_n107# din0[1] 0.11847f
C1617 a_n2461_151# din0[1] 0.41087f
C1618 a_n2515_151# din0[1] 0.4115f
C1619 a_n1377_298# din0[1] 0.2891f
C1620 a_n1431_298# din0[1] 0.28861f
C1621 a_n2147_299# din0[1] 0.13174f
C1622 a_n2201_299# din0[1] 0.13174f
C1623 bank_0.port_data_0.write_driver_array_0.write_driver_0.net6 din0[1] 0.30506f
C1624 bank_0.port_data_0.write_driver_array_0.write_driver_0.net5 din0[1] 1.97924f
C1625 a_n1723_599# din0[1] 0.20033f
C1626 a_n1801_599# din0[1] 0.2007f
C1627 a_n1529_705# din0[1] 0.01312f
C1628 a_n1607_705# din0[1] 0.01468f
C1629 a_n1685_705# din0[1] 0.02303f
C1630 a_n1763_705# din0[1] 0.01546f
C1631 a_n1841_705# din0[1] 0.02095f
C1632 a_n1919_705# din0[1] 0.0125f
C1633 a_n1997_705# din0[1] 0.01791f
C1634 a_n2343_705# din0[1] 0.04024f
C1635 control_logic_rw_0.pand3_0.pnand3_0_0.nmos_m1_w0_840_sactive_dactive_0.D din0[1] 0.04051f
C1636 a_n1529_927# din0[1] 0.02267f
C1637 a_n1607_927# din0[1] 0.02881f
C1638 a_n1685_927# din0[1] 0.03988f
C1639 a_n1763_927# din0[1] 0.03114f
C1640 a_n1841_927# din0[1] 0.03583f
C1641 a_n1919_927# din0[1] 0.02524f
C1642 a_n1997_927# din0[1] 0.02982f
C1643 a_n2402_963# din0[1] 1.45066f
C1644 a_n2461_963# din0[1] 1.45092f
C1645 a_n1774_1111# din0[1] 0.13497f
C1646 a_n1828_1111# din0[1] 0.13432f
C1647 a_n2402_1369# din0[1] 0.03226f
C1648 control_logic_rw_0.pnand2_1_0.nmos_m1_w0_840_sactive_dli_0.S din0[1] 0.84181f
C1649 a_n2515_1369# din0[1] 0.80886f
C1650 a_5313_1712# din0[1] 0.02173f
C1651 a_5259_1712# din0[1] 0.02437f
C1652 a_5053_1712# din0[1] 0.02232f
C1653 a_4999_1712# din0[1] 0.02362f
C1654 a_4793_1712# din0[1] 4.44492f
C1655 a_4739_1712# din0[1] 4.44659f
C1656 a_5372_1928# din0[1] 0.02281f
C1657 a_5313_1928# din0[1] 0.03115f
C1658 a_5259_1928# din0[1] 0.02662f
C1659 a_5112_1928# din0[1] 0.02415f
C1660 a_5053_1928# din0[1] 0.03167f
C1661 a_4999_1928# din0[1] 0.02614f
C1662 a_4852_1928# din0[1] 0.02348f
C1663 a_4793_1928# din0[1] 0.03084f
C1664 a_4739_1928# din0[1] 0.02544f
C1665 a_n1997_1923# din0[1] 0.02326f
C1666 a_n2330_1957# din0[1] 0.04125f
C1667 a_n2402_1923# din0[1] 0.0415f
C1668 a_n1919_2223# din0[1] 1.82673f
C1669 a_n1997_2223# din0[1] 1.83815f
C1670 a_n4427_2449# din0[1] 2.52107f
C1671 a_n4480_2449# din0[1] 2.51485f
C1672 a_5530_2493# din0[1] 0.42479f
C1673 a_5461_2493# din0[1] 0.35049f
C1674 a_5270_2493# din0[1] 1.73335f
C1675 a_5201_2493# din0[1] 1.7458f
C1676 a_5010_2493# din0[1] 0.17946f
C1677 a_4941_2493# din0[1] 0.17516f
C1678 a_4750_2493# din0[1] 0.17994f
C1679 a_4681_2493# din0[1] 0.29615f
C1680 a_4490_2493# din0[1] 0.1824f
C1681 a_4421_2493# din0[1] 0.18892f
C1682 bank_0.replica_bitcell_array_0.dummy_array_3_0.dummy_cell_1rw_18.q din0[1] 0.17522f
C1683 bank_0.replica_bitcell_array_0.dummy_array_3_0.dummy_cell_1rw_18.qb din0[1] 0.74376f
C1684 bank_0.replica_bitcell_array_0.dummy_array_1_0.dummy_cell_1rw_0.qb din0[1] 0.41443f
C1685 bank_0.replica_bitcell_array_0.dummy_array_1_0.dummy_cell_1rw_1.q din0[1] 0.4774f
C1686 bank_0.replica_bitcell_array_0.replica_column_0.dummy_cell_1rw_1.q din0[1] 0.11884f
C1687 bank_0.replica_bitcell_array_0.replica_column_0.dummy_cell_1rw_1.qb din0[1] 0.12161f
C1688 bank_0.replica_bitcell_array_0.dummy_array_2_0.dummy_cell_1rw_18.qb din0[1] 0.12462f
C1689 a_3797_2957# din0[1] 0.26543f
C1690 a_3743_2957# din0[1] 0.27105f
C1691 bank_0.replica_bitcell_array_0.dummy_array_3_0.dummy_cell_1rw_17.q din0[1] 0.11774f
C1692 bank_0.replica_bitcell_array_0.dummy_array_0.dummy_cell_1rw_0.q din0[1] 0.11202f
C1693 bank_0.replica_bitcell_array_0.dummy_array_0.dummy_cell_1rw_1.q din0[1] 0.39716f
C1694 a_3483_2957# din0[1] 0.02331f
C1695 a_3424_2957# din0[1] 0.03042f
C1696 a_3370_2957# din0[1] 0.02049f
C1697 bank_0.replica_bitcell_array_0.dummy_array_2_0.dummy_cell_1rw_17.q din0[1] 0.11788f
C1698 a_5530_3325# din0[1] 0.14734f
C1699 a_5461_3325# din0[1] 0.12252f
C1700 a_5270_3325# din0[1] 0.13486f
C1701 a_5201_3325# din0[1] 0.12031f
C1702 a_5010_3325# din0[1] 2.40088f
C1703 a_4941_3325# din0[1] 0.12728f
C1704 a_4490_3325# din0[1] 0.14409f
C1705 a_4421_3325# din0[1] 0.12929f
C1706 a_n4113_3141# din0[1] 0.67306f
C1707 a_n4166_3141# din0[1] 0.6673f
C1708 a_n4427_3141# din0[1] 0.01553f
C1709 a_n4480_3141# din0[1] 0.01071f
C1710 a_n4741_3141# din0[1] 0.01691f
C1711 a_n4794_3141# din0[1] 0.01266f
C1712 a_n5055_3141# din0[1] 0.01689f
C1713 a_n5108_3141# din0[1] 0.01157f
C1714 a_n5369_3141# din0[1] 0.01545f
C1715 a_n5422_3141# din0[1] 0.01003f
C1716 a_3483_3319# din0[1] 0.02565f
C1717 bank_0.port_address_0.and2_dec_0_0.pnand2_0.nmos_m1_w0_840_sactive_dli_0.S din0[1] 0.02767f
C1718 a_3370_3319# din0[1] 0.01961f
C1719 a_n4113_3289# din0[1] 0.01457f
C1720 a_3797_3467# din0[1] 0.24098f
C1721 a_3743_3467# din0[1] 0.24717f
C1722 a_5530_3511# din0[1] 0.14269f
C1723 a_5461_3511# din0[1] 0.12838f
C1724 a_4490_3511# din0[1] 0.14261f
C1725 a_4421_3511# din0[1] 0.12696f
C1726 a_3483_3467# din0[1] 0.02514f
C1727 bank_0.port_address_0.wordline_driver_array_0.wordline_driver_15.pnand2_0.nmos_m1_w0_840_sli_dactiv_uq0 din0[1] 0.02744f
C1728 a_3370_3467# din0[1] 0.01968f
C1729 bank_0.replica_bitcell_array_0.dummy_array_3_0.dummy_cell_1rw_16.q din0[1] 0.47106f
C1730 bank_0.replica_bitcell_array_0.bitcell_array_0.cell_1rw_15.qb din0[1] 0.26172f
C1731 bank_0.replica_bitcell_array_0.bitcell_array_0.cell_1rw_31.qb din0[1] 0.23352f
C1732 bank_0.replica_bitcell_array_0.replica_column_0.replica_cell_1rw_15.q din0[1] 0.32111f
C1733 bank_0.replica_bitcell_array_0.dummy_array_2_0.dummy_cell_1rw_16.qb din0[1] 0.11909f
C1734 a_3797_3829# din0[1] 0.0122f
C1735 a_2789_3467# din0[1] 0.02376f
C1736 bank_0.port_address_0.hierarchical_decoder_0.and2_dec_15.pnand2_0.nmos_m1_w0_840_sactive_dli_0.S din0[1] 3.61854f
C1737 a_1822_3467# din0[1] 1.66375f
C1738 a_1768_3467# din0[1] 1.67012f
C1739 a_2676_3467# din0[1] 3.61164f
C1740 a_3743_3829# din0[1] 0.0178f
C1741 a_3483_3829# din0[1] 0.02454f
C1742 a_3424_3829# din0[1] 0.49576f
C1743 a_3370_3829# din0[1] 0.48588f
C1744 a_3103_3829# din0[1] 0.01208f
C1745 a_1508_3467# din0[1] 0.02326f
C1746 bank_0.port_address_0.hierarchical_decoder_0.hierarchical_predecode2x4_1.and2_dec_3.pnand2_0.nmos_m_uq0 din0[1] 0.02416f
C1747 a_739_3467# din0[1] 0.64815f
C1748 a_685_3467# din0[1] 0.65446f
C1749 a_1395_3467# din0[1] 0.01793f
C1750 a_3049_3829# din0[1] 0.01736f
C1751 a_2789_3829# din0[1] 0.02397f
C1752 a_2730_3829# din0[1] 0.03012f
C1753 a_2676_3829# din0[1] 0.01916f
C1754 a_1822_3829# din0[1] 0.48802f
C1755 a_n4427_3289# din0[1] 0.01537f
C1756 a_n4480_3289# din0[1] 0.01037f
C1757 a_n4741_3289# din0[1] 2.4536f
C1758 a_n4794_3289# din0[1] 2.44853f
C1759 a_n5055_3289# din0[1] 0.01611f
C1760 a_n5108_3289# din0[1] 0.01154f
C1761 a_n5369_3289# din0[1] 0.01497f
C1762 a_1768_3829# din0[1] 0.49366f
C1763 a_1508_3829# din0[1] 0.02364f
C1764 a_1449_3829# din0[1] 0.02962f
C1765 a_1395_3829# din0[1] 0.01872f
C1766 a_739_3829# din0[1] 0.01154f
C1767 a_685_3829# din0[1] 0.01739f
C1768 a_3797_3975# din0[1] 0.36995f
C1769 a_3743_3975# din0[1] 0.37524f
C1770 bank_0.replica_bitcell_array_0.dummy_array_3_0.dummy_cell_1rw_15.q din0[1] 0.23729f
C1771 bank_0.replica_bitcell_array_0.bitcell_array_0.cell_1rw_14.qb din0[1] 0.41031f
C1772 bank_0.replica_bitcell_array_0.bitcell_array_0.cell_1rw_30.q din0[1] 0.11686f
C1773 bank_0.replica_bitcell_array_0.replica_column_0.replica_cell_1rw_14.q din0[1] 0.52855f
C1774 a_3483_3975# din0[1] 0.02426f
C1775 a_3424_3975# din0[1] 0.03021f
C1776 a_3370_3975# din0[1] 0.01985f
C1777 bank_0.replica_bitcell_array_0.dummy_array_2_0.dummy_cell_1rw_15.qb din0[1] 0.11929f
C1778 a_5530_4343# din0[1] 0.14269f
C1779 a_5461_4343# din0[1] 0.12882f
C1780 a_4490_4343# din0[1] 0.14368f
C1781 a_4421_4343# din0[1] 0.12863f
C1782 a_3103_3975# din0[1] 0.01133f
C1783 a_3049_3975# din0[1] 0.01676f
C1784 a_2789_3975# din0[1] 0.02327f
C1785 a_2730_3975# din0[1] 0.02919f
C1786 a_2676_3975# din0[1] 0.01834f
C1787 a_3483_4337# din0[1] 0.02473f
C1788 bank_0.port_address_0.wordline_driver_array_0.wordline_driver_14.pnand2_0.nmos_m1_w0_840_sli_dactiv_uq0 din0[1] 0.48304f
C1789 a_1822_3975# din0[1] 1.95334f
C1790 a_1768_3975# din0[1] 1.95927f
C1791 a_1508_3975# din0[1] 0.02427f
C1792 a_1449_3975# din0[1] 1.30052f
C1793 a_1395_3975# din0[1] 1.28946f
C1794 a_3370_4337# din0[1] 0.47574f
C1795 a_2789_4337# din0[1] 0.02328f
C1796 bank_0.port_address_0.hierarchical_decoder_0.and2_dec_14.pnand2_0.nmos_m1_w0_840_sactive_dli_0.S din0[1] 0.02391f
C1797 a_739_3975# din0[1] 0.35166f
C1798 a_685_3975# din0[1] 0.35604f
C1799 a_2676_4337# din0[1] 0.01778f
C1800 a_1508_4337# din0[1] 1.87225f
C1801 bank_0.port_address_0.hierarchical_decoder_0.hierarchical_predecode2x4_1.and2_dec_2.pnand2_0.nmos_m_uq0 din0[1] 2.13884f
C1802 a_1395_4337# din0[1] 0.28422f
C1803 a_3797_4485# din0[1] 0.24164f
C1804 a_3743_4485# din0[1] 0.24795f
C1805 a_5530_4529# din0[1] 0.14445f
C1806 a_5461_4529# din0[1] 0.1322f
C1807 a_4490_4529# din0[1] 0.14416f
C1808 a_4421_4529# din0[1] 0.12892f
C1809 a_3483_4485# din0[1] 0.02601f
C1810 bank_0.port_address_0.wordline_driver_array_0.wordline_driver_13.pnand2_0.nmos_m1_w0_840_sli_dactiv_uq0 din0[1] 0.02891f
C1811 a_3103_4485# din0[1] 0.23676f
C1812 a_3049_4485# din0[1] 0.24297f
C1813 a_3370_4485# din0[1] 0.01998f
C1814 bank_0.replica_bitcell_array_0.dummy_array_3_0.dummy_cell_1rw_14.qb din0[1] 0.47518f
C1815 bank_0.replica_bitcell_array_0.bitcell_array_0.cell_1rw_13.qb din0[1] 0.46541f
C1816 bank_0.replica_bitcell_array_0.bitcell_array_0.cell_1rw_29.q din0[1] 0.53201f
C1817 bank_0.replica_bitcell_array_0.dummy_array_2_0.dummy_cell_1rw_14.qb din0[1] 0.47827f
C1818 a_3797_4847# din0[1] 0.42107f
C1819 a_2789_4485# din0[1] 2.04143f
C1820 bank_0.port_address_0.hierarchical_decoder_0.and2_dec_13.pnand2_0.nmos_m1_w0_840_sactive_dli_0.S din0[1] 2.04219f
C1821 a_1822_4485# din0[1] 2.43026f
C1822 a_1768_4485# din0[1] 2.43663f
C1823 a_2676_4485# din0[1] 0.0177f
C1824 a_3743_4847# din0[1] 0.42664f
C1825 a_3483_4847# din0[1] 0.02392f
C1826 a_3424_4847# din0[1] 0.48567f
C1827 a_3370_4847# din0[1] 0.47566f
C1828 a_3103_4847# din0[1] 0.06894f
C1829 a_1508_4485# din0[1] 0.02429f
C1830 bank_0.port_address_0.hierarchical_decoder_0.hierarchical_predecode2x4_1.and2_dec_1.pnand2_0.nmos_m_uq0 din0[1] 1.48924f
C1831 a_1395_4485# din0[1] 1.4814f
C1832 a_3049_4847# din0[1] 0.07423f
C1833 a_2789_4847# din0[1] 0.02262f
C1834 a_2730_4847# din0[1] 2.28322f
C1835 a_2676_4847# din0[1] 2.27274f
C1836 a_1822_4847# din0[1] 0.1297f
C1837 a_1768_4847# din0[1] 0.1357f
C1838 a_1508_4847# din0[1] 0.02315f
C1839 a_1449_4847# din0[1] 0.02949f
C1840 a_1395_4847# din0[1] 0.01831f
C1841 a_n4113_4821# din0[1] 0.01447f
C1842 a_n4427_4821# din0[1] 0.01531f
C1843 a_n4480_4821# din0[1] 0.01017f
C1844 a_n4741_4821# din0[1] 2.29598f
C1845 a_n4794_4821# din0[1] 2.29132f
C1846 a_n5055_4821# din0[1] 0.01663f
C1847 a_n5108_4821# din0[1] 0.01182f
C1848 a_n5369_4821# din0[1] 0.01524f
C1849 a_3797_4993# din0[1] 0.94883f
C1850 a_3743_4993# din0[1] 0.95372f
C1851 bank_0.replica_bitcell_array_0.dummy_array_3_0.dummy_cell_1rw_13.qb din0[1] 0.47579f
C1852 bank_0.replica_bitcell_array_0.bitcell_array_0.cell_1rw_12.q din0[1] 0.1151f
C1853 bank_0.replica_bitcell_array_0.bitcell_array_0.cell_1rw_28.q din0[1] 0.41049f
C1854 a_3483_4993# din0[1] 0.02416f
C1855 a_3424_4993# din0[1] 0.03035f
C1856 a_3370_4993# din0[1] 0.01967f
C1857 bank_0.replica_bitcell_array_0.dummy_array_2_0.dummy_cell_1rw_13.q din0[1] 0.11938f
C1858 a_5530_5361# din0[1] 0.14411f
C1859 a_5461_5361# din0[1] 0.13211f
C1860 a_4490_5361# din0[1] 0.14502f
C1861 a_4421_5361# din0[1] 0.13052f
C1862 a_3103_4993# din0[1] 0.82419f
C1863 a_3049_4993# din0[1] 0.8296f
C1864 a_2789_4993# din0[1] 0.02281f
C1865 a_2730_4993# din0[1] 0.0284f
C1866 a_2676_4993# din0[1] 0.01788f
C1867 a_3483_5355# din0[1] 0.02506f
C1868 bank_0.port_address_0.wordline_driver_array_0.wordline_driver_12.pnand2_0.nmos_m1_w0_840_sli_dactiv_uq0 din0[1] 0.48832f
C1869 a_1822_4993# din0[1] 0.65918f
C1870 a_1768_4993# din0[1] 0.66528f
C1871 a_1508_4993# din0[1] 0.02329f
C1872 a_1449_4993# din0[1] 2.24956f
C1873 a_1395_4993# din0[1] 2.2384f
C1874 a_n4113_4969# din0[1] 0.01424f
C1875 a_3370_5355# din0[1] 0.48061f
C1876 a_3103_5397# din0[1] 0.16344f
C1877 a_3049_5397# din0[1] 0.16972f
C1878 a_2789_5355# din0[1] 0.02457f
C1879 bank_0.port_address_0.hierarchical_decoder_0.and2_dec_12.pnand2_0.nmos_m1_w0_840_sactive_dli_0.S din0[1] 0.02704f
C1880 a_n4427_4969# din0[1] 0.01521f
C1881 a_n4480_4969# din0[1] 0.01032f
C1882 a_n4741_4969# din0[1] 0.0163f
C1883 a_n4794_4969# din0[1] 0.01153f
C1884 a_n5055_4969# din0[1] 0.01643f
C1885 a_n5108_4969# din0[1] 0.01163f
C1886 a_n5369_4969# din0[1] 2.45203f
C1887 a_n5422_4969# din0[1] 2.4466f
C1888 a_2676_5355# din0[1] 0.01861f
C1889 a_1508_5355# din0[1] 0.02507f
C1890 bank_0.port_address_0.hierarchical_decoder_0.hierarchical_predecode2x4_1.and2_dec_0.pnand2_0.nmos_m_uq0 din0[1] 0.03048f
C1891 a_1395_5355# din0[1] 0.02282f
C1892 a_5530_5547# din0[1] 0.14268f
C1893 a_5461_5547# din0[1] 0.12856f
C1894 a_4490_5547# din0[1] 0.14354f
C1895 a_4421_5547# din0[1] 0.12822f
C1896 a_3483_5503# din0[1] 0.02556f
C1897 bank_0.port_address_0.wordline_driver_array_0.wordline_driver_11.pnand2_0.nmos_m1_w0_840_sli_dactiv_uq0 din0[1] 0.48543f
C1898 a_3103_5503# din0[1] 0.11906f
C1899 a_3049_5503# din0[1] 0.12526f
C1900 a_3370_5503# din0[1] 0.47741f
C1901 bank_0.replica_bitcell_array_0.dummy_array_3_0.dummy_cell_1rw_12.q din0[1] 0.23767f
C1902 bank_0.replica_bitcell_array_0.bitcell_array_0.cell_1rw_11.q din0[1] 0.8185f
C1903 bank_0.replica_bitcell_array_0.bitcell_array_0.cell_1rw_27.q din0[1] 0.46734f
C1904 bank_0.replica_bitcell_array_0.replica_column_0.replica_cell_1rw_11.q din0[1] 0.05937f
C1905 bank_0.replica_bitcell_array_0.dummy_array_2_0.dummy_cell_1rw_12.q din0[1] 0.23916f
C1906 a_3797_5865# din0[1] 0.25068f
C1907 a_2789_5503# din0[1] 0.02401f
C1908 bank_0.port_address_0.hierarchical_decoder_0.and2_dec_11.pnand2_0.nmos_m1_w0_840_sactive_dli_0.S din0[1] 0.02552f
C1909 a_2676_5503# din0[1] 0.01828f
C1910 a_3743_5865# din0[1] 0.25612f
C1911 a_3483_5865# din0[1] 0.02483f
C1912 a_3424_5865# din0[1] 0.03057f
C1913 a_3370_5865# din0[1] 0.02034f
C1914 a_3103_5865# din0[1] 0.64445f
C1915 a_3049_5865# din0[1] 0.65015f
C1916 a_2789_5865# din0[1] 0.02288f
C1917 a_2730_5865# din0[1] 0.02836f
C1918 a_2676_5865# din0[1] 0.01786f
C1919 a_3797_6011# din0[1] 5.90906f
C1920 a_3743_6011# din0[1] 5.91438f
C1921 bank_0.replica_bitcell_array_0.dummy_array_3_0.dummy_cell_1rw_11.q din0[1] 0.4091f
C1922 bank_0.replica_bitcell_array_0.bitcell_array_0.cell_1rw_10.q din0[1] 0.11474f
C1923 bank_0.replica_bitcell_array_0.bitcell_array_0.cell_1rw_26.q din0[1] 0.11673f
C1924 bank_0.replica_bitcell_array_0.replica_column_0.replica_cell_1rw_10.q din0[1] 0.11593f
C1925 a_3483_6011# din0[1] 0.02392f
C1926 a_3424_6011# din0[1] 0.48327f
C1927 a_3370_6011# din0[1] 0.47332f
C1928 bank_0.replica_bitcell_array_0.dummy_array_2_0.dummy_cell_1rw_11.q din0[1] 0.1179f
C1929 a_5530_6379# din0[1] 2.47571f
C1930 a_5461_6379# din0[1] 0.12881f
C1931 a_4490_6379# din0[1] 0.14263f
C1932 a_4421_6379# din0[1] 0.12727f
C1933 a_3103_6011# din0[1] 0.16989f
C1934 a_3049_6011# din0[1] 0.17584f
C1935 a_2789_6011# din0[1] 0.0226f
C1936 a_2730_6011# din0[1] 0.02773f
C1937 a_2676_6011# din0[1] 0.01762f
C1938 a_3483_6373# din0[1] 0.02496f
C1939 bank_0.port_address_0.wordline_driver_array_0.wordline_driver_10.pnand2_0.nmos_m1_w0_840_sli_dactiv_uq0 din0[1] 0.02706f
C1940 a_3370_6373# din0[1] 0.0195f
C1941 a_2789_6373# din0[1] 1.93873f
C1942 bank_0.port_address_0.hierarchical_decoder_0.and2_dec_10.pnand2_0.nmos_m1_w0_840_sactive_dli_0.S din0[1] 1.93942f
C1943 a_2676_6373# din0[1] 0.01773f
C1944 a_3797_6521# din0[1] 0.23568f
C1945 a_3743_6521# din0[1] 0.24195f
C1946 a_5530_6565# din0[1] 0.14427f
C1947 a_5461_6565# din0[1] 0.12988f
C1948 a_4490_6565# din0[1] 0.14407f
C1949 a_4421_6565# din0[1] 0.1289f
C1950 a_3483_6521# din0[1] 0.02613f
C1951 bank_0.port_address_0.wordline_driver_array_0.wordline_driver_9.pnand2_0.nmos_m1_w0_840_sli_dactive_uq0 din0[1] 0.02926f
C1952 a_3103_6521# din0[1] 0.15492f
C1953 a_3049_6521# din0[1] 0.16121f
C1954 a_3370_6521# din0[1] 0.02005f
C1955 bank_0.replica_bitcell_array_0.dummy_array_3_0.dummy_cell_1rw_10.qb din0[1] 0.47418f
C1956 bank_0.replica_bitcell_array_0.bitcell_array_0.cell_1rw_9.qb din0[1] 0.1159f
C1957 bank_0.replica_bitcell_array_0.bitcell_array_0.cell_1rw_25.q din0[1] 0.5293f
C1958 bank_0.replica_bitcell_array_0.dummy_array_2_0.dummy_cell_1rw_10.qb din0[1] 0.11947f
C1959 a_3797_6883# din0[1] 0.17296f
C1960 a_2789_6521# din0[1] 0.02378f
C1961 bank_0.port_address_0.hierarchical_decoder_0.and2_dec_9.pnand2_0.nmos_m1_w0_840_sactive_dli_0.S din0[1] 0.02525f
C1962 a_2676_6521# din0[1] 0.01818f
C1963 a_3743_6883# din0[1] 0.17798f
C1964 a_3483_6883# din0[1] 0.02451f
C1965 a_3424_6883# din0[1] 0.49505f
C1966 a_3370_6883# din0[1] 0.48477f
C1967 a_3103_6883# din0[1] 1.15682f
C1968 a_1508_6521# din0[1] 0.02396f
C1969 bank_0.port_address_0.hierarchical_decoder_0.hierarchical_predecode2x4_0.and2_dec_3.pnand2_0.nmos_m_uq0 din0[1] 1.38877f
C1970 a_739_6521# din0[1] 0.33947f
C1971 a_685_6521# din0[1] 0.34556f
C1972 a_1395_6521# din0[1] 1.38106f
C1973 a_3049_6883# din0[1] 1.16233f
C1974 a_2789_6883# din0[1] 0.02389f
C1975 a_2730_6883# din0[1] 0.02975f
C1976 a_2676_6883# din0[1] 0.01907f
C1977 a_1822_6883# din0[1] 2.89701f
C1978 a_n4113_6501# din0[1] 0.01461f
C1979 a_n4427_6501# din0[1] 0.01552f
C1980 a_n4480_6501# din0[1] 0.0107f
C1981 a_n4741_6501# din0[1] 0.01709f
C1982 a_n4794_6501# din0[1] 0.01263f
C1983 a_n5055_6501# din0[1] 2.30641f
C1984 a_n5108_6501# din0[1] 2.30117f
C1985 a_n5369_6501# din0[1] 0.01573f
C1986 a_n5422_6501# din0[1] 0.01006f
C1987 a_n4113_6649# din0[1] 0.01444f
C1988 a_1768_6883# din0[1] 2.90272f
C1989 a_1508_6883# din0[1] 0.02368f
C1990 a_1449_6883# din0[1] 0.0299f
C1991 a_1395_6883# din0[1] 0.01876f
C1992 a_739_6883# din0[1] 2.83447f
C1993 a_685_6883# din0[1] 2.83921f
C1994 a_n4427_6649# din0[1] 0.01538f
C1995 a_n4480_6649# din0[1] 0.01043f
C1996 a_n4741_6649# din0[1] 2.46902f
C1997 a_n4794_6649# din0[1] 2.46391f
C1998 a_n5055_6649# din0[1] 0.01659f
C1999 a_n5108_6649# din0[1] 0.01148f
C2000 a_n5369_6649# din0[1] 0.01532f
C2001 a_3797_7029# din0[1] 0.01223f
C2002 a_3743_7029# din0[1] 0.01804f
C2003 bank_0.replica_bitcell_array_0.dummy_array_3_0.dummy_cell_1rw_9.qb din0[1] 0.11875f
C2004 bank_0.replica_bitcell_array_0.bitcell_array_0.cell_1rw_8.qb din0[1] 0.40967f
C2005 bank_0.replica_bitcell_array_0.bitcell_array_0.cell_1rw_24.qb din0[1] 0.11846f
C2006 a_3483_7029# din0[1] 0.02467f
C2007 a_3424_7029# din0[1] 0.03005f
C2008 a_3370_7029# din0[1] 0.02027f
C2009 bank_0.replica_bitcell_array_0.dummy_array_2_0.dummy_cell_1rw_9.qb din0[1] 0.11962f
C2010 a_5530_7397# din0[1] 0.14409f
C2011 a_5461_7397# din0[1] 0.12926f
C2012 a_4490_7397# din0[1] 0.14587f
C2013 a_4421_7397# din0[1] 0.13493f
C2014 a_3103_7029# din0[1] 0.01178f
C2015 a_3049_7029# din0[1] 0.01723f
C2016 a_2789_7029# din0[1] 0.02359f
C2017 a_2730_7029# din0[1] 0.02951f
C2018 a_2676_7029# din0[1] 0.01862f
C2019 a_3743_7433# din0[1] 0.01015f
C2020 a_3483_7391# din0[1] 0.02671f
C2021 bank_0.port_address_0.wordline_driver_array_0.wordline_driver_8.pnand2_0.nmos_m1_w0_840_sli_dactive_uq0 din0[1] 0.49562f
C2022 a_1822_7029# din0[1] 1.62957f
C2023 a_1768_7029# din0[1] 1.63527f
C2024 a_1508_7029# din0[1] 0.02327f
C2025 a_1449_7029# din0[1] 0.02971f
C2026 a_1395_7029# din0[1] 0.01849f
C2027 a_3370_7391# din0[1] 0.48624f
C2028 a_2789_7391# din0[1] 0.0238f
C2029 bank_0.port_address_0.hierarchical_decoder_0.and2_dec_8.pnand2_0.nmos_m1_w0_840_sactive_dli_0.S din0[1] 0.02502f
C2030 a_739_7029# din0[1] 0.01257f
C2031 a_685_7029# din0[1] 0.01651f
C2032 a_2676_7391# din0[1] 0.01808f
C2033 a_1822_7433# din0[1] 5.33555f
C2034 a_1768_7433# din0[1] 5.34191f
C2035 a_1508_7391# din0[1] 1.10265f
C2036 bank_0.port_address_0.hierarchical_decoder_0.hierarchical_predecode2x4_0.and2_dec_2.pnand2_0.nmos_m_uq0 din0[1] 1.10396f
C2037 a_1395_7391# din0[1] 0.01803f
C2038 a_5530_7583# din0[1] 0.14387f
C2039 a_5461_7583# din0[1] 0.13113f
C2040 a_4490_7583# din0[1] 0.14542f
C2041 a_4421_7583# din0[1] 0.12808f
C2042 a_3483_7539# din0[1] 0.02514f
C2043 bank_0.port_address_0.wordline_driver_array_0.wordline_driver_7.pnand2_0.nmos_m1_w0_840_sli_dactive_uq0 din0[1] 0.49073f
C2044 a_3370_7539# din0[1] 0.48297f
C2045 bank_0.replica_bitcell_array_0.dummy_array_3_0.dummy_cell_1rw_8.qb din0[1] 0.47655f
C2046 bank_0.replica_bitcell_array_0.bitcell_array_0.cell_1rw_7.qb din0[1] 0.41057f
C2047 bank_0.replica_bitcell_array_0.bitcell_array_0.cell_1rw_23.q din0[1] 0.46748f
C2048 bank_0.replica_bitcell_array_0.dummy_array_2_0.dummy_cell_1rw_8.qb din0[1] 0.11931f
C2049 a_3797_7901# din0[1] 0.01211f
C2050 a_2789_7539# din0[1] 0.02368f
C2051 bank_0.port_address_0.hierarchical_decoder_0.and2_dec_7.pnand2_0.nmos_m1_w0_840_sactive_dli_0.S din0[1] 0.02463f
C2052 a_1822_7539# din0[1] 1.23578f
C2053 a_1768_7539# din0[1] 1.24216f
C2054 a_2676_7539# din0[1] 0.01794f
C2055 a_3743_7901# din0[1] 0.01762f
C2056 a_3483_7901# din0[1] 0.02411f
C2057 a_3424_7901# din0[1] 0.02965f
C2058 a_3370_7901# din0[1] 0.01971f
C2059 a_3103_7901# din0[1] 0.01068f
C2060 a_1508_7539# din0[1] 4.28364f
C2061 bank_0.port_address_0.hierarchical_decoder_0.hierarchical_predecode2x4_0.and2_dec_1.pnand2_0.nmos_m_uq0 din0[1] 4.28536f
C2062 a_1395_7539# din0[1] 0.01837f
C2063 a_3049_7901# din0[1] 0.01615f
C2064 a_2789_7901# din0[1] 0.02267f
C2065 a_2730_7901# din0[1] 0.02813f
C2066 a_2676_7901# din0[1] 0.01766f
C2067 a_1768_7901# din0[1] 0.01577f
C2068 a_1508_7901# din0[1] 0.35575f
C2069 a_1449_7901# din0[1] 0.36189f
C2070 a_1395_7901# din0[1] 0.01804f
C2071 a_3797_8047# din0[1] 0.01247f
C2072 a_3743_8047# din0[1] 0.01762f
C2073 bank_0.replica_bitcell_array_0.dummy_array_3_0.dummy_cell_1rw_7.q din0[1] 0.1175f
C2074 bank_0.replica_bitcell_array_0.bitcell_array_0.cell_1rw_6.qb din0[1] 0.116f
C2075 bank_0.replica_bitcell_array_0.bitcell_array_0.cell_1rw_22.qb din0[1] 0.26651f
C2076 a_3483_8047# din0[1] 0.02409f
C2077 a_3424_8047# din0[1] 0.03009f
C2078 a_3370_8047# din0[1] 0.01973f
C2079 bank_0.replica_bitcell_array_0.dummy_array_2_0.dummy_cell_1rw_7.qb din0[1] 0.11915f
C2080 a_5530_8415# din0[1] 0.14427f
C2081 a_5461_8415# din0[1] 0.13277f
C2082 a_4490_8415# din0[1] 0.14671f
C2083 a_4421_8415# din0[1] 0.12914f
C2084 a_3103_8047# din0[1] 0.01039f
C2085 a_3049_8047# din0[1] 0.01602f
C2086 a_2789_8047# din0[1] 0.02265f
C2087 a_2730_8047# din0[1] 0.02801f
C2088 a_2676_8047# din0[1] 0.01765f
C2089 a_3483_8409# din0[1] 0.02575f
C2090 bank_0.port_address_0.wordline_driver_array_0.wordline_driver_6.pnand2_0.nmos_m1_w0_840_sli_dactive_uq0 din0[1] 0.49126f
C2091 a_1822_8047# din0[1] 1.66634f
C2092 a_1768_8047# din0[1] 1.67234f
C2093 a_1508_8047# din0[1] 0.02274f
C2094 a_1449_8047# din0[1] 0.02848f
C2095 a_1395_8047# din0[1] 0.01786f
C2096 a_3370_8409# din0[1] 0.48304f
C2097 a_3103_8451# din0[1] 0.48853f
C2098 a_3049_8451# din0[1] 0.49481f
C2099 a_2789_8409# din0[1] 0.02363f
C2100 bank_0.port_address_0.hierarchical_decoder_0.and2_dec_6.pnand2_0.nmos_m1_w0_840_sactive_dli_0.S din0[1] 0.02474f
C2101 a_n4113_8181# din0[1] 0.01452f
C2102 a_n4427_8181# din0[1] 0.01533f
C2103 a_n4480_8181# din0[1] 0.01014f
C2104 a_n4741_8181# din0[1] 0.01655f
C2105 a_n4794_8181# din0[1] 0.01179f
C2106 a_n5055_8181# din0[1] 0.01654f
C2107 a_n5108_8181# din0[1] 0.01148f
C2108 a_n5369_8181# din0[1] 2.30159f
C2109 a_n5422_8181# din0[1] 2.29606f
C2110 a_2676_8409# din0[1] 0.01797f
C2111 a_1508_8409# din0[1] 0.02376f
C2112 bank_0.port_address_0.hierarchical_decoder_0.hierarchical_predecode2x4_0.and2_dec_0.pnand2_0.nmos_m_uq0 din0[1] 0.02592f
C2113 a_n4113_8329# din0[1] 0.01465f
C2114 a_n4166_8329# din0[1] 0.01004f
C2115 a_1395_8409# din0[1] 0.0185f
C2116 a_3797_8557# din0[1] 0.53556f
C2117 a_3743_8557# din0[1] 0.54184f
C2118 a_5530_8601# din0[1] 0.14242f
C2119 a_5461_8601# din0[1] 0.12915f
C2120 a_4490_8601# din0[1] 0.14257f
C2121 a_4421_8601# din0[1] 0.12674f
C2122 a_3483_8557# din0[1] 0.02485f
C2123 bank_0.port_address_0.wordline_driver_array_0.wordline_driver_5.pnand2_0.nmos_m1_w0_840_sli_dactive_uq0 din0[1] 0.02702f
C2124 a_3103_8557# din0[1] 0.23634f
C2125 a_3049_8557# din0[1] 0.24267f
C2126 a_3370_8557# din0[1] 0.01952f
C2127 bank_0.replica_bitcell_array_0.dummy_array_3_0.dummy_cell_1rw_6.qb din0[1] 0.23521f
C2128 bank_0.replica_bitcell_array_0.bitcell_array_0.cell_1rw_5.qb din0[1] 0.11615f
C2129 bank_0.replica_bitcell_array_0.bitcell_array_0.cell_1rw_21.qb din0[1] 1.0577f
C2130 bank_0.replica_bitcell_array_0.dummy_array_2_0.dummy_cell_1rw_6.qb din0[1] 0.11908f
C2131 a_3797_8919# din0[1] 0.01172f
C2132 a_2789_8557# din0[1] 1.64127f
C2133 bank_0.port_address_0.hierarchical_decoder_0.and2_dec_5.pnand2_0.nmos_m1_w0_840_sactive_dli_0.S din0[1] 1.64189f
C2134 a_2676_8557# din0[1] 0.01768f
C2135 a_3743_8919# din0[1] 0.01716f
C2136 a_3483_8919# din0[1] 0.02387f
C2137 a_3424_8919# din0[1] 0.48708f
C2138 a_n4427_8329# din0[1] 0.01561f
C2139 a_n4480_8329# din0[1] 0.01077f
C2140 a_n4741_8329# din0[1] 0.01644f
C2141 a_n4794_8329# din0[1] 0.01164f
C2142 a_n5055_8329# din0[1] 0.01629f
C2143 a_n5108_8329# din0[1] 0.01129f
C2144 a_n5369_8329# din0[1] 0.01517f
C2145 a_3370_8919# din0[1] 0.4769f
C2146 a_3103_8919# din0[1] 0.17083f
C2147 a_3049_8919# din0[1] 0.17661f
C2148 a_2789_8919# din0[1] 0.02264f
C2149 a_2730_8919# din0[1] 0.02793f
C2150 a_2676_8919# din0[1] 0.0176f
C2151 a_3797_9065# din0[1] 0.3483f
C2152 a_3743_9065# din0[1] 0.3537f
C2153 bank_0.replica_bitcell_array_0.dummy_array_3_0.dummy_cell_1rw_5.q din0[1] 0.23931f
C2154 bank_0.replica_bitcell_array_0.bitcell_array_0.cell_1rw_4.qb din0[1] 0.26221f
C2155 bank_0.replica_bitcell_array_0.bitcell_array_0.cell_1rw_20.q din0[1] 0.11677f
C2156 bank_0.replica_bitcell_array_0.replica_column_0.replica_cell_1rw_4.q din0[1] 0.57158f
C2157 a_3483_9065# din0[1] 0.02374f
C2158 a_3424_9065# din0[1] 0.48302f
C2159 a_3370_9065# din0[1] 0.47275f
C2160 bank_0.replica_bitcell_array_0.dummy_array_2_0.dummy_cell_1rw_5.qb din0[1] 0.11922f
C2161 a_5530_9433# din0[1] 0.14304f
C2162 a_5461_9433# din0[1] 0.13155f
C2163 a_4490_9433# din0[1] 0.14314f
C2164 a_4421_9433# din0[1] 0.12767f
C2165 a_3103_9065# din0[1] 0.01013f
C2166 a_3049_9065# din0[1] 0.01575f
C2167 a_2789_9065# din0[1] 0.02242f
C2168 a_2730_9065# din0[1] 0.02771f
C2169 a_n4741_9063# din0[1] 2.52522f
C2170 a_n4794_9063# din0[1] 2.51904f
C2171 a_2676_9065# din0[1] 0.01739f
C2172 a_3483_9427# din0[1] 0.02546f
C2173 bank_0.port_address_0.wordline_driver_array_0.wordline_driver_4.pnand2_0.nmos_m1_w0_840_sli_dactive_uq0 din0[1] 0.02723f
C2174 a_3370_9427# din0[1] 0.01935f
C2175 a_3103_9469# din0[1] 2.65787f
C2176 a_3049_9469# din0[1] 2.66413f
C2177 a_2789_9427# din0[1] 0.02296f
C2178 bank_0.port_address_0.hierarchical_decoder_0.and2_dec_4.pnand2_0.nmos_m1_w0_840_sactive_dli_0.S din0[1] 2.28773f
C2179 a_2676_9427# din0[1] 2.28207f
C2180 a_3797_9575# din0[1] 0.16698f
C2181 a_3743_9575# din0[1] 0.17325f
C2182 a_5530_9619# din0[1] 2.49338f
C2183 a_5461_9619# din0[1] 0.13079f
C2184 a_4490_9619# din0[1] 0.14408f
C2185 a_4421_9619# din0[1] 0.13709f
C2186 a_3483_9575# din0[1] 0.02489f
C2187 bank_0.port_address_0.wordline_driver_array_0.wordline_driver_3.pnand2_0.nmos_m1_w0_840_sli_dactive_uq0 din0[1] 0.48108f
C2188 a_3103_9575# din0[1] 2.36001f
C2189 a_3049_9575# din0[1] 2.36632f
C2190 a_3370_9575# din0[1] 0.4735f
C2191 bank_0.replica_bitcell_array_0.dummy_array_3_0.dummy_cell_1rw_4.qb din0[1] 1.06477f
C2192 bank_0.replica_bitcell_array_0.bitcell_array_0.cell_1rw_3.q din0[1] 0.23186f
C2193 bank_0.replica_bitcell_array_0.bitcell_array_0.cell_1rw_19.q din0[1] 0.46711f
C2194 bank_0.replica_bitcell_array_0.dummy_array_2_0.dummy_cell_1rw_4.q din0[1] 0.23843f
C2195 a_3797_9937# din0[1] 0.12865f
C2196 a_2789_9575# din0[1] 0.02299f
C2197 bank_0.port_address_0.hierarchical_decoder_0.and2_dec_3.pnand2_0.nmos_m1_w0_840_sactive_dli_0.S din0[1] 0.02333f
C2198 a_2676_9575# din0[1] 0.01743f
C2199 a_3743_9937# din0[1] 0.13422f
C2200 a_3483_9937# din0[1] 0.02372f
C2201 a_3424_9937# din0[1] 0.02933f
C2202 a_3370_9937# din0[1] 0.01924f
C2203 a_3103_9937# din0[1] 1.35142f
C2204 a_3049_9937# din0[1] 1.35698f
C2205 a_2789_9937# din0[1] 0.02234f
C2206 a_2730_9937# din0[1] 0.02762f
C2207 a_n4113_9861# din0[1] 0.01544f
C2208 a_n4166_9861# din0[1] 0.01077f
C2209 a_n4427_9861# din0[1] 7.15671f
C2210 a_n4480_9861# din0[1] 7.15189f
C2211 a_n4741_9861# din0[1] 0.01703f
C2212 a_n4794_9861# din0[1] 0.01176f
C2213 a_n5055_9861# din0[1] 0.01733f
C2214 a_n5108_9861# din0[1] 0.01149f
C2215 a_n5369_9861# din0[1] 0.01543f
C2216 a_n5422_9861# din0[1] 0.01002f
C2217 a_2676_9937# din0[1] 0.01732f
C2218 a_3797_10083# din0[1] 0.01277f
C2219 a_3743_10083# din0[1] 0.01778f
C2220 bank_0.replica_bitcell_array_0.dummy_array_3_0.dummy_cell_1rw_3.qb din0[1] 0.1193f
C2221 bank_0.replica_bitcell_array_0.bitcell_array_0.cell_1rw_2.qb din0[1] 0.82226f
C2222 bank_0.replica_bitcell_array_0.bitcell_array_0.cell_1rw_18.q din0[1] 0.237f
C2223 a_3483_10083# din0[1] 0.02425f
C2224 a_3424_10083# din0[1] 0.03053f
C2225 a_3370_10083# din0[1] 0.0199f
C2226 bank_0.replica_bitcell_array_0.dummy_array_2_0.dummy_cell_1rw_3.qb din0[1] 0.23691f
C2227 a_5530_10451# din0[1] 0.14743f
C2228 a_5461_10451# din0[1] 0.13352f
C2229 a_4490_10451# din0[1] 0.14742f
C2230 a_4421_10451# din0[1] 0.13045f
C2231 a_3103_10083# din0[1] 0.01065f
C2232 a_3049_10083# din0[1] 0.01608f
C2233 a_2789_10083# din0[1] 0.02265f
C2234 a_2730_10083# din0[1] 2.35083f
C2235 a_2676_10083# din0[1] 2.34035f
C2236 a_3797_10487# din0[1] 0.36061f
C2237 a_3743_10487# din0[1] 0.36676f
C2238 a_3483_10445# din0[1] 0.02534f
C2239 bank_0.port_address_0.wordline_driver_array_0.wordline_driver_2.pnand2_0.nmos_m1_w0_840_sli_dactive_uq0 din0[1] 0.49033f
C2240 row_addr_dff_0.dff_3.net5 din0[1] 1.15119f
C2241 row_addr_dff_0.dff_3.net2 din0[1] 0.93961f
C2242 addr0[0] din0[1] 1.40784f
C2243 a_3370_10445# din0[1] 0.48247f
C2244 a_3103_10487# din0[1] 0.15884f
C2245 a_3049_10487# din0[1] 0.16512f
C2246 a_2789_10445# din0[1] 0.02345f
C2247 bank_0.port_address_0.hierarchical_decoder_0.and2_dec_2.pnand2_0.nmos_m1_w0_840_sactive_dli_0.S din0[1] 0.0244f
C2248 a_2676_10445# din0[1] 0.01774f
C2249 a_5530_10637# din0[1] 0.14268f
C2250 a_5461_10637# din0[1] 0.12843f
C2251 a_4490_10637# din0[1] 0.14286f
C2252 a_4421_10637# din0[1] 0.12732f
C2253 a_3483_10593# din0[1] 0.02558f
C2254 bank_0.port_address_0.wordline_driver_array_0.wordline_driver_1.pnand2_0.nmos_m1_w0_840_sli_dactive_uq0 din0[1] 0.02798f
C2255 a_3370_10593# din0[1] 0.01985f
C2256 bank_0.replica_bitcell_array_0.dummy_array_3_0.dummy_cell_1rw_2.qb din0[1] 0.47533f
C2257 bank_0.replica_bitcell_array_0.bitcell_array_0.cell_1rw_1.qb din0[1] 0.46391f
C2258 bank_0.replica_bitcell_array_0.bitcell_array_0.cell_1rw_17.q din0[1] 1.40819f
C2259 bank_0.replica_bitcell_array_0.dummy_array_2_0.dummy_cell_1rw_2.qb din0[1] 0.47766f
C2260 a_3797_10955# din0[1] 0.01243f
C2261 a_2789_10593# din0[1] 2.38995f
C2262 bank_0.port_address_0.hierarchical_decoder_0.and2_dec_1.pnand2_0.nmos_m1_w0_840_sactive_dli_0.S din0[1] 2.3905f
C2263 a_2676_10593# din0[1] 0.01766f
C2264 a_3743_10955# din0[1] 0.01758f
C2265 a_3483_10955# din0[1] 9.58981f
C2266 a_3424_10955# din0[1] 10.05703f
C2267 a_3370_10955# din0[1] 0.48091f
C2268 a_3103_10955# din0[1] 0.1439f
C2269 row_addr_dff_0.dff_2.net5 din0[1] 7.06166f
C2270 row_addr_dff_0.dff_2.net2 din0[1] 1.22428f
C2271 addr0[1] din0[1] 1.03619f
C2272 a_3049_10955# din0[1] 0.14986f
C2273 a_2789_10955# din0[1] 0.0229f
C2274 a_2730_10955# din0[1] 0.02808f
C2275 a_2676_10955# din0[1] 0.01779f
C2276 a_3797_11101# din0[1] 0.01274f
C2277 a_3743_11101# din0[1] 0.01822f
C2278 bank_0.replica_bitcell_array_0.dummy_array_3_0.dummy_cell_1rw_1.qb din0[1] 0.11888f
C2279 bank_0.replica_bitcell_array_0.bitcell_array_0.cell_1rw_0.q din0[1] 0.23219f
C2280 bank_0.replica_bitcell_array_0.bitcell_array_0.cell_1rw_16.q din0[1] 0.1169f
C2281 a_3483_11101# din0[1] 0.02445f
C2282 a_3424_11101# din0[1] 0.48788f
C2283 a_3370_11101# din0[1] 0.47769f
C2284 bank_0.replica_bitcell_array_0.dummy_array_2_0.dummy_cell_1rw_1.qb din0[1] 1.08268f
C2285 a_5530_11469# din0[1] 0.14259f
C2286 a_5461_11469# din0[1] 0.12843f
C2287 a_4490_11469# din0[1] 2.55972f
C2288 a_4421_11469# din0[1] 0.12703f
C2289 a_3103_11101# din0[1] 0.01035f
C2290 a_3049_11101# din0[1] 0.01613f
C2291 a_2789_11101# din0[1] 0.02262f
C2292 a_2730_11101# din0[1] 0.02783f
C2293 a_2676_11101# din0[1] 0.01754f
C2294 a_3797_11505# din0[1] 0.6933f
C2295 a_3743_11505# din0[1] 0.69955f
C2296 a_3483_11463# din0[1] 0.02454f
C2297 bank_0.port_address_0.wordline_driver_array_0.wordline_driver_0.pnand2_0.nmos_m1_w0_840_sactive_dli_uq0 din0[1] 0.02626f
C2298 row_addr_dff_0.dff_1.net5 din0[1] 0.99581f
C2299 row_addr_dff_0.dff_1.net2 din0[1] 5.52658f
C2300 addr0[2] din0[1] 0.44417f
C2301 a_3370_11463# din0[1] 0.01912f
C2302 a_2789_11463# din0[1] 0.02276f
C2303 bank_0.port_address_0.hierarchical_decoder_0.and2_dec_0.pnand2_0.nmos_m1_w0_840_sactive_dli_0.S din0[1] 0.02286f
C2304 a_2676_11463# din0[1] 0.01737f
C2305 a_5530_11655# din0[1] 0.19011f
C2306 a_5461_11655# din0[1] 0.17853f
C2307 a_5270_11655# din0[1] 0.18316f
C2308 a_5201_11655# din0[1] 0.17852f
C2309 a_5010_11655# din0[1] 0.81828f
C2310 a_4941_11655# din0[1] 0.17586f
C2311 a_4750_11655# din0[1] 1.21889f
C2312 a_4681_11655# din0[1] 0.23414f
C2313 a_4490_11655# din0[1] 0.18222f
C2314 row_addr_dff_0.dff_0.net5 din0[1] 0.97979f
C2315 row_addr_dff_0.dff_0.net2 din0[1] 0.88842f
C2316 addr0[3] din0[1] 0.46169f
C2317 a_4421_11655# din0[1] 0.71652f
C2318 bank_0.replica_bitcell_array_0.dummy_array_3_0.dummy_cell_1rw_0.qb din0[1] 0.12755f
C2319 bank_0.replica_bitcell_array_0.dummy_array_0_0.dummy_cell_1rw_0.qb din0[1] 0.24198f
C2320 bank_0.replica_bitcell_array_0.dummy_array_0_0.dummy_cell_1rw_1.q din0[1] 0.12097f
C2321 bank_0.replica_bitcell_array_0.dummy_array_0_0.dummy_cell_1rw_1.qb din0[1] 0.63512f
C2322 bank_0.replica_bitcell_array_0.replica_column_0.dummy_cell_1rw_0.q din0[1] 0.05894f
C2323 bank_0.replica_bitcell_array_0.replica_column_0.dummy_cell_1rw_0.qb din0[1] 1.52614f
C2324 bank_0.replica_bitcell_array_0.dummy_array_2_0.dummy_cell_1rw_0.q din0[1] 0.77865f
C2325 w_n2769_n767# din0[1] 17.4507f
C2326 w_n4225_n767# din0[1] 7.31929f
C2327 w_n2769_44# din0[1] 11.6162f
C2328 w_n2769_857# din0[1] 9.66068f
C2329 w_n2769_1669# din0[1] 6.66748f
C2330 w_4605_1519# din0[1] 11.8821f
C2331 w_3116_2703# din0[1] 6.84936f
C2332 w_2422_3679# din0[1] 13.3356f
C2333 w_1141_3679# din0[1] 7.57496f
C2334 w_431_3679# din0[1] 4.6745f
C2335 w_n5644_2820# din0[1] 21.9701f
C2336 w_2422_4697# din0[1] 13.2272f
C2337 w_1141_4697# din0[1] 7.49573f
C2338 w_n5644_4500# din0[1] 21.8977f
C2339 w_2422_5715# din0[1] 13.2225f
C2340 w_2422_6733# din0[1] 13.3934f
C2341 w_1141_6733# din0[1] 7.51109f
C2342 w_431_6733# din0[1] 4.57378f
C2343 w_n5644_6180# din0[1] 21.9986f
C2344 w_2422_7751# din0[1] 13.214f
C2345 w_1141_7751# din0[1] 7.40295f
C2346 w_n5644_7860# din0[1] 21.9463f
C2347 w_2422_8769# din0[1] 13.1057f
C2348 w_2422_9787# din0[1] 13.1419f
C2349 w_n5644_9540# din0[1] 16.7195f
C2350 w_2422_10805# din0[1] 13.141f
.ends
