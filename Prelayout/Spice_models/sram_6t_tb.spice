* 6T SRAM Hold SNM - Real SKY130 PDK Models
.include "/home/devdutt/skywater-pdk-libs-sky130_fd_pr/cells/nfet_01v8/sky130_fd_pr__nfet_01v8__mismatch.corner.spice"
.include "/home/devdutt/skywater-pdk-libs-sky130_fd_pr/cells/nfet_01v8/sky130_fd_pr__nfet_01v8__tt.pm3.spice"
.include "/home/devdutt/skywater-pdk-libs-sky130_fd_pr/cells/pfet_01v8/sky130_fd_pr__pfet_01v8__mismatch.corner.spice"
.include "/home/devdutt/skywater-pdk-libs-sky130_fd_pr/cells/pfet_01v8/sky130_fd_pr__pfet_01v8__tt_discrete.corner.spice"
.include "/home/devdutt/skywater-pdk-libs-sky130_fd_pr/cells/pfet_01v8/sky130_fd_pr__pfet_01v8__tt.pm3.spice"

VDD VDD GND DC 1.8
Vin Q   GND DC 0

* INV1: input=Q, output=QB
XM4 QB Q  GND GND sky130_fd_pr__nfet_01v8 W=1.0u L=0.15u
XM6 QB Q  VDD VDD sky130_fd_pr__pfet_01v8 W=0.5u L=0.15u

* INV2: input=QB, output=Q2 (open loop)
XM3 Q2 QB GND GND sky130_fd_pr__nfet_01v8 W=1.0u L=0.15u
XM5 Q2 QB VDD VDD sky130_fd_pr__pfet_01v8 W=0.5u L=0.15u

.dc Vin 0 1.8 0.005
.print dc v(q) v(qb) v(q2)
.end
