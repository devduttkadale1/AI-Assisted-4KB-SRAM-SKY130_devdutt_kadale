* Tri-State Buffer
.param VDD=1.8

.model nfet_sky130 nmos level=8
+ tox=4.15e-9 toxe=4.15e-9 toxp=2.1e-9 toxref=4.15e-9
+ phi=0.7 vth0=0.49 k1=0.78 k2=0.0 k3=0.0
+ dvt0=1.0 dvt1=2.0 dvt2=-0.032
+ u0=160 ua=2.25e-9 ub=5.87e-19 uc=0.0
+ voff=-0.126 nfactor=2.1 cit=0.0 cdsc=0.0
+ cgso=2.4e-10 cgdo=2.4e-10
+ cj=1.7e-3 mj=0.5 cjsw=3.5e-10 mjsw=0.35
+ pclm=0.04 delta=0.01

.model pfet_sky130 pmos level=8
+ tox=4.15e-9 toxe=4.15e-9 toxp=2.1e-9 toxref=4.15e-9
+ phi=0.7 vth0=-0.50 k1=0.78 k2=0.0 k3=0.0
+ dvt0=1.0 dvt1=2.0 dvt2=-0.032
+ u0=30 ua=2.25e-9 ub=5.87e-19 uc=0.0
+ voff=-0.126 nfactor=2.1 cit=0.0 cdsc=0.0
+ cgso=2.4e-10 cgdo=2.4e-10
+ cj=1.7e-3 mj=0.5 cjsw=3.5e-10 mjsw=0.35
+ pclm=0.04 delta=0.01

VDD VDD GND DC {VDD}
VEN  EN  GND PULSE(0 {VDD} 5n 0.1n 0.1n 15n 30n)
VIn  In  GND PULSE(0 {VDD} 0  0.1n 0.1n 10n 20n)

MINVn ENB EN  GND GND nfet_sky130 W=1.0u L=0.15u
MINVp ENB EN  VDD VDD pfet_sky130 W=2.0u L=0.15u

MP1 Out ENB nodep VDD pfet_sky130 W=2.0u L=0.15u
MP2 nodep In VDD VDD pfet_sky130 W=2.0u L=0.15u
MN1 Out In  noden GND nfet_sky130 W=1.0u L=0.15u
MN2 noden EN GND  GND nfet_sky130 W=1.0u L=0.15u

COut Out GND 10f

.tran 0.01n 40n
.print tran v(In) v(EN) v(Out)
.end
