* NGSPICE file created from sram_2_16_sky130A_flat.ext - technology: sky130A

.option scale=10m

.subckt sram_2_16_sky130A_flat
X0 a_739_3829# din0[1] a_685_3829# w_431_3679# sky130_fd_pr__pfet_01v8 ad=3.192n pd=0.244m as=3.276n ps=0.246m w=84 l=15
X1 control_logic_rw_0.pnand2_1_0.nmos_m1_w0_840_sactive_dli_0.S control_logic_rw_0.pand2_0.Z a_n2515_1369# din0[1] sky130_fd_pr__nfet_01v8 ad=1.848n pd=0.128m as=3.276n ps=0.246m w=84 l=15
X2 a_n4427_9861# control_logic_rw_0.delay_chain_0.out a_n4480_9861# w_n5644_9540# sky130_fd_pr__pfet_01v8 ad=3.276n pd=0.246m as=3.192n ps=0.244m w=84 l=15
X3 a_n4741_6649# control_logic_rw_0.delay_chain_0.pinv_11_19.Z a_n4794_6649# w_n5644_6180# sky130_fd_pr__pfet_01v8 ad=3.276n pd=0.246m as=3.192n ps=0.244m w=84 l=15
X4 din0[1] bank_0.replica_bitcell_array_0.wl_0_13 bank_0.replica_bitcell_array_0.bitcell_array_0.cell_1rw_2.qb din0[1] sky130_fd_pr__nfet_01v8 ad=1.428n pd=0.152m as=3.864n ps=0.21m w=42 l=15
X5 bank_0.replica_bitcell_array_0.dummy_array_3_0.dummy_cell_1rw_8.q bank_0.replica_bitcell_array_0.dummy_array_3_0.dummy_cell_1rw_8.qb din0[1] din0[1] sky130_fd_pr__nfet_01v8 ad=3.864n pd=0.21m as=4.41n ps=0.322m w=126 l=15
X6 bank_0.replica_bitcell_array_0.dummy_array_3_0.dummy_cell_1rw_13.q bank_0.replica_bitcell_array_0.dummy_array_3_0.dummy_cell_1rw_13.qb din0[1] din0[1] sky130_fd_pr__nfet_01v8 ad=3.864n pd=0.21m as=4.41n ps=0.322m w=126 l=15
X7 a_n753_n919# control_logic_rw_0.pdriver_0_0.pinv_7_0.A a_n831_n919# din0[1] sky130_fd_pr__nfet_01v8 ad=1.795n pd=0.12m as=1.795n ps=0.12m w=57 l=15
X8 a_n4427_2449# control_logic_rw_0.delay_chain_0.pinv_11_44.Z a_n4480_2449# din0[1] sky130_fd_pr__nfet_01v8 ad=1.638n pd=0.162m as=1.596n ps=0.16m w=42 l=15
X9 din0[1] bank_0.replica_bitcell_array_0.wl_0_9 bank_0.replica_bitcell_array_0.bitcell_array_0.cell_1rw_22.qb din0[1] sky130_fd_pr__nfet_01v8 ad=1.428n pd=0.152m as=3.864n ps=0.21m w=42 l=15
X10 bank_0.replica_bitcell_array_0.replica_column_0.replica_cell_1rw_7.q din0[1] din0[1] din0[1] sky130_fd_pr__nfet_01v8 ad=3.864n pd=0.21m as=4.41n ps=0.322m w=126 l=15
X11 a_739_6883# row_addr_dff_0.dout_2 a_685_6883# w_431_6733# sky130_fd_pr__pfet_01v8 ad=3.192n pd=0.244m as=3.276n ps=0.246m w=84 l=15
X12 a_2789_6373# bank_0.port_address_0.hierarchical_decoder_0.predecode_5 bank_0.port_address_0.hierarchical_decoder_0.and2_dec_10.pnand2_0.nmos_m1_w0_840_sactive_dli_0.S din0[1] sky130_fd_pr__nfet_01v8 ad=3.192n pd=0.244m as=1.848n ps=0.128m w=84 l=15
X13 bank_0.replica_bitcell_array_0.replica_column_0.replica_cell_1rw_12.q din0[1] din0[1] din0[1] sky130_fd_pr__nfet_01v8 ad=3.864n pd=0.21m as=4.41n ps=0.322m w=126 l=15
X14 a_n3839_n661# control_logic_rw_0.dff_buf_array_0.dff_buf_0_1.pinv_0_0.A a_n3917_n661# w_n4225_n767# sky130_fd_pr__pfet_01v8 ad=3.192n pd=0.244m as=2.646n ps=0.147m w=84 l=15
X15 bank_0.port_address_0.hierarchical_decoder_0.and2_dec_15.pnand2_0.nmos_m1_w0_840_sactive_dli_0.S bank_0.port_address_0.hierarchical_decoder_0.predecode_0 a_2676_3467# din0[1] sky130_fd_pr__nfet_01v8 ad=1.848n pd=0.128m as=3.276n ps=0.246m w=84 l=15
X16 a_3797_7433# din0[1] a_3743_7433# din0[1] sky130_fd_pr__nfet_01v8 ad=1.596n pd=0.16m as=1.638n ps=0.162m w=42 l=15
X17 a_n2147_n661# control_logic_rw_0.pdriver_0_0.pinv_4_0.A a_n2201_n661# w_n2769_n767# sky130_fd_pr__pfet_01v8 ad=2.646n pd=0.147m as=3.276n ps=0.246m w=84 l=15
X18 a_n4741_9169# control_logic_rw_0.delay_chain_0.out a_n4794_9169# din0[1] sky130_fd_pr__nfet_01v8 ad=1.638n pd=0.162m as=1.596n ps=0.16m w=42 l=15
X19 row_addr_dff_0.dff_2.net4 row_addr_dff_0.dff_2.clkb row_addr_dff_0.dff_2.net3 din0[1] sky130_fd_pr__pfet_01v8 ad=2.915n pd=0.161m as=3.52n ps=0.238m w=55 l=15
X20 bank_0.replica_bitcell_array_0.bitcell_array_0.cell_1rw_29.qb bank_0.replica_bitcell_array_0.wl_0_2 din0[1] din0[1] sky130_fd_pr__nfet_01v8 ad=3.864n pd=0.21m as=1.428n ps=0.152m w=42 l=15
X21 a_n3369_n227# control_logic_rw_0.dff_buf_array_0.dout_bar_0 a_n3447_n227# din0[1] sky130_fd_pr__nfet_01v8 ad=2.128n pd=0.188m as=1.764n ps=0.119m w=56 l=15
X22 a_n5369_8181# control_logic_rw_0.delay_chain_0.pinv_11_14.Z a_n5422_8181# w_n5644_7860# sky130_fd_pr__pfet_01v8 ad=3.276n pd=0.246m as=3.192n ps=0.244m w=84 l=15
X23 din0[1] bank_0.replica_bitcell_array_0.replica_column_0.replica_cell_1rw_11.q din0[1] din0[1] sky130_fd_pr__nfet_01v8 ad=3.864n pd=0.21m as=1.57763u ps=0.1185 w=126 l=15
X24 din0[1] bank_0.replica_bitcell_array_0.replica_column_0.replica_cell_1rw_16.q din0[1] din0[1] sky130_fd_pr__nfet_01v8 ad=3.864n pd=0.21m as=0 ps=0 w=126 l=15
X25 bank_0.replica_bitcell_array_0.bitcell_array_0.cell_1rw_0.q bank_0.replica_bitcell_array_0.bitcell_array_0.cell_1rw_0.qb din0[1] din0[1] sky130_fd_pr__pfet_01v8 ad=1.925n pd=0.18m as=1.925n ps=0.18m w=55 l=15
X26 bank_0.replica_bitcell_array_0.dummy_array_3_0.dummy_cell_1rw_4.qb bank_0.replica_bitcell_array_0.wl_0_12 a_5530_9619# din0[1] sky130_fd_pr__nfet_01v8 ad=3.864n pd=0.21m as=1.428n ps=0.152m w=42 l=15
X27 din0[1] bank_0.replica_bitcell_array_0.bitcell_array_0.cell_1rw_10.q bank_0.replica_bitcell_array_0.bitcell_array_0.cell_1rw_10.qb din0[1] sky130_fd_pr__nfet_01v8 ad=4.41n pd=0.322m as=3.864n ps=0.21m w=126 l=15
X28 a_n1377_298# control_logic_rw_0.pdriver_1_0.pinv_6_0.A a_n1431_298# w_n2769_44# sky130_fd_pr__pfet_01v8 ad=3.307n pd=0.168m as=4.095n ps=0.288m w=105 l=15
X29 din0[1] row_addr_dff_0.dout_1 row_addr_dff_0.dff_2.net5 din0[1] sky130_fd_pr__nfet_01v8 ad=1.68n pd=0.122m as=2.352n ps=0.196m w=42 l=15
X30 a_3483_10955# control_logic_rw_0.wl_en a_3424_10955# w_2422_10805# sky130_fd_pr__pfet_01v8 ad=3.192n pd=0.244m as=1.848n ps=0.128m w=84 l=15
X31 din0[1] bank_0.replica_bitcell_array_0.bitcell_array_0.cell_1rw_2.q bank_0.replica_bitcell_array_0.bitcell_array_0.cell_1rw_2.qb din0[1] sky130_fd_pr__pfet_01v8 ad=1.925n pd=0.18m as=1.925n ps=0.18m w=55 l=15
X32 bank_0.port_address_0.hierarchical_decoder_0.and2_dec_4.pnand2_0.nmos_m1_w0_840_sactive_dli_0.S bank_0.port_address_0.hierarchical_decoder_0.predecode_3 a_2676_9427# din0[1] sky130_fd_pr__nfet_01v8 ad=1.848n pd=0.128m as=3.276n ps=0.246m w=84 l=15
X33 a_3797_6011# din0[1] a_3743_6011# w_2422_5715# sky130_fd_pr__pfet_01v8 ad=3.192n pd=0.244m as=3.276n ps=0.246m w=84 l=15
X34 a_n5369_4969# control_logic_rw_0.delay_chain_0.pinv_11_29.Z a_n5422_4969# w_n5644_4500# sky130_fd_pr__pfet_01v8 ad=3.276n pd=0.246m as=3.192n ps=0.244m w=84 l=15
X35 a_4490_11469# bank_0.replica_bitcell_array_0.wl_0_15 bank_0.replica_bitcell_array_0.dummy_array_2_0.dummy_cell_1rw_1.qb din0[1] sky130_fd_pr__nfet_01v8 ad=1.428n pd=0.152m as=3.864n ps=0.21m w=42 l=15
X36 bank_0.port_address_0.wordline_driver_array_0.wordline_driver_11.pnand2_0.nmos_m1_w0_840_sactive_dli_0.S bank_0.port_address_0.wordline_driver_array_0.in_4 a_3370_5503# din0[1] sky130_fd_pr__nfet_01v8 ad=1.848n pd=0.128m as=3.276n ps=0.246m w=84 l=15
X37 din0[1] bank_0.replica_bitcell_array_0.wl_0_12 din0[1] din0[1] sky130_fd_pr__nfet_01v8 ad=3.864n pd=0.21m as=0 ps=0 w=42 l=15
X38 din0[1] bank_0.replica_bitcell_array_0.dummy_array_2_0.dummy_cell_1rw_11.q bank_0.replica_bitcell_array_0.dummy_array_2_0.dummy_cell_1rw_11.qb din0[1] sky130_fd_pr__nfet_01v8 ad=4.41n pd=0.322m as=3.864n ps=0.21m w=126 l=15
X39 a_n1352_n227# control_logic_rw_0.dff_buf_array_0.dout_bar_0 a_n1430_n227# din0[1] sky130_fd_pr__nfet_01v8 ad=1.764n pd=0.119m as=1.764n ps=0.119m w=56 l=15
X40 din0[1] din0[1] din0[1] din0[1] sky130_fd_pr__pfet_01v8 ad=0.696n pd=90u as=0.92582u ps=0.08816 w=19 l=1
X41 a_3103_3975# din0[1] a_3049_3975# w_2422_3679# sky130_fd_pr__pfet_01v8 ad=3.192n pd=0.244m as=3.276n ps=0.246m w=84 l=15
X42 a_n1723_599# control_logic_rw_0.pdriver_1_0.pinv_8_0.Z a_n1801_599# din0[1] sky130_fd_pr__nfet_01v8 ad=1.596n pd=0.16m as=1.323n ps=0.105m w=42 l=15
X43 a_n5369_7489# control_logic_rw_0.delay_chain_0.pinv_11_14.Z a_n5422_7489# din0[1] sky130_fd_pr__nfet_01v8 ad=1.638n pd=0.162m as=1.596n ps=0.16m w=42 l=15
X44 a_n1919_2223# control_logic_rw_0.dff_buf_array_0.dout_1 a_n1997_2223# din0[1] sky130_fd_pr__nfet_01v8 ad=1.596n pd=0.16m as=1.323n ps=0.105m w=42 l=15
X45 bank_0.replica_bitcell_array_0.dummy_array_3_0.dummy_cell_1rw_2.q bank_0.replica_bitcell_array_0.dummy_array_3_0.dummy_cell_1rw_2.qb din0[1] din0[1] sky130_fd_pr__pfet_01v8 ad=1.925n pd=0.18m as=1.925n ps=0.18m w=55 l=15
X46 bank_0.replica_bitcell_array_0.bitcell_array_0.cell_1rw_1.q bank_0.replica_bitcell_array_0.bitcell_array_0.cell_1rw_1.qb din0[1] din0[1] sky130_fd_pr__nfet_01v8 ad=3.864n pd=0.21m as=4.41n ps=0.322m w=126 l=15
X47 a_n1588_n107# control_logic_rw_0.dff_buf_array_0.dout_bar_0 a_n1666_n107# din0[1] sky130_fd_pr__nfet_01v8 ad=1.764n pd=0.119m as=1.764n ps=0.119m w=56 l=15
X48 a_n2461_299# control_logic_rw_0.dff_buf_array_0.dout_bar_0 a_n2515_299# w_n2769_44# sky130_fd_pr__pfet_01v8 ad=3.192n pd=0.244m as=3.276n ps=0.246m w=84 l=15
X49 din0[1] bank_0.replica_bitcell_array_0.dummy_array_0.dummy_cell_1rw_0.q bank_0.replica_bitcell_array_0.dummy_array_0.dummy_cell_1rw_0.qb din0[1] sky130_fd_pr__pfet_01v8 ad=1.925n pd=0.18m as=1.925n ps=0.18m w=55 l=15
X50 din0[1] din0[1] din0[1] din0[1] sky130_fd_pr__nfet_01v8 ad=1.823n pd=0.184m as=0 ps=0 w=33 l=8
X51 bank_0.replica_bitcell_array_0.dummy_array_3_0.dummy_cell_1rw_3.q bank_0.replica_bitcell_array_0.dummy_array_3_0.dummy_cell_1rw_3.qb din0[1] din0[1] sky130_fd_pr__pfet_01v8 ad=1.925n pd=0.18m as=1.925n ps=0.18m w=55 l=15
X52 bank_0.replica_bitcell_array_0.bitcell_array_0.cell_1rw_7.q bank_0.replica_bitcell_array_0.wl_0_8 din0[1] din0[1] sky130_fd_pr__nfet_01v8 ad=3.864n pd=0.21m as=1.428n ps=0.152m w=42 l=15
X53 a_n4427_6649# control_logic_rw_0.delay_chain_0.pinv_11_19.Z a_n4480_6649# w_n5644_6180# sky130_fd_pr__pfet_01v8 ad=3.276n pd=0.246m as=3.192n ps=0.244m w=84 l=15
X54 control_logic_rw_0.dff_buf_array_0.dff_buf_0_0.dff_0.net4 din0[1] control_logic_rw_0.dff_buf_array_0.dff_buf_0_0.dff_0.net3 din0[1] sky130_fd_pr__nfet_01v8 ad=2.226n pd=0.148m as=2.73n ps=0.214m w=42 l=15
X55 a_n1567_n919# control_logic_rw_0.pdriver_0_0.pinv_6_0.A a_n1645_n919# din0[1] sky130_fd_pr__nfet_01v8 ad=1.638n pd=0.115m as=1.638n ps=0.115m w=52 l=15
X56 a_4793_1712# control_logic_rw_0.p_en_bar a_4739_1712# w_4605_1519# sky130_fd_pr__pfet_01v8 ad=3.192n pd=0.244m as=3.276n ps=0.246m w=84 l=15
X57 din0[1] bank_0.replica_bitcell_array_0.dummy_array_2_0.dummy_cell_1rw_17.q bank_0.replica_bitcell_array_0.dummy_array_2_0.dummy_cell_1rw_17.qb din0[1] sky130_fd_pr__pfet_01v8 ad=1.925n pd=0.18m as=1.925n ps=0.18m w=55 l=15
X58 din0[1] bank_0.replica_bitcell_array_0.wl_0_13 din0[1] din0[1] sky130_fd_pr__nfet_01v8 ad=1.428n pd=0.152m as=0 ps=0 w=42 l=15
X59 a_n1763_927# control_logic_rw_0.dff_buf_array_0.dout_bar_0 a_n1841_927# w_n2769_857# sky130_fd_pr__pfet_01v8 ad=3.78n pd=0.183m as=3.78n ps=0.183m w=120 l=15
X60 a_3103_8919# din0[1] a_3049_8919# w_2422_8769# sky130_fd_pr__pfet_01v8 ad=3.192n pd=0.244m as=3.276n ps=0.246m w=84 l=15
X61 bank_0.replica_bitcell_array_0.dummy_array_2_0.dummy_cell_1rw_8.q bank_0.replica_bitcell_array_0.wl_0_8 a_4421_7583# din0[1] sky130_fd_pr__nfet_01v8 ad=3.864n pd=0.21m as=1.428n ps=0.152m w=42 l=15
X62 a_3483_4485# control_logic_rw_0.wl_en bank_0.port_address_0.wordline_driver_array_0.wordline_driver_13.pnand2_0.nmos_m1_w0_840_sactive_dli_0.S din0[1] sky130_fd_pr__nfet_01v8 ad=3.192n pd=0.244m as=1.848n ps=0.128m w=84 l=15
X63 a_3797_10955# din0[1] a_3743_10955# w_2422_10805# sky130_fd_pr__pfet_01v8 ad=3.192n pd=0.244m as=3.276n ps=0.246m w=84 l=15
X64 a_3797_9469# din0[1] a_3743_9469# din0[1] sky130_fd_pr__nfet_01v8 ad=1.596n pd=0.16m as=1.638n ps=0.162m w=42 l=15
X65 bank_0.replica_bitcell_array_0.bitcell_array_0.cell_1rw_25.qb bank_0.replica_bitcell_array_0.wl_0_6 din0[1] din0[1] sky130_fd_pr__nfet_01v8 ad=3.864n pd=0.21m as=1.428n ps=0.152m w=42 l=15
X66 bank_0.replica_bitcell_array_0.bitcell_array_0.cell_1rw_29.q bank_0.replica_bitcell_array_0.bitcell_array_0.cell_1rw_29.qb din0[1] din0[1] sky130_fd_pr__pfet_01v8 ad=1.925n pd=0.18m as=1.925n ps=0.18m w=55 l=15
X67 a_2730_10083# bank_0.port_address_0.hierarchical_decoder_0.predecode_1 a_2676_10083# w_2422_9787# sky130_fd_pr__pfet_01v8 ad=1.848n pd=0.128m as=3.276n ps=0.246m w=84 l=15
X68 bank_0.replica_bitcell_array_0.dummy_array_3_0.dummy_cell_1rw_8.q bank_0.replica_bitcell_array_0.dummy_array_3_0.dummy_cell_1rw_8.qb din0[1] din0[1] sky130_fd_pr__pfet_01v8 ad=1.925n pd=0.18m as=1.925n ps=0.18m w=55 l=15
X69 bank_0.replica_bitcell_array_0.bitcell_array_0.cell_1rw_15.qb bank_0.replica_bitcell_array_0.wl_0_0 din0[1] din0[1] sky130_fd_pr__nfet_01v8 ad=3.864n pd=0.21m as=1.428n ps=0.152m w=42 l=15
X70 a_n4427_9169# control_logic_rw_0.delay_chain_0.out a_n4480_9169# din0[1] sky130_fd_pr__nfet_01v8 ad=1.638n pd=0.162m as=1.596n ps=0.16m w=42 l=15
X71 din0[1] bank_0.replica_bitcell_array_0.replica_column_0.replica_cell_1rw_7.q din0[1] din0[1] sky130_fd_pr__nfet_01v8 ad=3.864n pd=0.21m as=0 ps=0 w=126 l=15
X72 din0[1] bank_0.replica_bitcell_array_0.replica_column_0.replica_cell_1rw_12.q din0[1] din0[1] sky130_fd_pr__nfet_01v8 ad=3.864n pd=0.21m as=0 ps=0 w=126 l=15
X73 a_3483_10445# control_logic_rw_0.wl_en bank_0.port_address_0.wordline_driver_array_0.wordline_driver_2.pnand2_0.nmos_m1_w0_840_sactive_dli_0.S din0[1] sky130_fd_pr__nfet_01v8 ad=3.192n pd=0.244m as=1.848n ps=0.128m w=84 l=15
X74 a_1822_7433# din0[1] a_1768_7433# din0[1] sky130_fd_pr__nfet_01v8 ad=1.596n pd=0.16m as=1.638n ps=0.162m w=42 l=15
X75 data_dff_0.dff_1.clkb din0[1] din0[1] din0[1] sky130_fd_pr__pfet_01v8 ad=2.53n pd=0.202m as=2.53n ps=0.202m w=55 l=15
X76 a_3797_8047# din0[1] a_3743_8047# w_2422_7751# sky130_fd_pr__pfet_01v8 ad=3.192n pd=0.244m as=3.276n ps=0.246m w=84 l=15
X77 bank_0.replica_bitcell_array_0.replica_column_0.replica_cell_1rw_7.q din0[1] din0[1] din0[1] sky130_fd_pr__pfet_01v8 ad=1.925n pd=0.18m as=1.925n ps=0.18m w=55 l=15
X78 bank_0.replica_bitcell_array_0.dummy_array_2_0.dummy_cell_1rw_16.qb bank_0.replica_bitcell_array_0.wl_0_0 a_4490_3511# din0[1] sky130_fd_pr__nfet_01v8 ad=3.864n pd=0.21m as=1.428n ps=0.152m w=42 l=15
X79 a_3797_3829# din0[1] a_3743_3829# w_2422_3679# sky130_fd_pr__pfet_01v8 ad=3.192n pd=0.244m as=3.276n ps=0.246m w=84 l=15
X80 control_logic_rw_0.dff_buf_array_0.dff_buf_0_0.dff_0.net3 control_logic_rw_0.dff_buf_array_0.dff_buf_0_0.dff_0.net1 din0[1] din0[1] sky130_fd_pr__pfet_01v8 ad=3.465n pd=0.236m as=2.2n ps=0.135m w=55 l=15
X81 bank_0.replica_bitcell_array_0.dummy_array_2_0.dummy_cell_1rw_0.q bank_0.replica_bitcell_array_0.dummy_array_2_0.dummy_cell_1rw_0.qb din0[1] din0[1] sky130_fd_pr__pfet_01v8 ad=1.925n pd=0.18m as=1.925n ps=0.18m w=55 l=15
X82 a_3424_9065# bank_0.port_address_0.wordline_driver_array_0.in_11 a_3370_9065# w_2422_8769# sky130_fd_pr__pfet_01v8 ad=1.848n pd=0.128m as=3.276n ps=0.246m w=84 l=15
X83 bank_0.port_address_0.wordline_driver_array_0.wordline_driver_7.pnand2_0.nmos_m1_w0_840_sactive_dli_0.S bank_0.port_address_0.wordline_driver_array_0.in_8 a_3370_7539# din0[1] sky130_fd_pr__nfet_01v8 ad=1.848n pd=0.128m as=3.276n ps=0.246m w=84 l=15
X84 din0[1] bank_0.replica_bitcell_array_0.wl_0_15 bank_0.replica_bitcell_array_0.bitcell_array_0.cell_1rw_0.q din0[1] sky130_fd_pr__nfet_01v8 ad=1.428n pd=0.152m as=3.864n ps=0.21m w=42 l=15
X85 a_3424_4847# bank_0.port_address_0.wordline_driver_array_0.in_2 a_3370_4847# w_2422_4697# sky130_fd_pr__pfet_01v8 ad=1.848n pd=0.128m as=3.276n ps=0.246m w=84 l=15
X86 din0[1] bank_0.replica_bitcell_array_0.bitcell_array_0.cell_1rw_31.q bank_0.replica_bitcell_array_0.bitcell_array_0.cell_1rw_31.qb din0[1] sky130_fd_pr__pfet_01v8 ad=1.925n pd=0.18m as=1.925n ps=0.18m w=55 l=15
X87 bank_0.replica_bitcell_array_0.replica_column_0.replica_cell_1rw_0.q din0[1] din0[1] din0[1] sky130_fd_pr__pfet_01v8 ad=1.925n pd=0.18m as=1.925n ps=0.18m w=55 l=15
X88 din0[1] bank_0.replica_bitcell_array_0.bitcell_array_0.cell_1rw_27.q bank_0.replica_bitcell_array_0.bitcell_array_0.cell_1rw_27.qb din0[1] sky130_fd_pr__nfet_01v8 ad=4.41n pd=0.322m as=3.864n ps=0.21m w=126 l=15
X89 a_3103_5397# din0[1] a_3049_5397# din0[1] sky130_fd_pr__nfet_01v8 ad=1.596n pd=0.16m as=1.638n ps=0.162m w=42 l=15
X90 a_3103_10083# din0[1] a_3049_10083# w_2422_9787# sky130_fd_pr__pfet_01v8 ad=3.192n pd=0.244m as=3.276n ps=0.246m w=84 l=15
X91 din0[1] bank_0.replica_bitcell_array_0.dummy_array_0.dummy_cell_1rw_1.q bank_0.replica_bitcell_array_0.dummy_array_0.dummy_cell_1rw_1.qb din0[1] sky130_fd_pr__nfet_01v8 ad=4.41n pd=0.322m as=3.864n ps=0.21m w=126 l=15
X92 din0[1] bank_0.replica_bitcell_array_0.dummy_array_3_0.dummy_cell_1rw_6.q bank_0.replica_bitcell_array_0.dummy_array_3_0.dummy_cell_1rw_6.qb din0[1] sky130_fd_pr__pfet_01v8 ad=1.925n pd=0.18m as=1.925n ps=0.18m w=55 l=15
X93 a_n1065_n691# control_logic_rw_0.pdriver_0_0.pinv_7_0.A a_n1143_n691# w_n2769_n767# sky130_fd_pr__pfet_01v8 ad=3.622n pd=0.178m as=3.622n ps=0.178m w=115 l=15
X94 bank_0.replica_bitcell_array_0.bitcell_array_0.cell_1rw_24.q bank_0.replica_bitcell_array_0.bitcell_array_0.cell_1rw_24.qb din0[1] din0[1] sky130_fd_pr__pfet_01v8 ad=1.925n pd=0.18m as=1.925n ps=0.18m w=55 l=15
X95 data_dff_0.dff_1.clkb din0[1] din0[1] din0[1] sky130_fd_pr__nfet_01v8 ad=1.932n pd=0.176m as=1.932n ps=0.176m w=42 l=15
X96 din0[1] bank_0.replica_bitcell_array_0.dummy_array_0_0.dummy_cell_1rw_0.q bank_0.replica_bitcell_array_0.dummy_array_0_0.dummy_cell_1rw_0.qb din0[1] sky130_fd_pr__pfet_01v8 ad=1.925n pd=0.18m as=1.925n ps=0.18m w=55 l=15
X97 a_3797_9575# din0[1] a_3743_9575# din0[1] sky130_fd_pr__nfet_01v8 ad=1.596n pd=0.16m as=1.638n ps=0.162m w=42 l=15
X98 din0[1] bank_0.replica_bitcell_array_0.dummy_array_3_0.dummy_cell_1rw_7.q bank_0.replica_bitcell_array_0.dummy_array_3_0.dummy_cell_1rw_7.qb din0[1] sky130_fd_pr__nfet_01v8 ad=4.41n pd=0.322m as=3.864n ps=0.21m w=126 l=15
X99 data_dff_0.dff_0.net2 data_dff_0.dff_0.clkb data_dff_0.dff_0.net1 din0[1] sky130_fd_pr__pfet_01v8 ad=3.74n pd=0.246m as=2.915n ps=0.161m w=55 l=15
X100 a_3797_6883# din0[1] a_3743_6883# w_2422_6733# sky130_fd_pr__pfet_01v8 ad=3.192n pd=0.244m as=3.276n ps=0.246m w=84 l=15
X101 bank_0.replica_bitcell_array_0.bitcell_array_0.cell_1rw_2.q bank_0.replica_bitcell_array_0.bitcell_array_0.cell_1rw_2.qb din0[1] din0[1] sky130_fd_pr__nfet_01v8 ad=3.864n pd=0.21m as=4.41n ps=0.322m w=126 l=15
X102 din0[1] bank_0.replica_bitcell_array_0.replica_column_0.replica_cell_1rw_5.q din0[1] din0[1] sky130_fd_pr__pfet_01v8 ad=1.925n pd=0.18m as=0 ps=0 w=55 l=15
X103 a_5530_6379# bank_0.replica_bitcell_array_0.wl_0_5 bank_0.replica_bitcell_array_0.dummy_array_3_0.dummy_cell_1rw_11.qb din0[1] sky130_fd_pr__nfet_01v8 ad=1.428n pd=0.152m as=3.864n ps=0.21m w=42 l=15
X104 row_addr_dff_0.dff_1.net2 row_addr_dff_0.dff_3.clk row_addr_dff_0.dff_1.net1 din0[1] sky130_fd_pr__nfet_01v8 ad=2.856n pd=0.22m as=2.226n ps=0.148m w=42 l=15
X105 din0[1] bank_0.replica_bitcell_array_0.wl_0_5 din0[1] din0[1] sky130_fd_pr__nfet_01v8 ad=1.428n pd=0.152m as=0 ps=0 w=42 l=15
X106 a_n2088_1411# control_logic_rw_0.delay_chain_0.out a_n2142_1411# din0[1] sky130_fd_pr__nfet_01v8 ad=1.596n pd=0.16m as=1.638n ps=0.162m w=42 l=15
X107 bank_0.replica_bitcell_array_0.bitcell_array_0.cell_1rw_31.q bank_0.replica_bitcell_array_0.wl_0_0 din0[1] din0[1] sky130_fd_pr__nfet_01v8 ad=3.864n pd=0.21m as=1.428n ps=0.152m w=42 l=15
X108 bank_0.replica_bitcell_array_0.bitcell_array_0.cell_1rw_17.q bank_0.replica_bitcell_array_0.bitcell_array_0.cell_1rw_17.qb din0[1] din0[1] sky130_fd_pr__pfet_01v8 ad=1.925n pd=0.18m as=1.925n ps=0.18m w=55 l=15
X109 bank_0.replica_bitcell_array_0.replica_column_0.replica_cell_1rw_1.q din0[1] din0[1] din0[1] sky130_fd_pr__nfet_01v8 ad=3.864n pd=0.21m as=4.41n ps=0.322m w=126 l=15
X110 din0[1] bank_0.replica_bitcell_array_0.wl_0_11 bank_0.replica_bitcell_array_0.bitcell_array_0.cell_1rw_4.qb din0[1] sky130_fd_pr__nfet_01v8 ad=1.428n pd=0.152m as=3.864n ps=0.21m w=42 l=15
X111 a_1508_7539# row_addr_dff_0.dout_3 bank_0.port_address_0.hierarchical_decoder_0.hierarchical_predecode2x4_0.and2_dec_1.pnand2_0.nmos_m1_w0_840_sactive_dli_0.S din0[1] sky130_fd_pr__nfet_01v8 ad=3.192n pd=0.244m as=1.848n ps=0.128m w=84 l=15
X112 a_1508_4847# row_addr_dff_0.dout_1 a_1449_4847# w_1141_4697# sky130_fd_pr__pfet_01v8 ad=3.192n pd=0.244m as=1.848n ps=0.128m w=84 l=15
X113 control_logic_rw_0.pand3_0.pnand3_0_0.nmos_m1_w0_840_sactive_dactive_0.S control_logic_rw_0.dff_buf_array_0.dout_bar_0 a_n2515_705# din0[1] sky130_fd_pr__nfet_01v8 ad=1.848n pd=0.128m as=3.276n ps=0.246m w=84 l=15
X114 bank_0.replica_bitcell_array_0.bitcell_array_0.cell_1rw_17.qb bank_0.replica_bitcell_array_0.wl_0_14 din0[1] din0[1] sky130_fd_pr__nfet_01v8 ad=3.864n pd=0.21m as=1.428n ps=0.152m w=42 l=15
X115 data_dff_0.dff_0.net2 din0[1] data_dff_0.dff_0.net1 din0[1] sky130_fd_pr__nfet_01v8 ad=2.856n pd=0.22m as=2.226n ps=0.148m w=42 l=15
X116 din0[1] din0[1] din0[1] din0[1] sky130_fd_pr__nfet_01v8 ad=1.936n pd=0.134m as=0 ps=0 w=57 l=15
X117 a_n441_n691# control_logic_rw_0.pdriver_0_0.pinv_7_0.A a_n519_n691# w_n2769_n767# sky130_fd_pr__pfet_01v8 ad=3.622n pd=0.178m as=3.622n ps=0.178m w=115 l=15
X118 bank_0.replica_bitcell_array_0.bitcell_array_0.cell_1rw_18.q bank_0.replica_bitcell_array_0.bitcell_array_0.cell_1rw_18.qb din0[1] din0[1] sky130_fd_pr__pfet_01v8 ad=1.925n pd=0.18m as=1.925n ps=0.18m w=55 l=15
X119 a_4490_9433# bank_0.replica_bitcell_array_0.wl_0_11 bank_0.replica_bitcell_array_0.dummy_array_2_0.dummy_cell_1rw_5.qb din0[1] sky130_fd_pr__nfet_01v8 ad=1.428n pd=0.152m as=3.864n ps=0.21m w=42 l=15
X120 a_n5055_7383# control_logic_rw_0.delay_chain_0.pinv_11_19.Z a_n5108_7383# din0[1] sky130_fd_pr__nfet_01v8 ad=1.638n pd=0.162m as=1.596n ps=0.16m w=42 l=15
X121 a_n5055_6501# control_logic_rw_0.delay_chain_0.pinv_11_24.Z a_n5108_6501# w_n5644_6180# sky130_fd_pr__pfet_01v8 ad=3.276n pd=0.246m as=3.192n ps=0.244m w=84 l=15
X122 bank_0.replica_bitcell_array_0.dummy_array_3_0.dummy_cell_1rw_4.q bank_0.replica_bitcell_array_0.dummy_array_3_0.dummy_cell_1rw_4.qb din0[1] din0[1] sky130_fd_pr__nfet_01v8 ad=3.864n pd=0.21m as=4.41n ps=0.322m w=126 l=15
X123 bank_0.replica_bitcell_array_0.dummy_array_3_0.dummy_cell_1rw_9.q bank_0.replica_bitcell_array_0.dummy_array_3_0.dummy_cell_1rw_9.qb din0[1] din0[1] sky130_fd_pr__nfet_01v8 ad=3.864n pd=0.21m as=4.41n ps=0.322m w=126 l=15
X124 bank_0.replica_bitcell_array_0.bitcell_array_0.cell_1rw_25.q bank_0.replica_bitcell_array_0.bitcell_array_0.cell_1rw_25.qb din0[1] din0[1] sky130_fd_pr__pfet_01v8 ad=1.925n pd=0.18m as=1.925n ps=0.18m w=55 l=15
X125 din0[1] bank_0.replica_bitcell_array_0.bitcell_array_0.cell_1rw_26.q bank_0.replica_bitcell_array_0.bitcell_array_0.cell_1rw_26.qb din0[1] sky130_fd_pr__pfet_01v8 ad=1.925n pd=0.18m as=1.925n ps=0.18m w=55 l=15
X126 control_logic_rw_0.pand2_1.pnand2_0_0.nmos_m1_w0_840_sactive_dli_0.S control_logic_rw_0.pinv_3_1.Z a_n2201_n255# din0[1] sky130_fd_pr__nfet_01v8 ad=1.848n pd=0.128m as=3.276n ps=0.246m w=84 l=15
X127 din0[1] control_logic_rw_0.dff_buf_array_0.dff_buf_0_0.dff_0.net3 control_logic_rw_0.dff_buf_array_0.dff_buf_0_0.dff_0.net2 din0[1] sky130_fd_pr__pfet_01v8 ad=2.2n pd=0.135m as=2.915n ps=0.216m w=55 l=15
X128 a_n4741_5703# control_logic_rw_0.delay_chain_0.pinv_11_29.Z a_n4794_5703# din0[1] sky130_fd_pr__nfet_01v8 ad=1.638n pd=0.162m as=1.596n ps=0.16m w=42 l=15
X129 din0[1] bank_0.replica_bitcell_array_0.replica_column_0.replica_cell_1rw_0.q din0[1] din0[1] sky130_fd_pr__pfet_01v8 ad=1.925n pd=0.18m as=0 ps=0 w=55 l=15
X130 bank_0.replica_bitcell_array_0.replica_column_0.replica_cell_1rw_3.q din0[1] din0[1] din0[1] sky130_fd_pr__nfet_01v8 ad=3.864n pd=0.21m as=4.41n ps=0.322m w=126 l=15
X131 bank_0.replica_bitcell_array_0.dummy_array_3_0.dummy_cell_1rw_4.q bank_0.replica_bitcell_array_0.wl_0_12 a_5461_9619# din0[1] sky130_fd_pr__nfet_01v8 ad=3.864n pd=0.21m as=1.428n ps=0.152m w=42 l=15
X132 bank_0.replica_bitcell_array_0.replica_column_0.replica_cell_1rw_8.q din0[1] din0[1] din0[1] sky130_fd_pr__nfet_01v8 ad=3.864n pd=0.21m as=4.41n ps=0.322m w=126 l=15
X133 a_n4741_3289# control_logic_rw_0.delay_chain_0.pinv_11_39.Z a_n4794_3289# w_n5644_2820# sky130_fd_pr__pfet_01v8 ad=3.276n pd=0.246m as=3.192n ps=0.244m w=84 l=15
X134 bank_0.replica_bitcell_array_0.dummy_array_2_0.dummy_cell_1rw_1.q bank_0.replica_bitcell_array_0.dummy_array_2_0.dummy_cell_1rw_1.qb din0[1] din0[1] sky130_fd_pr__nfet_01v8 ad=3.864n pd=0.21m as=4.41n ps=0.322m w=126 l=15
X135 bank_0.port_address_0.hierarchical_decoder_0.and2_dec_11.pnand2_0.nmos_m1_w0_840_sactive_dli_0.S bank_0.port_address_0.hierarchical_decoder_0.predecode_0 a_2676_5503# din0[1] sky130_fd_pr__nfet_01v8 ad=1.848n pd=0.128m as=3.276n ps=0.246m w=84 l=15
X136 din0[1] din0[1] din0[1] din0[1] sky130_fd_pr__nfet_01v8 ad=2.751n pd=0.165m as=0 ps=0 w=42 l=15
X137 bank_0.replica_bitcell_array_0.dummy_array_3_0.dummy_cell_1rw_0.q bank_0.replica_bitcell_array_0.dummy_array_3_0.dummy_cell_1rw_0.qb din0[1] din0[1] sky130_fd_pr__nfet_01v8 ad=3.864n pd=0.21m as=4.41n ps=0.322m w=126 l=15
X138 din0[1] bank_0.replica_bitcell_array_0.wl_0_1 bank_0.replica_bitcell_array_0.bitcell_array_0.cell_1rw_14.q din0[1] sky130_fd_pr__nfet_01v8 ad=1.428n pd=0.152m as=3.864n ps=0.21m w=42 l=15
X139 a_n2402_n107# control_logic_rw_0.pand2_0.pnand2_0_0.nmos_m1_w0_840_sactive_dli_0.G control_logic_rw_0.pand2_0.pnand2_0_0.nmos_m1_w0_840_sactive_dli_0.S din0[1] sky130_fd_pr__nfet_01v8 ad=3.192n pd=0.244m as=1.848n ps=0.128m w=84 l=15
X140 din0[1] bank_0.replica_bitcell_array_0.wl_0_13 bank_0.replica_bitcell_array_0.replica_column_0.replica_cell_1rw_2.q din0[1] sky130_fd_pr__nfet_01v8 ad=1.428n pd=0.152m as=3.864n ps=0.21m w=42 l=15
X141 bank_0.replica_bitcell_array_0.bitcell_array_0.cell_1rw_13.q bank_0.replica_bitcell_array_0.bitcell_array_0.cell_1rw_13.qb din0[1] din0[1] sky130_fd_pr__pfet_01v8 ad=1.925n pd=0.18m as=1.925n ps=0.18m w=55 l=15
X142 bank_0.port_address_0.wordline_driver_array_0.wordline_driver_14.pnand2_0.nmos_m1_w0_840_sactive_dli_0.S bank_0.port_address_0.wordline_driver_array_0.in_1 a_3370_4337# din0[1] sky130_fd_pr__nfet_01v8 ad=1.848n pd=0.128m as=3.276n ps=0.246m w=84 l=15
X143 a_n1997_705# control_logic_rw_0.dff_buf_array_0.dout_bar_0 a_n2051_705# din0[1] sky130_fd_pr__nfet_01v8 ad=1.89n pd=0.123m as=2.34n ps=0.198m w=60 l=15
X144 bank_0.replica_bitcell_array_0.replica_column_0.replica_cell_1rw_3.q bank_0.replica_bitcell_array_0.wl_0_12 din0[1] din0[1] sky130_fd_pr__nfet_01v8 ad=3.864n pd=0.21m as=1.428n ps=0.152m w=42 l=15
X145 din0[1] bank_0.replica_bitcell_array_0.bitcell_array_0.cell_1rw_20.q bank_0.replica_bitcell_array_0.bitcell_array_0.cell_1rw_20.qb din0[1] sky130_fd_pr__pfet_01v8 ad=1.925n pd=0.18m as=1.925n ps=0.18m w=55 l=15
X146 din0[1] bank_0.replica_bitcell_array_0.bitcell_array_0.cell_1rw_27.q bank_0.replica_bitcell_array_0.bitcell_array_0.cell_1rw_27.qb din0[1] sky130_fd_pr__pfet_01v8 ad=1.925n pd=0.18m as=1.925n ps=0.18m w=55 l=15
X147 a_1822_8047# din0[1] a_1768_8047# w_1141_7751# sky130_fd_pr__pfet_01v8 ad=3.192n pd=0.244m as=3.276n ps=0.246m w=84 l=15
X148 a_4421_4343# bank_0.replica_bitcell_array_0.wl_0_1 bank_0.replica_bitcell_array_0.dummy_array_2_0.dummy_cell_1rw_15.q din0[1] sky130_fd_pr__nfet_01v8 ad=1.428n pd=0.152m as=3.864n ps=0.21m w=42 l=15
X149 din0[1] bank_0.replica_bitcell_array_0.bitcell_array_0.cell_1rw_23.q bank_0.replica_bitcell_array_0.bitcell_array_0.cell_1rw_23.qb din0[1] sky130_fd_pr__nfet_01v8 ad=4.41n pd=0.322m as=3.864n ps=0.21m w=126 l=15
X150 din0[1] bank_0.replica_bitcell_array_0.bitcell_array_0.cell_1rw_28.q bank_0.replica_bitcell_array_0.bitcell_array_0.cell_1rw_28.qb din0[1] sky130_fd_pr__nfet_01v8 ad=4.41n pd=0.322m as=3.864n ps=0.21m w=126 l=15
X151 bank_0.replica_bitcell_array_0.dummy_array_2_0.dummy_cell_1rw_14.q bank_0.replica_bitcell_array_0.dummy_array_2_0.dummy_cell_1rw_14.qb din0[1] din0[1] sky130_fd_pr__pfet_01v8 ad=1.925n pd=0.18m as=1.925n ps=0.18m w=55 l=15
X152 a_1822_3829# din0[1] a_1768_3829# w_1141_3679# sky130_fd_pr__pfet_01v8 ad=3.192n pd=0.244m as=3.276n ps=0.246m w=84 l=15
X153 a_n5055_5809# control_logic_rw_0.delay_chain_0.pinv_11_24.Z a_n5108_5809# din0[1] sky130_fd_pr__nfet_01v8 ad=1.638n pd=0.162m as=1.596n ps=0.16m w=42 l=15
X154 din0[1] bank_0.replica_bitcell_array_0.replica_column_0.replica_cell_1rw_1.q din0[1] din0[1] sky130_fd_pr__pfet_01v8 ad=1.925n pd=0.18m as=0 ps=0 w=55 l=15
X155 bank_0.replica_bitcell_array_0.bitcell_array_0.cell_1rw_20.q bank_0.replica_bitcell_array_0.bitcell_array_0.cell_1rw_20.qb din0[1] din0[1] sky130_fd_pr__pfet_01v8 ad=1.925n pd=0.18m as=1.925n ps=0.18m w=55 l=15
X156 a_n4113_9063# control_logic_rw_0.delay_chain_0.pinv_11_14.Z a_n4166_9063# din0[1] sky130_fd_pr__nfet_01v8 ad=1.638n pd=0.162m as=1.596n ps=0.16m w=42 l=15
X157 din0[1] bank_0.replica_bitcell_array_0.wl_0_11 bank_0.replica_bitcell_array_0.bitcell_array_0.cell_1rw_20.q din0[1] sky130_fd_pr__nfet_01v8 ad=1.428n pd=0.152m as=3.864n ps=0.21m w=42 l=15
X158 din0[1] bank_0.replica_bitcell_array_0.wl_0_7 bank_0.replica_bitcell_array_0.bitcell_array_0.cell_1rw_8.q din0[1] sky130_fd_pr__nfet_01v8 ad=1.428n pd=0.152m as=3.864n ps=0.21m w=42 l=15
X159 row_addr_dff_0.dff_0.net3 row_addr_dff_0.dff_0.net1 din0[1] din0[1] sky130_fd_pr__pfet_01v8 ad=3.465n pd=0.236m as=2.2n ps=0.135m w=55 l=15
X160 bank_0.port_address_0.wordline_driver_array_0.wordline_driver_8.pnand2_0.nmos_m1_w0_840_sactive_dli_0.S bank_0.port_address_0.wordline_driver_array_0.in_7 a_3370_7391# din0[1] sky130_fd_pr__nfet_01v8 ad=1.848n pd=0.128m as=3.276n ps=0.246m w=84 l=15
X161 a_n675_n919# control_logic_rw_0.pdriver_0_0.pinv_7_0.A a_n753_n919# din0[1] sky130_fd_pr__nfet_01v8 ad=1.795n pd=0.12m as=1.795n ps=0.12m w=57 l=15
X162 a_n1196_n513# control_logic_rw_0.dff_buf_array_0.dout_bar_0 a_n1274_n513# w_n2769_n767# sky130_fd_pr__pfet_01v8 ad=3.528n pd=0.175m as=3.528n ps=0.175m w=112 l=15
X163 a_4421_7397# bank_0.replica_bitcell_array_0.wl_0_7 bank_0.replica_bitcell_array_0.dummy_array_2_0.dummy_cell_1rw_9.q din0[1] sky130_fd_pr__nfet_01v8 ad=1.428n pd=0.152m as=3.864n ps=0.21m w=42 l=15
X164 bank_0.replica_bitcell_array_0.bitcell_array_0.cell_1rw_8.q bank_0.replica_bitcell_array_0.bitcell_array_0.cell_1rw_8.qb din0[1] din0[1] sky130_fd_pr__pfet_01v8 ad=1.925n pd=0.18m as=1.925n ps=0.18m w=55 l=15
X165 a_1822_6883# din0[1] a_1768_6883# w_1141_6733# sky130_fd_pr__pfet_01v8 ad=3.192n pd=0.244m as=3.276n ps=0.246m w=84 l=15
X166 a_n2461_1923# control_logic_rw_0.delay_chain_0.out a_n2515_1923# w_n2769_1669# sky130_fd_pr__pfet_01v8 ad=1.848n pd=0.128m as=3.276n ps=0.246m w=84 l=15
X167 bank_0.replica_bitcell_array_0.replica_column_0.replica_cell_1rw_2.q din0[1] din0[1] din0[1] sky130_fd_pr__nfet_01v8 ad=3.864n pd=0.21m as=4.41n ps=0.322m w=126 l=15
X168 a_2789_4485# bank_0.port_address_0.hierarchical_decoder_0.predecode_4 bank_0.port_address_0.hierarchical_decoder_0.and2_dec_13.pnand2_0.nmos_m1_w0_840_sactive_dli_0.S din0[1] sky130_fd_pr__nfet_01v8 ad=3.192n pd=0.244m as=1.848n ps=0.128m w=84 l=15
X169 a_1508_4337# bank_0.port_address_0.hierarchical_decoder_0.hierarchical_predecode2x4_1.pinv_0.Z bank_0.port_address_0.hierarchical_decoder_0.hierarchical_predecode2x4_1.and2_dec_2.pnand2_0.nmos_m1_w0_840_sactive_dli_0.S din0[1] sky130_fd_pr__nfet_01v8 ad=3.192n pd=0.244m as=1.848n ps=0.128m w=84 l=15
X170 din0[1] bank_0.replica_bitcell_array_0.dummy_array_0_0.dummy_cell_1rw_1.q bank_0.replica_bitcell_array_0.dummy_array_0_0.dummy_cell_1rw_1.qb din0[1] sky130_fd_pr__nfet_01v8 ad=4.41n pd=0.322m as=3.864n ps=0.21m w=126 l=15
X171 a_n2069_n661# control_logic_rw_0.pdriver_0_0.pinv_4_0.A a_n2147_n661# w_n2769_n767# sky130_fd_pr__pfet_01v8 ad=3.192n pd=0.244m as=2.646n ps=0.147m w=84 l=15
X172 bank_0.replica_bitcell_array_0.dummy_array_2_0.dummy_cell_1rw_9.q bank_0.replica_bitcell_array_0.dummy_array_2_0.dummy_cell_1rw_9.qb din0[1] din0[1] sky130_fd_pr__pfet_01v8 ad=1.925n pd=0.18m as=1.925n ps=0.18m w=55 l=15
X173 control_logic_rw_0.dff_buf_array_0.dff_buf_0_0.dff_0.net5 control_logic_rw_0.dff_buf_array_0.dff_buf_0_0.dff_0.clkb control_logic_rw_0.dff_buf_array_0.dff_buf_0_0.dff_0.net4 din0[1] sky130_fd_pr__nfet_01v8 ad=3.318n pd=0.242m as=2.226n ps=0.148m w=42 l=15
X174 bank_0.replica_bitcell_array_0.bitcell_array_0.cell_1rw_21.q bank_0.replica_bitcell_array_0.bitcell_array_0.cell_1rw_21.qb din0[1] din0[1] sky130_fd_pr__nfet_01v8 ad=3.864n pd=0.21m as=4.41n ps=0.322m w=126 l=15
X175 bank_0.replica_bitcell_array_0.dummy_array_3_0.dummy_cell_1rw_5.q bank_0.replica_bitcell_array_0.dummy_array_3_0.dummy_cell_1rw_5.qb din0[1] din0[1] sky130_fd_pr__nfet_01v8 ad=3.864n pd=0.21m as=4.41n ps=0.322m w=126 l=15
X176 bank_0.replica_bitcell_array_0.replica_column_0.replica_cell_1rw_4.q din0[1] din0[1] din0[1] sky130_fd_pr__nfet_01v8 ad=3.864n pd=0.21m as=4.41n ps=0.322m w=126 l=15
X177 a_1508_7391# bank_0.port_address_0.hierarchical_decoder_0.hierarchical_predecode2x4_0.pinv_0.Z bank_0.port_address_0.hierarchical_decoder_0.hierarchical_predecode2x4_0.and2_dec_2.pnand2_0.nmos_m1_w0_840_sactive_dli_0.S din0[1] sky130_fd_pr__nfet_01v8 ad=3.192n pd=0.244m as=1.848n ps=0.128m w=84 l=15
X178 bank_0.replica_bitcell_array_0.dummy_array_3_0.dummy_cell_1rw_2.qb bank_0.replica_bitcell_array_0.wl_0_14 a_5530_10637# din0[1] sky130_fd_pr__nfet_01v8 ad=3.864n pd=0.21m as=1.428n ps=0.152m w=42 l=15
X179 a_2730_9065# bank_0.port_address_0.hierarchical_decoder_0.predecode_3 a_2676_9065# w_2422_8769# sky130_fd_pr__pfet_01v8 ad=1.848n pd=0.128m as=3.276n ps=0.246m w=84 l=15
X180 bank_0.port_address_0.hierarchical_decoder_0.and2_dec_7.pnand2_0.nmos_m1_w0_840_sactive_dli_0.S bank_0.port_address_0.hierarchical_decoder_0.predecode_0 a_2676_7539# din0[1] sky130_fd_pr__nfet_01v8 ad=1.848n pd=0.128m as=3.276n ps=0.246m w=84 l=15
X181 a_3483_6521# control_logic_rw_0.wl_en bank_0.port_address_0.wordline_driver_array_0.wordline_driver_9.pnand2_0.nmos_m1_w0_840_sactive_dli_0.S din0[1] sky130_fd_pr__nfet_01v8 ad=3.192n pd=0.244m as=1.848n ps=0.128m w=84 l=15
X182 a_n4427_5703# control_logic_rw_0.delay_chain_0.pinv_11_29.Z a_n4480_5703# din0[1] sky130_fd_pr__nfet_01v8 ad=1.638n pd=0.162m as=1.596n ps=0.16m w=42 l=15
X183 a_2730_4847# bank_0.port_address_0.hierarchical_decoder_0.predecode_2 a_2676_4847# w_2422_4697# sky130_fd_pr__pfet_01v8 ad=1.848n pd=0.128m as=3.276n ps=0.246m w=84 l=15
X184 bank_0.port_address_0.hierarchical_decoder_0.hierarchical_predecode2x4_1.and2_dec_1.pnand2_0.nmos_m1_w0_840_sactive_dli_0.S bank_0.port_address_0.hierarchical_decoder_0.hierarchical_predecode2x4_1.pinv_1.Z a_1395_4485# din0[1] sky130_fd_pr__nfet_01v8 ad=1.848n pd=0.128m as=3.276n ps=0.246m w=84 l=15
X185 a_739_4379# row_addr_dff_0.dout_1 a_685_4379# din0[1] sky130_fd_pr__nfet_01v8 ad=1.596n pd=0.16m as=1.638n ps=0.162m w=42 l=15
X186 a_n1666_n107# control_logic_rw_0.dff_buf_array_0.dout_bar_0 a_n1744_n107# din0[1] sky130_fd_pr__nfet_01v8 ad=1.764n pd=0.119m as=1.764n ps=0.119m w=56 l=15
X187 din0[1] bank_0.replica_bitcell_array_0.dummy_array_3_0.dummy_cell_1rw_16.q bank_0.replica_bitcell_array_0.dummy_array_3_0.dummy_cell_1rw_16.qb din0[1] sky130_fd_pr__nfet_01v8 ad=4.41n pd=0.322m as=3.864n ps=0.21m w=126 l=15
X188 bank_0.replica_bitcell_array_0.bitcell_array_0.cell_1rw_9.q bank_0.replica_bitcell_array_0.bitcell_array_0.cell_1rw_9.qb din0[1] din0[1] sky130_fd_pr__pfet_01v8 ad=1.925n pd=0.18m as=1.925n ps=0.18m w=55 l=15
X189 a_n4427_3289# control_logic_rw_0.delay_chain_0.pinv_11_39.Z a_n4480_3289# w_n5644_2820# sky130_fd_pr__pfet_01v8 ad=3.276n pd=0.246m as=3.192n ps=0.244m w=84 l=15
X190 bank_0.replica_bitcell_array_0.bitcell_array_0.cell_1rw_21.qb bank_0.replica_bitcell_array_0.wl_0_10 din0[1] din0[1] sky130_fd_pr__nfet_01v8 ad=3.864n pd=0.21m as=1.428n ps=0.152m w=42 l=15
X191 a_n1274_n227# control_logic_rw_0.dff_buf_array_0.dout_bar_0 a_n1352_n227# din0[1] sky130_fd_pr__nfet_01v8 ad=1.764n pd=0.119m as=1.764n ps=0.119m w=56 l=15
X192 a_n1978_123# control_logic_rw_0.dff_buf_array_0.dout_bar_0 a_n2056_123# w_n2769_44# sky130_fd_pr__pfet_01v8 ad=3.528n pd=0.175m as=3.528n ps=0.175m w=112 l=15
X193 control_logic_rw_0.dff_buf_array_0.dff_buf_0_0.dff_0.net1 din0[1] web0 din0[1] sky130_fd_pr__pfet_01v8 ad=2.915n pd=0.161m as=2.53n ps=0.202m w=55 l=15
X194 a_4793_1928# control_logic_rw_0.p_en_bar a_4739_1928# w_4605_1519# sky130_fd_pr__pfet_01v8 ad=1.848n pd=0.128m as=3.276n ps=0.246m w=84 l=15
X195 bank_0.replica_bitcell_array_0.dummy_array_0_0.dummy_cell_1rw_1.q bank_0.replica_bitcell_array_0.dummy_array_0_0.dummy_cell_1rw_1.qb din0[1] din0[1] sky130_fd_pr__nfet_01v8 ad=3.864n pd=0.21m as=4.41n ps=0.322m w=126 l=15
X196 din0[1] bank_0.replica_bitcell_array_0.replica_column_0.replica_cell_1rw_3.q din0[1] din0[1] sky130_fd_pr__nfet_01v8 ad=3.864n pd=0.21m as=0 ps=0 w=126 l=15
X197 din0[1] bank_0.replica_bitcell_array_0.replica_column_0.replica_cell_1rw_8.q din0[1] din0[1] sky130_fd_pr__nfet_01v8 ad=3.864n pd=0.21m as=0 ps=0 w=126 l=15
X198 bank_0.replica_bitcell_array_0.dummy_array_2_0.dummy_cell_1rw_10.q bank_0.replica_bitcell_array_0.dummy_array_2_0.dummy_cell_1rw_10.qb din0[1] din0[1] sky130_fd_pr__pfet_01v8 ad=1.925n pd=0.18m as=1.925n ps=0.18m w=55 l=15
X199 control_logic_rw_0.dff_buf_array_0.dff_buf_0_1.dff_0.net2 control_logic_rw_0.dff_buf_array_0.dff_buf_0_1.dff_0.clkb control_logic_rw_0.dff_buf_array_0.dff_buf_0_1.dff_0.net1 din0[1] sky130_fd_pr__pfet_01v8 ad=3.74n pd=0.246m as=2.915n ps=0.161m w=55 l=15
X200 row_addr_dff_0.dff_1.net5 row_addr_dff_0.dff_1.clkb row_addr_dff_0.dff_1.net4 din0[1] sky130_fd_pr__nfet_01v8 ad=3.318n pd=0.242m as=2.226n ps=0.148m w=42 l=15
X201 data_dff_0.dff_0.net1 din0[1] din0[1] din0[1] sky130_fd_pr__pfet_01v8 ad=2.915n pd=0.161m as=2.53n ps=0.202m w=55 l=15
X202 a_n1510_n107# control_logic_rw_0.dff_buf_array_0.dout_bar_0 a_n1588_n107# din0[1] sky130_fd_pr__nfet_01v8 ad=1.764n pd=0.119m as=1.764n ps=0.119m w=56 l=15
X203 a_3103_7433# din0[1] a_3049_7433# din0[1] sky130_fd_pr__nfet_01v8 ad=1.596n pd=0.16m as=1.638n ps=0.162m w=42 l=15
X204 a_5461_6379# bank_0.replica_bitcell_array_0.wl_0_5 bank_0.replica_bitcell_array_0.dummy_array_3_0.dummy_cell_1rw_11.q din0[1] sky130_fd_pr__nfet_01v8 ad=1.428n pd=0.152m as=3.864n ps=0.21m w=42 l=15
X205 row_addr_dff_0.dff_2.net3 row_addr_dff_0.dff_2.net1 din0[1] din0[1] sky130_fd_pr__pfet_01v8 ad=3.465n pd=0.236m as=2.2n ps=0.135m w=55 l=15
X206 a_3424_10955# bank_0.port_address_0.wordline_driver_array_0.in_14 a_3370_10955# w_2422_10805# sky130_fd_pr__pfet_01v8 ad=1.848n pd=0.128m as=3.276n ps=0.246m w=84 l=15
X207 bank_0.replica_bitcell_array_0.dummy_array_3_0.dummy_cell_1rw_18.q bank_0.replica_bitcell_array_0.dummy_array_3_0.dummy_cell_1rw_18.qb din0[1] din0[1] sky130_fd_pr__nfet_01v8 ad=3.864n pd=0.21m as=4.41n ps=0.322m w=126 l=15
X208 din0[1] bank_0.replica_bitcell_array_0.wl_0_5 bank_0.replica_bitcell_array_0.replica_column_0.replica_cell_1rw_10.q din0[1] sky130_fd_pr__nfet_01v8 ad=1.428n pd=0.152m as=3.864n ps=0.21m w=42 l=15
X209 a_5010_3325# bank_0.replica_bitcell_array_0.rbl_wl_0_0 bank_0.replica_bitcell_array_0.dummy_array_0.dummy_cell_1rw_1.qb din0[1] sky130_fd_pr__nfet_01v8 ad=1.428n pd=0.152m as=3.864n ps=0.21m w=42 l=15
X210 din0[1] bank_0.replica_bitcell_array_0.bitcell_array_0.cell_1rw_0.q bank_0.replica_bitcell_array_0.bitcell_array_0.cell_1rw_0.qb din0[1] sky130_fd_pr__nfet_01v8 ad=4.41n pd=0.322m as=3.864n ps=0.21m w=126 l=15
X211 bank_0.replica_bitcell_array_0.bitcell_array_0.cell_1rw_4.q bank_0.replica_bitcell_array_0.bitcell_array_0.cell_1rw_4.qb din0[1] din0[1] sky130_fd_pr__pfet_01v8 ad=1.925n pd=0.18m as=1.925n ps=0.18m w=55 l=15
X212 a_n5369_4023# control_logic_rw_0.delay_chain_0.pinv_11_39.Z a_n5422_4023# din0[1] sky130_fd_pr__nfet_01v8 ad=1.638n pd=0.162m as=1.596n ps=0.16m w=42 l=15
X213 control_logic_rw_0.dff_buf_array_0.dff_buf_0_1.dff_0.net2 din0[1] control_logic_rw_0.dff_buf_array_0.dff_buf_0_1.dff_0.net1 din0[1] sky130_fd_pr__nfet_01v8 ad=2.856n pd=0.22m as=2.226n ps=0.148m w=42 l=15
X214 bank_0.replica_bitcell_array_0.dummy_array_2_0.dummy_cell_1rw_0.qb din0[1] a_4490_11655# din0[1] sky130_fd_pr__nfet_01v8 ad=3.864n pd=0.21m as=1.428n ps=0.152m w=42 l=15
X215 row_addr_dff_0.dff_3.net2 row_addr_dff_0.dff_3.clk row_addr_dff_0.dff_3.net1 din0[1] sky130_fd_pr__nfet_01v8 ad=2.856n pd=0.22m as=2.226n ps=0.148m w=42 l=15
X216 data_dff_0.dff_0.net1 data_dff_0.dff_0.clkb din0[1] din0[1] sky130_fd_pr__nfet_01v8 ad=2.226n pd=0.148m as=1.932n ps=0.176m w=42 l=15
X217 a_n1742_n513# control_logic_rw_0.dff_buf_array_0.dout_bar_0 a_n1796_n513# w_n2769_n767# sky130_fd_pr__pfet_01v8 ad=3.528n pd=0.175m as=4.368n ps=0.302m w=112 l=15
X218 bank_0.replica_bitcell_array_0.replica_column_0.dummy_cell_1rw_1.q bank_0.replica_bitcell_array_0.replica_column_0.dummy_cell_1rw_1.qb din0[1] din0[1] sky130_fd_pr__nfet_01v8 ad=3.864n pd=0.21m as=4.41n ps=0.322m w=126 l=15
X219 a_3483_7029# control_logic_rw_0.wl_en a_3424_7029# w_2422_6733# sky130_fd_pr__pfet_01v8 ad=3.192n pd=0.244m as=1.848n ps=0.128m w=84 l=15
X220 a_3103_6011# din0[1] a_3049_6011# w_2422_5715# sky130_fd_pr__pfet_01v8 ad=3.192n pd=0.244m as=3.276n ps=0.246m w=84 l=15
X221 bank_0.replica_bitcell_array_0.dummy_array_2_0.dummy_cell_1rw_5.q bank_0.replica_bitcell_array_0.dummy_array_2_0.dummy_cell_1rw_5.qb din0[1] din0[1] sky130_fd_pr__pfet_01v8 ad=1.925n pd=0.18m as=1.925n ps=0.18m w=55 l=15
X222 a_5530_8415# bank_0.replica_bitcell_array_0.wl_0_9 bank_0.replica_bitcell_array_0.dummy_array_3_0.dummy_cell_1rw_7.qb din0[1] sky130_fd_pr__nfet_01v8 ad=1.428n pd=0.152m as=3.864n ps=0.21m w=42 l=15
X223 din0[1] row_addr_dff_0.dout_3 row_addr_dff_0.dff_0.net5 din0[1] sky130_fd_pr__pfet_01v8 ad=2.2n pd=0.135m as=3.08n ps=0.222m w=55 l=15
X224 a_n4113_4821# control_logic_rw_0.delay_chain_0.pinv_11_39.Z a_n4166_4821# w_n5644_4500# sky130_fd_pr__pfet_01v8 ad=3.276n pd=0.246m as=3.192n ps=0.244m w=84 l=15
X225 din0[1] din0[1] din0[1] din0[1] sky130_fd_pr__nfet_01v8 ad=2.1n pd=0.184m as=0 ps=0 w=42 l=15
X226 din0[1] bank_0.replica_bitcell_array_0.dummy_array_2_0.dummy_cell_1rw_0.q bank_0.replica_bitcell_array_0.dummy_array_2_0.dummy_cell_1rw_0.qb din0[1] sky130_fd_pr__nfet_01v8 ad=4.41n pd=0.322m as=3.864n ps=0.21m w=126 l=15
X227 din0[1] bank_0.replica_bitcell_array_0.wl_0_9 din0[1] din0[1] sky130_fd_pr__nfet_01v8 ad=1.428n pd=0.152m as=0 ps=0 w=42 l=15
X228 a_3797_2957# din0[1] a_3743_2957# w_3116_2703# sky130_fd_pr__pfet_01v8 ad=3.192n pd=0.244m as=3.276n ps=0.246m w=84 l=15
X229 din0[1] bank_0.replica_bitcell_array_0.bitcell_array_0.cell_1rw_12.q bank_0.replica_bitcell_array_0.bitcell_array_0.cell_1rw_12.qb din0[1] sky130_fd_pr__pfet_01v8 ad=1.925n pd=0.18m as=1.925n ps=0.18m w=55 l=15
X230 a_n1685_927# control_logic_rw_0.dff_buf_array_0.dout_bar_0 a_n1763_927# w_n2769_857# sky130_fd_pr__pfet_01v8 ad=3.78n pd=0.183m as=3.78n ps=0.183m w=120 l=15
X231 a_3483_10083# control_logic_rw_0.wl_en a_3424_10083# w_2422_9787# sky130_fd_pr__pfet_01v8 ad=3.192n pd=0.244m as=1.848n ps=0.128m w=84 l=15
X232 bank_0.replica_bitcell_array_0.dummy_array_3_0.dummy_cell_1rw_14.qb bank_0.replica_bitcell_array_0.wl_0_2 a_5530_4529# din0[1] sky130_fd_pr__nfet_01v8 ad=3.864n pd=0.21m as=1.428n ps=0.152m w=42 l=15
X233 a_3424_3975# bank_0.port_address_0.wordline_driver_array_0.in_1 a_3370_3975# w_2422_3679# sky130_fd_pr__pfet_01v8 ad=1.848n pd=0.128m as=3.276n ps=0.246m w=84 l=15
X234 din0[1] bank_0.replica_bitcell_array_0.dummy_array_3_0.dummy_cell_1rw_0.q bank_0.replica_bitcell_array_0.dummy_array_3_0.dummy_cell_1rw_0.qb din0[1] sky130_fd_pr__nfet_01v8 ad=4.41n pd=0.322m as=3.864n ps=0.21m w=126 l=15
X235 bank_0.port_address_0.hierarchical_decoder_0.and2_dec_14.pnand2_0.nmos_m1_w0_840_sactive_dli_0.S bank_0.port_address_0.hierarchical_decoder_0.predecode_1 a_2676_4337# din0[1] sky130_fd_pr__nfet_01v8 ad=1.848n pd=0.128m as=3.276n ps=0.246m w=84 l=15
X236 din0[1] row_addr_dff_0.dff_1.net3 row_addr_dff_0.dff_1.net2 din0[1] sky130_fd_pr__nfet_01v8 ad=1.68n pd=0.122m as=2.226n ps=0.19m w=42 l=15
X237 a_3483_8557# control_logic_rw_0.wl_en bank_0.port_address_0.wordline_driver_array_0.wordline_driver_5.pnand2_0.nmos_m1_w0_840_sactive_dli_0.S din0[1] sky130_fd_pr__nfet_01v8 ad=3.192n pd=0.244m as=1.848n ps=0.128m w=84 l=15
X238 bank_0.replica_bitcell_array_0.bitcell_array_0.cell_1rw_5.q bank_0.replica_bitcell_array_0.bitcell_array_0.cell_1rw_5.qb din0[1] din0[1] sky130_fd_pr__nfet_01v8 ad=3.864n pd=0.21m as=4.41n ps=0.322m w=126 l=15
X239 din0[1] bank_0.replica_bitcell_array_0.dummy_array_2_0.dummy_cell_1rw_13.q bank_0.replica_bitcell_array_0.dummy_array_2_0.dummy_cell_1rw_13.qb din0[1] sky130_fd_pr__pfet_01v8 ad=1.925n pd=0.18m as=1.925n ps=0.18m w=55 l=15
X240 din0[1] din0[1] din0[1] din0[1] sky130_fd_pr__pfet_01v8 ad=2.75n pd=0.21m as=0 ps=0 w=55 l=15
X241 a_3483_5865# control_logic_rw_0.wl_en a_3424_5865# w_2422_5715# sky130_fd_pr__pfet_01v8 ad=3.192n pd=0.244m as=1.848n ps=0.128m w=84 l=15
X242 row_addr_dff_0.dff_0.net2 row_addr_dff_0.dff_3.clk row_addr_dff_0.dff_0.net1 din0[1] sky130_fd_pr__nfet_01v8 ad=2.856n pd=0.22m as=2.226n ps=0.148m w=42 l=15
X243 bank_0.replica_bitcell_array_0.bitcell_array_0.cell_1rw_21.q bank_0.replica_bitcell_array_0.bitcell_array_0.cell_1rw_21.qb din0[1] din0[1] sky130_fd_pr__pfet_01v8 ad=1.925n pd=0.18m as=1.925n ps=0.18m w=55 l=15
X244 din0[1] bank_0.replica_bitcell_array_0.wl_0_2 din0[1] din0[1] sky130_fd_pr__nfet_01v8 ad=3.864n pd=0.21m as=0 ps=0 w=42 l=15
X245 bank_0.replica_bitcell_array_0.dummy_array_2_0.dummy_cell_1rw_6.q bank_0.replica_bitcell_array_0.dummy_array_2_0.dummy_cell_1rw_6.qb din0[1] din0[1] sky130_fd_pr__nfet_01v8 ad=3.864n pd=0.21m as=4.41n ps=0.322m w=126 l=15
X246 bank_0.replica_bitcell_array_0.bitcell_array_0.cell_1rw_7.qb bank_0.replica_bitcell_array_0.wl_0_8 din0[1] din0[1] sky130_fd_pr__nfet_01v8 ad=3.864n pd=0.21m as=1.428n ps=0.152m w=42 l=15
X247 din0[1] bank_0.replica_bitcell_array_0.replica_column_0.replica_cell_1rw_4.q din0[1] din0[1] sky130_fd_pr__nfet_01v8 ad=3.864n pd=0.21m as=0 ps=0 w=126 l=15
X248 control_logic_rw_0.dff_buf_array_0.dff_buf_0_0.pinv_0_0.A control_logic_rw_0.dff_buf_array_0.dff_buf_0_0.dff_0.net4 din0[1] din0[1] sky130_fd_pr__pfet_01v8 ad=2.2n pd=0.19m as=2.2n ps=0.135m w=55 l=15
X249 row_addr_dff_0.dff_1.net1 row_addr_dff_0.dff_1.clkb addr0[2] din0[1] sky130_fd_pr__nfet_01v8 ad=2.226n pd=0.148m as=1.932n ps=0.176m w=42 l=15
X250 bank_0.replica_bitcell_array_0.dummy_array_2_0.dummy_cell_1rw_2.q bank_0.replica_bitcell_array_0.wl_0_14 a_4421_10637# din0[1] sky130_fd_pr__nfet_01v8 ad=3.864n pd=0.21m as=1.428n ps=0.152m w=42 l=15
X251 bank_0.replica_bitcell_array_0.dummy_array_2_0.dummy_cell_1rw_8.qb bank_0.replica_bitcell_array_0.wl_0_8 a_4490_7583# din0[1] sky130_fd_pr__nfet_01v8 ad=3.864n pd=0.21m as=1.428n ps=0.152m w=42 l=15
X252 row_addr_dff_0.dout_2 row_addr_dff_0.dff_1.net4 din0[1] din0[1] sky130_fd_pr__pfet_01v8 ad=2.2n pd=0.19m as=2.2n ps=0.135m w=55 l=15
X253 bank_0.port_address_0.hierarchical_decoder_0.and2_dec_8.pnand2_0.nmos_m1_w0_840_sactive_dli_0.S bank_0.port_address_0.hierarchical_decoder_0.predecode_3 a_2676_7391# din0[1] sky130_fd_pr__nfet_01v8 ad=1.848n pd=0.128m as=3.276n ps=0.246m w=84 l=15
X254 a_n5055_3141# control_logic_rw_0.delay_chain_0.pinv_11_44.Z a_n5108_3141# w_n5644_2820# sky130_fd_pr__pfet_01v8 ad=3.276n pd=0.246m as=3.192n ps=0.244m w=84 l=15
X255 bank_0.replica_bitcell_array_0.dummy_array_3_0.dummy_cell_1rw_2.q bank_0.replica_bitcell_array_0.wl_0_14 a_5461_10637# din0[1] sky130_fd_pr__nfet_01v8 ad=3.864n pd=0.21m as=1.428n ps=0.152m w=42 l=15
X256 a_n987_n691# control_logic_rw_0.pdriver_0_0.pinv_7_0.A a_n1065_n691# w_n2769_n767# sky130_fd_pr__pfet_01v8 ad=3.622n pd=0.178m as=3.622n ps=0.178m w=115 l=15
X257 a_3424_8919# bank_0.port_address_0.wordline_driver_array_0.in_10 a_3370_8919# w_2422_8769# sky130_fd_pr__pfet_01v8 ad=1.848n pd=0.128m as=3.276n ps=0.246m w=84 l=15
X258 din0[1] bank_0.replica_bitcell_array_0.bitcell_array_0.cell_1rw_23.q bank_0.replica_bitcell_array_0.bitcell_array_0.cell_1rw_23.qb din0[1] sky130_fd_pr__pfet_01v8 ad=1.925n pd=0.18m as=1.925n ps=0.18m w=55 l=15
X259 a_3103_9469# din0[1] a_3049_9469# din0[1] sky130_fd_pr__nfet_01v8 ad=1.596n pd=0.16m as=1.638n ps=0.162m w=42 l=15
X260 a_1508_3975# bank_0.port_address_0.hierarchical_decoder_0.hierarchical_predecode2x4_1.pinv_0.Z a_1449_3975# w_1141_3679# sky130_fd_pr__pfet_01v8 ad=3.192n pd=0.244m as=1.848n ps=0.128m w=84 l=15
X261 bank_0.port_address_0.wordline_driver_array_0.wordline_driver_2.pnand2_0.nmos_m1_w0_840_sactive_dli_0.S bank_0.port_address_0.wordline_driver_array_0.in_13 a_3370_10445# din0[1] sky130_fd_pr__nfet_01v8 ad=1.848n pd=0.128m as=3.276n ps=0.246m w=84 l=15
X262 din0[1] bank_0.replica_bitcell_array_0.bitcell_array_0.cell_1rw_19.q bank_0.replica_bitcell_array_0.bitcell_array_0.cell_1rw_19.qb din0[1] sky130_fd_pr__nfet_01v8 ad=4.41n pd=0.322m as=3.864n ps=0.21m w=126 l=15
X263 din0[1] bank_0.replica_bitcell_array_0.bitcell_array_0.cell_1rw_24.q bank_0.replica_bitcell_array_0.bitcell_array_0.cell_1rw_24.qb din0[1] sky130_fd_pr__nfet_01v8 ad=4.41n pd=0.322m as=3.864n ps=0.21m w=126 l=15
X264 din0[1] bank_0.replica_bitcell_array_0.wl_0_3 bank_0.replica_bitcell_array_0.bitcell_array_0.cell_1rw_28.qb din0[1] sky130_fd_pr__nfet_01v8 ad=1.428n pd=0.152m as=3.864n ps=0.21m w=42 l=15
X265 bank_0.replica_bitcell_array_0.dummy_array_1_0.dummy_cell_1rw_0.q din0[1] a_5201_2493# din0[1] sky130_fd_pr__nfet_01v8 ad=3.864n pd=0.21m as=1.428n ps=0.152m w=42 l=15
X266 a_n5055_9861# control_logic_rw_0.delay_chain_0.out a_n5108_9861# w_n5644_9540# sky130_fd_pr__pfet_01v8 ad=3.276n pd=0.246m as=3.192n ps=0.244m w=84 l=15
X267 a_n2461_1517# control_logic_rw_0.delay_chain_0.out a_n2515_1517# din0[1] sky130_fd_pr__nfet_01v8 ad=1.596n pd=0.16m as=1.638n ps=0.162m w=42 l=15
X268 bank_0.replica_bitcell_array_0.dummy_array_0_0.dummy_cell_1rw_0.q din0[1] a_5201_11655# din0[1] sky130_fd_pr__nfet_01v8 ad=3.864n pd=0.21m as=1.428n ps=0.152m w=42 l=15
X269 a_3103_8047# din0[1] a_3049_8047# w_2422_7751# sky130_fd_pr__pfet_01v8 ad=3.192n pd=0.244m as=3.276n ps=0.246m w=84 l=15
X270 a_n363_n691# control_logic_rw_0.pdriver_0_0.pinv_7_0.A a_n441_n691# w_n2769_n767# sky130_fd_pr__pfet_01v8 ad=4.37n pd=0.306m as=3.622n ps=0.178m w=115 l=15
X271 a_n2461_1111# control_logic_rw_0.pand2_0.Z a_n2515_1111# w_n2769_857# sky130_fd_pr__pfet_01v8 ad=1.33n pd=0.135m as=3.276n ps=0.246m w=84 l=15
X272 a_3797_10083# din0[1] a_3743_10083# w_2422_9787# sky130_fd_pr__pfet_01v8 ad=3.192n pd=0.244m as=3.276n ps=0.246m w=84 l=15
X273 a_3103_3829# din0[1] a_3049_3829# w_2422_3679# sky130_fd_pr__pfet_01v8 ad=3.192n pd=0.244m as=3.276n ps=0.246m w=84 l=15
X274 bank_0.replica_bitcell_array_0.dummy_array_2_0.dummy_cell_1rw_18.q din0[1] a_4421_2493# din0[1] sky130_fd_pr__nfet_01v8 ad=3.864n pd=0.21m as=1.428n ps=0.152m w=42 l=15
X275 din0[1] row_addr_dff_0.dout_1 row_addr_dff_0.dff_2.net5 din0[1] sky130_fd_pr__pfet_01v8 ad=2.2n pd=0.135m as=3.08n ps=0.222m w=55 l=15
X276 a_3797_4379# din0[1] a_3743_4379# din0[1] sky130_fd_pr__nfet_01v8 ad=1.596n pd=0.16m as=1.638n ps=0.162m w=42 l=15
X277 din0[1] din0[1] din0[1] din0[1] sky130_fd_pr__nfet_01v8 ad=0.56n pd=77u as=0 ps=0 w=42 l=15
X278 a_n5055_2449# control_logic_rw_0.delay_chain_0.pinv_11_44.Z a_n5108_2449# din0[1] sky130_fd_pr__nfet_01v8 ad=1.638n pd=0.162m as=1.596n ps=0.16m w=42 l=15
X279 din0[1] bank_0.replica_bitcell_array_0.replica_column_0.replica_cell_1rw_0.q din0[1] din0[1] sky130_fd_pr__nfet_01v8 ad=3.864n pd=0.21m as=0 ps=0 w=126 l=15
X280 bank_0.replica_bitcell_array_0.bitcell_array_0.cell_1rw_23.q bank_0.replica_bitcell_array_0.wl_0_8 din0[1] din0[1] sky130_fd_pr__nfet_01v8 ad=3.864n pd=0.21m as=1.428n ps=0.152m w=42 l=15
X281 bank_0.replica_bitcell_array_0.dummy_array_3_0.dummy_cell_1rw_18.q bank_0.replica_bitcell_array_0.dummy_array_3_0.dummy_cell_1rw_18.qb din0[1] din0[1] sky130_fd_pr__pfet_01v8 ad=1.925n pd=0.18m as=1.925n ps=0.18m w=55 l=15
X282 din0[1] bank_0.replica_bitcell_array_0.bitcell_array_0.cell_1rw_8.q bank_0.replica_bitcell_array_0.bitcell_array_0.cell_1rw_8.qb din0[1] sky130_fd_pr__pfet_01v8 ad=1.925n pd=0.18m as=1.925n ps=0.18m w=55 l=15
X283 bank_0.replica_bitcell_array_0.bitcell_array_0.cell_1rw_11.q bank_0.replica_bitcell_array_0.wl_0_4 din0[1] din0[1] sky130_fd_pr__nfet_01v8 ad=3.864n pd=0.21m as=1.428n ps=0.152m w=42 l=15
X284 a_n2402_206# control_logic_rw_0.pand2_0.pnand2_0_0.nmos_m1_w0_840_sactive_dli_0.G a_n2461_151# w_n2769_44# sky130_fd_pr__pfet_01v8 ad=2.173n pd=0.26m as=1.33n ps=0.135m w=49 l=15
X285 din0[1] bank_0.replica_bitcell_array_0.replica_column_0.dummy_cell_1rw_1.q bank_0.replica_bitcell_array_0.replica_column_0.dummy_cell_1rw_1.qb din0[1] sky130_fd_pr__nfet_01v8 ad=4.41n pd=0.322m as=3.864n ps=0.21m w=126 l=15
X286 a_2789_6521# bank_0.port_address_0.hierarchical_decoder_0.predecode_5 bank_0.port_address_0.hierarchical_decoder_0.and2_dec_9.pnand2_0.nmos_m1_w0_840_sactive_dli_0.S din0[1] sky130_fd_pr__nfet_01v8 ad=3.192n pd=0.244m as=1.848n ps=0.128m w=84 l=15
X287 control_logic_rw_0.pand3_0_0.pnand3_0_0.nmos_m1_w0_840_sactive_dactive_0.S control_logic_rw_0.delay_chain_0.out a_n2515_2181# din0[1] sky130_fd_pr__nfet_01v8 ad=1.848n pd=0.128m as=3.276n ps=0.246m w=84 l=15
X288 a_2789_10593# bank_0.port_address_0.hierarchical_decoder_0.predecode_7 bank_0.port_address_0.hierarchical_decoder_0.and2_dec_1.pnand2_0.nmos_m1_w0_840_sactive_dli_0.S din0[1] sky130_fd_pr__nfet_01v8 ad=3.192n pd=0.244m as=1.848n ps=0.128m w=84 l=15
X289 bank_0.replica_bitcell_array_0.dummy_array_3_0.dummy_cell_1rw_10.qb bank_0.replica_bitcell_array_0.wl_0_6 a_5530_6565# din0[1] sky130_fd_pr__nfet_01v8 ad=3.864n pd=0.21m as=1.428n ps=0.152m w=42 l=15
X290 a_n1997_2223# control_logic_rw_0.dff_buf_array_0.dout_1 a_n2051_2223# din0[1] sky130_fd_pr__nfet_01v8 ad=1.323n pd=0.105m as=1.638n ps=0.162m w=42 l=15
X291 bank_0.replica_bitcell_array_0.replica_column_0.dummy_cell_1rw_1.q bank_0.replica_bitcell_array_0.replica_column_0.dummy_cell_1rw_1.qb din0[1] din0[1] sky130_fd_pr__pfet_01v8 ad=1.925n pd=0.18m as=1.925n ps=0.18m w=55 l=15
X292 a_3103_9575# din0[1] a_3049_9575# din0[1] sky130_fd_pr__nfet_01v8 ad=1.596n pd=0.16m as=1.638n ps=0.162m w=42 l=15
X293 bank_0.replica_bitcell_array_0.bitcell_array_0.cell_1rw_22.q bank_0.replica_bitcell_array_0.bitcell_array_0.cell_1rw_22.qb din0[1] din0[1] sky130_fd_pr__nfet_01v8 ad=3.864n pd=0.21m as=4.41n ps=0.322m w=126 l=15
X294 din0[1] bank_0.replica_bitcell_array_0.dummy_array_2_0.dummy_cell_1rw_9.q bank_0.replica_bitcell_array_0.dummy_array_2_0.dummy_cell_1rw_9.qb din0[1] sky130_fd_pr__pfet_01v8 ad=1.925n pd=0.18m as=1.925n ps=0.18m w=55 l=15
X295 bank_0.replica_bitcell_array_0.dummy_array_2_0.dummy_cell_1rw_12.q bank_0.replica_bitcell_array_0.wl_0_4 a_4421_5547# din0[1] sky130_fd_pr__nfet_01v8 ad=3.864n pd=0.21m as=1.428n ps=0.152m w=42 l=15
X296 a_3483_5355# control_logic_rw_0.wl_en bank_0.port_address_0.wordline_driver_array_0.wordline_driver_12.pnand2_0.nmos_m1_w0_840_sactive_dli_0.S din0[1] sky130_fd_pr__nfet_01v8 ad=3.192n pd=0.244m as=1.848n ps=0.128m w=84 l=15
X297 din0[1] bank_0.replica_bitcell_array_0.bitcell_array_0.cell_1rw_30.q bank_0.replica_bitcell_array_0.bitcell_array_0.cell_1rw_30.qb din0[1] sky130_fd_pr__pfet_01v8 ad=1.925n pd=0.18m as=1.925n ps=0.18m w=55 l=15
X298 a_3103_6883# din0[1] a_3049_6883# w_2422_6733# sky130_fd_pr__pfet_01v8 ad=3.192n pd=0.244m as=3.276n ps=0.246m w=84 l=15
X299 row_addr_dff_0.dff_2.net2 row_addr_dff_0.dff_3.clk row_addr_dff_0.dff_2.net1 din0[1] sky130_fd_pr__nfet_01v8 ad=2.856n pd=0.22m as=2.226n ps=0.148m w=42 l=15
X300 din0[1] bank_0.replica_bitcell_array_0.wl_0_6 din0[1] din0[1] sky130_fd_pr__nfet_01v8 ad=3.864n pd=0.21m as=0 ps=0 w=42 l=15
X301 din0[1] bank_0.replica_bitcell_array_0.bitcell_array_0.cell_1rw_9.q bank_0.replica_bitcell_array_0.bitcell_array_0.cell_1rw_9.qb din0[1] sky130_fd_pr__pfet_01v8 ad=1.925n pd=0.18m as=1.925n ps=0.18m w=55 l=15
X302 bank_0.replica_bitcell_array_0.dummy_array_3_0.dummy_cell_1rw_12.q bank_0.replica_bitcell_array_0.dummy_array_3_0.dummy_cell_1rw_12.qb din0[1] din0[1] sky130_fd_pr__pfet_01v8 ad=1.925n pd=0.18m as=1.925n ps=0.18m w=55 l=15
X303 bank_0.replica_bitcell_array_0.bitcell_array_0.cell_1rw_30.q bank_0.replica_bitcell_array_0.bitcell_array_0.cell_1rw_30.qb din0[1] din0[1] sky130_fd_pr__pfet_01v8 ad=1.925n pd=0.18m as=1.925n ps=0.18m w=55 l=15
X304 din0[1] bank_0.replica_bitcell_array_0.dummy_array_3_0.dummy_cell_1rw_16.q bank_0.replica_bitcell_array_0.dummy_array_3_0.dummy_cell_1rw_16.qb din0[1] sky130_fd_pr__pfet_01v8 ad=1.925n pd=0.18m as=1.925n ps=0.18m w=55 l=15
X305 din0[1] bank_0.replica_bitcell_array_0.bitcell_array_0.cell_1rw_5.q bank_0.replica_bitcell_array_0.bitcell_array_0.cell_1rw_5.qb din0[1] sky130_fd_pr__nfet_01v8 ad=4.41n pd=0.322m as=3.864n ps=0.21m w=126 l=15
X306 bank_0.port_address_0.hierarchical_decoder_0.hierarchical_predecode2x4_0.and2_dec_3.pnand2_0.nmos_m1_w0_840_sactive_dli_0.S bank_0.port_address_0.hierarchical_decoder_0.hierarchical_predecode2x4_0.pinv_1.Z a_1395_6521# din0[1] sky130_fd_pr__nfet_01v8 ad=1.848n pd=0.128m as=3.276n ps=0.246m w=84 l=15
X307 bank_0.replica_bitcell_array_0.replica_column_0.replica_cell_1rw_11.q din0[1] din0[1] din0[1] sky130_fd_pr__pfet_01v8 ad=1.925n pd=0.18m as=1.925n ps=0.18m w=55 l=15
X308 din0[1] bank_0.replica_bitcell_array_0.dummy_array_3_0.dummy_cell_1rw_12.q bank_0.replica_bitcell_array_0.dummy_array_3_0.dummy_cell_1rw_12.qb din0[1] sky130_fd_pr__nfet_01v8 ad=4.41n pd=0.322m as=3.864n ps=0.21m w=126 l=15
X309 bank_0.replica_bitcell_array_0.dummy_array_3_0.dummy_cell_1rw_13.q bank_0.replica_bitcell_array_0.dummy_array_3_0.dummy_cell_1rw_13.qb din0[1] din0[1] sky130_fd_pr__pfet_01v8 ad=1.925n pd=0.18m as=1.925n ps=0.18m w=55 l=15
X310 a_3797_4485# din0[1] a_3743_4485# din0[1] sky130_fd_pr__nfet_01v8 ad=1.596n pd=0.16m as=1.638n ps=0.162m w=42 l=15
X311 a_n4113_4129# control_logic_rw_0.delay_chain_0.pinv_11_39.Z a_n4166_4129# din0[1] sky130_fd_pr__nfet_01v8 ad=1.638n pd=0.162m as=1.596n ps=0.16m w=42 l=15
X312 din0[1] bank_0.replica_bitcell_array_0.dummy_array_3_0.dummy_cell_1rw_17.q bank_0.replica_bitcell_array_0.dummy_array_3_0.dummy_cell_1rw_17.qb din0[1] sky130_fd_pr__nfet_01v8 ad=4.41n pd=0.322m as=3.864n ps=0.21m w=126 l=15
X313 din0[1] row_addr_dff_0.dff_3.net4 din0[1] din0[1] sky130_fd_pr__pfet_01v8 ad=2.2n pd=0.135m as=0 ps=0 w=55 l=15
X314 bank_0.replica_bitcell_array_0.bitcell_array_0.cell_1rw_5.q bank_0.replica_bitcell_array_0.bitcell_array_0.cell_1rw_5.qb din0[1] din0[1] sky130_fd_pr__pfet_01v8 ad=1.925n pd=0.18m as=1.925n ps=0.18m w=55 l=15
X315 bank_0.port_address_0.wordline_driver_array_0.wordline_driver_6.pnand2_0.nmos_m1_w0_840_sactive_dli_0.S bank_0.port_address_0.wordline_driver_array_0.in_9 a_3370_8409# din0[1] sky130_fd_pr__nfet_01v8 ad=1.848n pd=0.128m as=3.276n ps=0.246m w=84 l=15
X316 din0[1] bank_0.replica_bitcell_array_0.dummy_array_2_0.dummy_cell_1rw_10.q bank_0.replica_bitcell_array_0.dummy_array_2_0.dummy_cell_1rw_10.qb din0[1] sky130_fd_pr__pfet_01v8 ad=1.925n pd=0.18m as=1.925n ps=0.18m w=55 l=15
X317 a_n2343_705# control_logic_rw_0.pand3_0.pnand3_0_0.nmos_m1_w0_840_sactive_dli_0.G control_logic_rw_0.pand3_0.pnand3_0_0.nmos_m1_w0_840_sactive_dactive_0.D din0[1] sky130_fd_pr__nfet_01v8 ad=3.192n pd=0.244m as=1.848n ps=0.128m w=84 l=15
X318 din0[1] bank_0.replica_bitcell_array_0.bitcell_array_0.cell_1rw_19.q bank_0.replica_bitcell_array_0.bitcell_array_0.cell_1rw_19.qb din0[1] sky130_fd_pr__pfet_01v8 ad=1.925n pd=0.18m as=1.925n ps=0.18m w=55 l=15
X319 din0[1] bank_0.replica_bitcell_array_0.replica_column_0.replica_cell_1rw_15.q din0[1] din0[1] sky130_fd_pr__pfet_01v8 ad=1.925n pd=0.18m as=0 ps=0 w=55 l=15
X320 data_dff_0.dff_0.net3 data_dff_0.dff_0.net1 din0[1] din0[1] sky130_fd_pr__pfet_01v8 ad=3.465n pd=0.236m as=2.2n ps=0.135m w=55 l=15
X321 a_n1118_n513# control_logic_rw_0.dff_buf_array_0.dout_bar_0 a_n1196_n513# w_n2769_n767# sky130_fd_pr__pfet_01v8 ad=4.256n pd=0.3m as=3.528n ps=0.175m w=112 l=15
X322 row_addr_dff_0.dff_1.clkb row_addr_dff_0.dff_3.clk din0[1] din0[1] sky130_fd_pr__pfet_01v8 ad=2.53n pd=0.202m as=2.53n ps=0.202m w=55 l=15
X323 row_addr_dff_0.dff_3.net5 row_addr_dff_0.dff_3.clkb row_addr_dff_0.dff_3.net4 din0[1] sky130_fd_pr__nfet_01v8 ad=3.318n pd=0.242m as=2.226n ps=0.148m w=42 l=15
X324 din0[1] bank_0.replica_bitcell_array_0.dummy_array_2_0.dummy_cell_1rw_6.q bank_0.replica_bitcell_array_0.dummy_array_2_0.dummy_cell_1rw_6.qb din0[1] sky130_fd_pr__nfet_01v8 ad=4.41n pd=0.322m as=3.864n ps=0.21m w=126 l=15
X325 din0[1] bank_0.replica_bitcell_array_0.bitcell_array_0.cell_1rw_20.q bank_0.replica_bitcell_array_0.bitcell_array_0.cell_1rw_20.qb din0[1] sky130_fd_pr__nfet_01v8 ad=4.41n pd=0.322m as=3.864n ps=0.21m w=126 l=15
X326 bank_0.replica_bitcell_array_0.replica_column_0.replica_cell_1rw_12.q din0[1] din0[1] din0[1] sky130_fd_pr__pfet_01v8 ad=1.925n pd=0.18m as=1.925n ps=0.18m w=55 l=15
X327 bank_0.replica_bitcell_array_0.bitcell_array_0.cell_1rw_17.q bank_0.replica_bitcell_array_0.wl_0_14 din0[1] din0[1] sky130_fd_pr__nfet_01v8 ad=3.864n pd=0.21m as=1.428n ps=0.152m w=42 l=15
X328 bank_0.replica_bitcell_array_0.dummy_array_2_0.dummy_cell_1rw_6.q bank_0.replica_bitcell_array_0.dummy_array_2_0.dummy_cell_1rw_6.qb din0[1] din0[1] sky130_fd_pr__pfet_01v8 ad=1.925n pd=0.18m as=1.925n ps=0.18m w=55 l=15
X329 a_2789_7029# bank_0.port_address_0.hierarchical_decoder_0.predecode_5 a_2730_7029# w_2422_6733# sky130_fd_pr__pfet_01v8 ad=3.192n pd=0.244m as=1.848n ps=0.128m w=84 l=15
X330 din0[1] bank_0.replica_bitcell_array_0.wl_0_1 bank_0.replica_bitcell_array_0.bitcell_array_0.cell_1rw_14.qb din0[1] sky130_fd_pr__nfet_01v8 ad=1.428n pd=0.152m as=3.864n ps=0.21m w=42 l=15
X331 a_n597_n919# control_logic_rw_0.pdriver_0_0.pinv_7_0.A a_n675_n919# din0[1] sky130_fd_pr__nfet_01v8 ad=1.795n pd=0.12m as=1.795n ps=0.12m w=57 l=15
X332 din0[1] din0[1] din0[1] din0[1] sky130_fd_pr__pfet_01v8 ad=4.5n pd=0.29m as=0 ps=0 w=59 l=15
X333 a_5461_8415# bank_0.replica_bitcell_array_0.wl_0_9 bank_0.replica_bitcell_array_0.dummy_array_3_0.dummy_cell_1rw_7.q din0[1] sky130_fd_pr__nfet_01v8 ad=1.428n pd=0.152m as=3.864n ps=0.21m w=42 l=15
X334 bank_0.replica_bitcell_array_0.dummy_array_3_0.dummy_cell_1rw_7.q bank_0.replica_bitcell_array_0.dummy_array_3_0.dummy_cell_1rw_7.qb din0[1] din0[1] sky130_fd_pr__pfet_01v8 ad=1.925n pd=0.18m as=1.925n ps=0.18m w=55 l=15
X335 a_4490_4343# bank_0.replica_bitcell_array_0.wl_0_1 bank_0.replica_bitcell_array_0.dummy_array_2_0.dummy_cell_1rw_15.qb din0[1] sky130_fd_pr__nfet_01v8 ad=1.428n pd=0.152m as=3.864n ps=0.21m w=42 l=15
X336 data_dff_0.dff_0.net3 data_dff_0.dff_0.net1 din0[1] din0[1] sky130_fd_pr__nfet_01v8 ad=2.604n pd=0.208m as=1.68n ps=0.122m w=42 l=15
X337 a_n4741_9063# control_logic_rw_0.delay_chain_0.pinv_11_9.Z a_n4794_9063# din0[1] sky130_fd_pr__nfet_01v8 ad=1.638n pd=0.162m as=1.596n ps=0.16m w=42 l=15
X338 bank_0.replica_bitcell_array_0.replica_column_0.replica_cell_1rw_6.q din0[1] din0[1] din0[1] sky130_fd_pr__pfet_01v8 ad=1.925n pd=0.18m as=1.925n ps=0.18m w=55 l=15
X339 a_n5055_6649# control_logic_rw_0.delay_chain_0.pinv_11_19.Z a_n5108_6649# w_n5644_6180# sky130_fd_pr__pfet_01v8 ad=3.276n pd=0.246m as=3.192n ps=0.244m w=84 l=15
X340 bank_0.replica_bitcell_array_0.dummy_array_3_0.dummy_cell_1rw_14.q bank_0.replica_bitcell_array_0.dummy_array_3_0.dummy_cell_1rw_14.qb din0[1] din0[1] sky130_fd_pr__nfet_01v8 ad=3.864n pd=0.21m as=4.41n ps=0.322m w=126 l=15
X341 din0[1] bank_0.replica_bitcell_array_0.wl_0_9 bank_0.replica_bitcell_array_0.replica_column_0.replica_cell_1rw_6.q din0[1] sky130_fd_pr__nfet_01v8 ad=1.428n pd=0.152m as=3.864n ps=0.21m w=42 l=15
X342 a_2730_3975# bank_0.port_address_0.hierarchical_decoder_0.predecode_1 a_2676_3975# w_2422_3679# sky130_fd_pr__pfet_01v8 ad=1.848n pd=0.128m as=3.276n ps=0.246m w=84 l=15
X343 a_739_6521# row_addr_dff_0.dout_2 a_685_6521# din0[1] sky130_fd_pr__nfet_01v8 ad=1.596n pd=0.16m as=1.638n ps=0.162m w=42 l=15
X344 row_addr_dff_0.dff_0.net5 row_addr_dff_0.dff_0.clkb row_addr_dff_0.dff_0.net4 din0[1] sky130_fd_pr__nfet_01v8 ad=3.318n pd=0.242m as=2.226n ps=0.148m w=42 l=15
X345 a_2789_8557# bank_0.port_address_0.hierarchical_decoder_0.predecode_6 bank_0.port_address_0.hierarchical_decoder_0.and2_dec_5.pnand2_0.nmos_m1_w0_840_sactive_dli_0.S din0[1] sky130_fd_pr__nfet_01v8 ad=3.192n pd=0.244m as=1.848n ps=0.128m w=84 l=15
X346 a_1508_8409# row_addr_dff_0.dout_3 bank_0.port_address_0.hierarchical_decoder_0.hierarchical_predecode2x4_0.and2_dec_0.pnand2_0.nmos_m1_w0_840_sactive_dli_0.S din0[1] sky130_fd_pr__nfet_01v8 ad=3.192n pd=0.244m as=1.848n ps=0.128m w=84 l=15
X347 a_1449_7029# row_addr_dff_0.dout_2 a_1395_7029# w_1141_6733# sky130_fd_pr__pfet_01v8 ad=1.848n pd=0.128m as=3.276n ps=0.246m w=84 l=15
X348 din0[1] bank_0.replica_bitcell_array_0.wl_0_7 bank_0.replica_bitcell_array_0.bitcell_array_0.cell_1rw_8.qb din0[1] sky130_fd_pr__nfet_01v8 ad=1.428n pd=0.152m as=3.864n ps=0.21m w=42 l=15
X349 din0[1] bank_0.replica_bitcell_array_0.dummy_array_3_0.dummy_cell_1rw_11.q bank_0.replica_bitcell_array_0.dummy_array_3_0.dummy_cell_1rw_11.qb din0[1] sky130_fd_pr__pfet_01v8 ad=1.925n pd=0.18m as=1.925n ps=0.18m w=55 l=15
X350 bank_0.replica_bitcell_array_0.replica_column_0.replica_cell_1rw_13.q din0[1] din0[1] din0[1] sky130_fd_pr__nfet_01v8 ad=3.864n pd=0.21m as=4.41n ps=0.322m w=126 l=15
X351 bank_0.replica_bitcell_array_0.dummy_array_3_0.dummy_cell_1rw_14.q bank_0.replica_bitcell_array_0.wl_0_2 a_5461_4529# din0[1] sky130_fd_pr__nfet_01v8 ad=3.864n pd=0.21m as=1.428n ps=0.152m w=42 l=15
X352 a_1822_4379# din0[1] a_1768_4379# din0[1] sky130_fd_pr__nfet_01v8 ad=1.596n pd=0.16m as=1.638n ps=0.162m w=42 l=15
X353 a_2789_5865# bank_0.port_address_0.hierarchical_decoder_0.predecode_5 a_2730_5865# w_2422_5715# sky130_fd_pr__pfet_01v8 ad=3.192n pd=0.244m as=1.848n ps=0.128m w=84 l=15
X354 a_n3447_n689# control_logic_rw_0.dff_buf_array_0.dout_bar_0 a_n3525_n689# w_n4225_n767# sky130_fd_pr__pfet_01v8 ad=3.528n pd=0.175m as=3.528n ps=0.175m w=112 l=15
X355 a_4490_7397# bank_0.replica_bitcell_array_0.wl_0_7 bank_0.replica_bitcell_array_0.dummy_array_2_0.dummy_cell_1rw_9.qb din0[1] sky130_fd_pr__nfet_01v8 ad=1.428n pd=0.152m as=3.864n ps=0.21m w=42 l=15
X356 a_n909_n691# control_logic_rw_0.pdriver_0_0.pinv_7_0.A a_n987_n691# w_n2769_n767# sky130_fd_pr__pfet_01v8 ad=3.622n pd=0.178m as=3.622n ps=0.178m w=115 l=15
X357 din0[1] bank_0.replica_bitcell_array_0.replica_column_0.replica_cell_1rw_10.q din0[1] din0[1] sky130_fd_pr__pfet_01v8 ad=1.925n pd=0.18m as=0 ps=0 w=55 l=15
X358 bank_0.replica_bitcell_array_0.replica_column_0.replica_cell_1rw_13.q bank_0.replica_bitcell_array_0.wl_0_2 din0[1] din0[1] sky130_fd_pr__nfet_01v8 ad=3.864n pd=0.21m as=1.428n ps=0.152m w=42 l=15
X359 din0[1] row_addr_dff_0.dff_3.net3 row_addr_dff_0.dff_3.net2 din0[1] sky130_fd_pr__nfet_01v8 ad=1.68n pd=0.122m as=2.226n ps=0.19m w=42 l=15
X360 a_n5055_9169# control_logic_rw_0.delay_chain_0.out a_n5108_9169# din0[1] sky130_fd_pr__nfet_01v8 ad=1.638n pd=0.162m as=1.596n ps=0.16m w=42 l=15
X361 din0[1] bank_0.replica_bitcell_array_0.dummy_array_1_0.dummy_cell_1rw_1.q bank_0.replica_bitcell_array_0.dummy_array_1_0.dummy_cell_1rw_1.qb din0[1] sky130_fd_pr__nfet_01v8 ad=4.41n pd=0.322m as=3.864n ps=0.21m w=126 l=15
X362 a_n1196_n227# control_logic_rw_0.dff_buf_array_0.dout_bar_0 a_n1274_n227# din0[1] sky130_fd_pr__nfet_01v8 ad=1.764n pd=0.119m as=1.764n ps=0.119m w=56 l=15
X363 din0[1] bank_0.replica_bitcell_array_0.dummy_array_3_0.dummy_cell_1rw_5.q bank_0.replica_bitcell_array_0.dummy_array_3_0.dummy_cell_1rw_5.qb din0[1] sky130_fd_pr__pfet_01v8 ad=1.925n pd=0.18m as=1.925n ps=0.18m w=55 l=15
X364 din0[1] bank_0.replica_bitcell_array_0.dummy_array_3_0.dummy_cell_1rw_12.q bank_0.replica_bitcell_array_0.dummy_array_3_0.dummy_cell_1rw_12.qb din0[1] sky130_fd_pr__pfet_01v8 ad=1.925n pd=0.18m as=1.925n ps=0.18m w=55 l=15
X365 a_2730_8919# bank_0.port_address_0.hierarchical_decoder_0.predecode_2 a_2676_8919# w_2422_8769# sky130_fd_pr__pfet_01v8 ad=1.848n pd=0.128m as=3.276n ps=0.246m w=84 l=15
X366 a_n4113_8329# control_logic_rw_0.delay_chain_0.pinv_11_14.Z a_n4166_8329# w_n5644_7860# sky130_fd_pr__pfet_01v8 ad=3.276n pd=0.246m as=3.192n ps=0.244m w=84 l=15
X367 bank_0.replica_bitcell_array_0.bitcell_array_0.cell_1rw_6.q bank_0.replica_bitcell_array_0.bitcell_array_0.cell_1rw_6.qb din0[1] din0[1] sky130_fd_pr__nfet_01v8 ad=3.864n pd=0.21m as=4.41n ps=0.322m w=126 l=15
X368 a_3483_7901# control_logic_rw_0.wl_en a_3424_7901# w_2422_7751# sky130_fd_pr__pfet_01v8 ad=3.192n pd=0.244m as=1.848n ps=0.128m w=84 l=15
X369 din0[1] bank_0.replica_bitcell_array_0.dummy_array_3_0.dummy_cell_1rw_8.q bank_0.replica_bitcell_array_0.dummy_array_3_0.dummy_cell_1rw_8.qb din0[1] sky130_fd_pr__nfet_01v8 ad=4.41n pd=0.322m as=3.864n ps=0.21m w=126 l=15
X370 din0[1] bank_0.replica_bitcell_array_0.dummy_array_3_0.dummy_cell_1rw_13.q bank_0.replica_bitcell_array_0.dummy_array_3_0.dummy_cell_1rw_13.qb din0[1] sky130_fd_pr__nfet_01v8 ad=4.41n pd=0.322m as=3.864n ps=0.21m w=126 l=15
X371 din0[1] bank_0.replica_bitcell_array_0.wl_0_1 bank_0.replica_bitcell_array_0.bitcell_array_0.cell_1rw_30.q din0[1] sky130_fd_pr__nfet_01v8 ad=1.428n pd=0.152m as=3.864n ps=0.21m w=42 l=15
X372 a_n1432_n107# control_logic_rw_0.dff_buf_array_0.dout_bar_0 a_n1510_n107# din0[1] sky130_fd_pr__nfet_01v8 ad=2.128n pd=0.188m as=1.764n ps=0.119m w=56 l=15
X373 a_n1607_705# control_logic_rw_0.dff_buf_array_0.dout_bar_0 a_n1685_705# din0[1] sky130_fd_pr__nfet_01v8 ad=1.89n pd=0.123m as=1.89n ps=0.123m w=60 l=15
X374 row_addr_dff_0.dff_3.net1 row_addr_dff_0.dff_3.clkb addr0[0] din0[1] sky130_fd_pr__nfet_01v8 ad=2.226n pd=0.148m as=1.932n ps=0.176m w=42 l=15
X375 row_addr_dff_0.dff_1.net4 row_addr_dff_0.dff_1.clkb row_addr_dff_0.dff_1.net3 din0[1] sky130_fd_pr__pfet_01v8 ad=2.915n pd=0.161m as=3.52n ps=0.238m w=55 l=15
X376 din0[1] bank_0.replica_bitcell_array_0.wl_0_15 bank_0.replica_bitcell_array_0.bitcell_array_0.cell_1rw_16.qb din0[1] sky130_fd_pr__nfet_01v8 ad=1.428n pd=0.152m as=3.864n ps=0.21m w=42 l=15
X377 din0[1] bank_0.replica_bitcell_array_0.replica_column_0.replica_cell_1rw_4.q din0[1] din0[1] sky130_fd_pr__pfet_01v8 ad=1.925n pd=0.18m as=0 ps=0 w=55 l=15
X378 a_n5369_7383# control_logic_rw_0.delay_chain_0.pinv_11_19.Z a_n5422_7383# din0[1] sky130_fd_pr__nfet_01v8 ad=1.638n pd=0.162m as=1.596n ps=0.16m w=42 l=15
X379 a_n5369_6501# control_logic_rw_0.delay_chain_0.pinv_11_24.Z a_n5422_6501# w_n5644_6180# sky130_fd_pr__pfet_01v8 ad=3.276n pd=0.246m as=3.192n ps=0.244m w=84 l=15
X380 din0[1] bank_0.replica_bitcell_array_0.replica_column_0.replica_cell_1rw_11.q din0[1] din0[1] sky130_fd_pr__pfet_01v8 ad=1.925n pd=0.18m as=0 ps=0 w=55 l=15
X381 a_n2461_599# control_logic_rw_0.dff_buf_array_0.dout_bar_0 a_n2515_599# din0[1] sky130_fd_pr__nfet_01v8 ad=1.596n pd=0.16m as=1.638n ps=0.162m w=42 l=15
X382 bank_0.replica_bitcell_array_0.dummy_array_2_0.dummy_cell_1rw_7.q bank_0.replica_bitcell_array_0.dummy_array_2_0.dummy_cell_1rw_7.qb din0[1] din0[1] sky130_fd_pr__nfet_01v8 ad=3.864n pd=0.21m as=4.41n ps=0.322m w=126 l=15
X383 bank_0.replica_bitcell_array_0.bitcell_array_0.cell_1rw_14.q bank_0.replica_bitcell_array_0.bitcell_array_0.cell_1rw_14.qb din0[1] din0[1] sky130_fd_pr__pfet_01v8 ad=1.925n pd=0.18m as=1.925n ps=0.18m w=55 l=15
X384 data_dff_0.dff_0.net4 data_dff_0.dff_0.clkb data_dff_0.dff_0.net3 din0[1] sky130_fd_pr__pfet_01v8 ad=2.915n pd=0.161m as=3.52n ps=0.238m w=55 l=15
X385 row_addr_dff_0.dff_3.clkb row_addr_dff_0.dff_3.clk din0[1] din0[1] sky130_fd_pr__pfet_01v8 ad=2.53n pd=0.202m as=2.53n ps=0.202m w=55 l=15
X386 a_739_7029# row_addr_dff_0.dout_3 a_685_7029# w_431_6733# sky130_fd_pr__pfet_01v8 ad=3.192n pd=0.244m as=3.276n ps=0.246m w=84 l=15
X387 a_1822_4485# din0[1] a_1768_4485# din0[1] sky130_fd_pr__nfet_01v8 ad=1.596n pd=0.16m as=1.638n ps=0.162m w=42 l=15
X388 a_n3525_n919# control_logic_rw_0.dff_buf_array_0.dout_bar_0 a_n3579_n919# din0[1] sky130_fd_pr__nfet_01v8 ad=1.764n pd=0.119m as=2.184n ps=0.19m w=56 l=15
X389 a_n1664_n513# control_logic_rw_0.dff_buf_array_0.dout_bar_0 a_n1742_n513# w_n2769_n767# sky130_fd_pr__pfet_01v8 ad=3.528n pd=0.175m as=3.528n ps=0.175m w=112 l=15
X390 din0[1] din0[1] din0[1] din0[1] sky130_fd_pr__nfet_01v8 ad=0.56n pd=77u as=0 ps=0 w=19 l=1
X391 din0[1] row_addr_dff_0.dff_0.net3 row_addr_dff_0.dff_0.net2 din0[1] sky130_fd_pr__nfet_01v8 ad=1.68n pd=0.122m as=2.226n ps=0.19m w=42 l=15
X392 din0[1] bank_0.replica_bitcell_array_0.wl_0_7 bank_0.replica_bitcell_array_0.bitcell_array_0.cell_1rw_24.q din0[1] sky130_fd_pr__nfet_01v8 ad=1.428n pd=0.152m as=3.864n ps=0.21m w=42 l=15
X393 bank_0.replica_bitcell_array_0.dummy_array_2_0.dummy_cell_1rw_15.q bank_0.replica_bitcell_array_0.dummy_array_2_0.dummy_cell_1rw_15.qb din0[1] din0[1] sky130_fd_pr__pfet_01v8 ad=1.925n pd=0.18m as=1.925n ps=0.18m w=55 l=15
X394 a_n3525_n513# control_logic_rw_0.dff_buf_array_0.dout_bar_0 a_n3579_n513# w_n4225_n767# sky130_fd_pr__pfet_01v8 ad=3.528n pd=0.175m as=4.368n ps=0.302m w=112 l=15
X395 control_logic_rw_0.dff_buf_array_0.dff_buf_0_0.dff_0.clkb din0[1] din0[1] din0[1] sky130_fd_pr__nfet_01v8 ad=1.932n pd=0.176m as=1.932n ps=0.176m w=42 l=15
X396 din0[1] bank_0.replica_bitcell_array_0.bitcell_array_0.cell_1rw_18.q bank_0.replica_bitcell_array_0.bitcell_array_0.cell_1rw_18.qb din0[1] sky130_fd_pr__pfet_01v8 ad=1.925n pd=0.18m as=1.925n ps=0.18m w=55 l=15
X397 data_dff_0.dff_0.net4 din0[1] data_dff_0.dff_0.net3 din0[1] sky130_fd_pr__nfet_01v8 ad=2.226n pd=0.148m as=2.73n ps=0.214m w=42 l=15
X398 bank_0.replica_bitcell_array_0.bitcell_array_0.cell_1rw_31.q bank_0.replica_bitcell_array_0.bitcell_array_0.cell_1rw_31.qb din0[1] din0[1] sky130_fd_pr__nfet_01v8 ad=3.864n pd=0.21m as=4.41n ps=0.322m w=126 l=15
X399 bank_0.replica_bitcell_array_0.dummy_array_3_0.dummy_cell_1rw_10.q bank_0.replica_bitcell_array_0.dummy_array_3_0.dummy_cell_1rw_10.qb din0[1] din0[1] sky130_fd_pr__nfet_01v8 ad=3.864n pd=0.21m as=4.41n ps=0.322m w=126 l=15
X400 bank_0.replica_bitcell_array_0.dummy_array_3_0.dummy_cell_1rw_15.q bank_0.replica_bitcell_array_0.dummy_array_3_0.dummy_cell_1rw_15.qb din0[1] din0[1] sky130_fd_pr__nfet_01v8 ad=3.864n pd=0.21m as=4.41n ps=0.322m w=126 l=15
X401 row_addr_dff_0.dff_0.net1 row_addr_dff_0.dff_0.clkb addr0[3] din0[1] sky130_fd_pr__nfet_01v8 ad=2.226n pd=0.148m as=1.932n ps=0.176m w=42 l=15
X402 a_n5369_5809# control_logic_rw_0.delay_chain_0.pinv_11_24.Z a_n5422_5809# din0[1] sky130_fd_pr__nfet_01v8 ad=1.638n pd=0.162m as=1.596n ps=0.16m w=42 l=15
X403 a_3483_4993# control_logic_rw_0.wl_en a_3424_4993# w_2422_4697# sky130_fd_pr__pfet_01v8 ad=3.192n pd=0.244m as=1.848n ps=0.128m w=84 l=15
X404 a_2789_11101# bank_0.port_address_0.hierarchical_decoder_0.predecode_7 a_2730_11101# w_2422_10805# sky130_fd_pr__pfet_01v8 ad=3.192n pd=0.244m as=1.848n ps=0.128m w=84 l=15
X405 row_addr_dff_0.dff_2.net5 row_addr_dff_0.dff_2.clkb row_addr_dff_0.dff_2.net4 din0[1] sky130_fd_pr__nfet_01v8 ad=3.318n pd=0.242m as=2.226n ps=0.148m w=42 l=15
X406 a_n4427_9063# control_logic_rw_0.delay_chain_0.pinv_11_9.Z a_n4480_9063# din0[1] sky130_fd_pr__nfet_01v8 ad=1.638n pd=0.162m as=1.596n ps=0.16m w=42 l=15
X407 bank_0.replica_bitcell_array_0.replica_column_0.replica_cell_1rw_9.q din0[1] din0[1] din0[1] sky130_fd_pr__nfet_01v8 ad=3.864n pd=0.21m as=4.41n ps=0.322m w=126 l=15
X408 a_2789_5355# bank_0.port_address_0.hierarchical_decoder_0.predecode_4 bank_0.port_address_0.hierarchical_decoder_0.and2_dec_12.pnand2_0.nmos_m1_w0_840_sactive_dli_0.S din0[1] sky130_fd_pr__nfet_01v8 ad=3.192n pd=0.244m as=1.848n ps=0.128m w=84 l=15
X409 bank_0.replica_bitcell_array_0.replica_column_0.replica_cell_1rw_14.q din0[1] din0[1] din0[1] sky130_fd_pr__nfet_01v8 ad=3.864n pd=0.21m as=4.41n ps=0.322m w=126 l=15
X410 din0[1] din0[1] din0[1] din0[1] sky130_fd_pr__pfet_01v8 ad=0.696n pd=90u as=0 ps=0 w=55 l=15
X411 bank_0.replica_bitcell_array_0.dummy_array_3_0.dummy_cell_1rw_10.q bank_0.replica_bitcell_array_0.wl_0_6 a_5461_6565# din0[1] sky130_fd_pr__nfet_01v8 ad=3.864n pd=0.21m as=1.428n ps=0.152m w=42 l=15
X412 a_n1299_589# control_logic_rw_0.pdriver_1_0.pinv_6_0.A a_n1377_589# din0[1] sky130_fd_pr__nfet_01v8 ad=1.638n pd=0.115m as=1.638n ps=0.115m w=52 l=15
X413 a_3797_6415# din0[1] a_3743_6415# din0[1] sky130_fd_pr__nfet_01v8 ad=1.596n pd=0.16m as=1.638n ps=0.162m w=42 l=15
X414 bank_0.replica_bitcell_array_0.bitcell_array_0.cell_1rw_1.q bank_0.replica_bitcell_array_0.bitcell_array_0.cell_1rw_1.qb din0[1] din0[1] sky130_fd_pr__pfet_01v8 ad=1.925n pd=0.18m as=1.925n ps=0.18m w=55 l=15
X415 bank_0.replica_bitcell_array_0.replica_column_0.replica_cell_1rw_9.q bank_0.replica_bitcell_array_0.wl_0_6 din0[1] din0[1] sky130_fd_pr__nfet_01v8 ad=3.864n pd=0.21m as=1.428n ps=0.152m w=42 l=15
X416 control_logic_rw_0.dff_buf_array_0.dff_buf_0_1.dff_0.net4 control_logic_rw_0.dff_buf_array_0.dff_buf_0_1.dff_0.clkb control_logic_rw_0.dff_buf_array_0.dff_buf_0_1.dff_0.net3 din0[1] sky130_fd_pr__pfet_01v8 ad=2.915n pd=0.161m as=3.52n ps=0.238m w=55 l=15
X417 bank_0.replica_bitcell_array_0.bitcell_array_0.cell_1rw_31.qb bank_0.replica_bitcell_array_0.wl_0_0 din0[1] din0[1] sky130_fd_pr__nfet_01v8 ad=3.864n pd=0.21m as=1.428n ps=0.152m w=42 l=15
X418 din0[1] bank_0.replica_bitcell_array_0.replica_column_0.replica_cell_1rw_13.q din0[1] din0[1] sky130_fd_pr__nfet_01v8 ad=3.864n pd=0.21m as=0 ps=0 w=126 l=15
X419 bank_0.replica_bitcell_array_0.bitcell_array_0.cell_1rw_2.q bank_0.replica_bitcell_array_0.bitcell_array_0.cell_1rw_2.qb din0[1] din0[1] sky130_fd_pr__pfet_01v8 ad=1.925n pd=0.18m as=1.925n ps=0.18m w=55 l=15
X420 a_n4741_4821# control_logic_rw_0.delay_chain_0.pinv_11_34.Z a_n4794_4821# w_n5644_4500# sky130_fd_pr__pfet_01v8 ad=3.276n pd=0.246m as=3.192n ps=0.244m w=84 l=15
X421 din0[1] din0[1] data_dff_0.dff_0.net5 din0[1] sky130_fd_pr__pfet_01v8 ad=2.2n pd=0.135m as=3.08n ps=0.222m w=55 l=15
X422 bank_0.replica_bitcell_array_0.dummy_array_3_0.dummy_cell_1rw_6.qb bank_0.replica_bitcell_array_0.wl_0_10 a_5530_8601# din0[1] sky130_fd_pr__nfet_01v8 ad=3.864n pd=0.21m as=1.428n ps=0.152m w=42 l=15
X423 bank_0.port_address_0.hierarchical_decoder_0.and2_dec_6.pnand2_0.nmos_m1_w0_840_sactive_dli_0.S bank_0.port_address_0.hierarchical_decoder_0.predecode_1 a_2676_8409# din0[1] sky130_fd_pr__nfet_01v8 ad=1.848n pd=0.128m as=3.276n ps=0.246m w=84 l=15
X424 din0[1] din0[1] din0[1] din0[1] sky130_fd_pr__nfet_01v8 ad=1.485n pd=0.134m as=0 ps=0 w=57 l=15
X425 a_3424_6011# bank_0.port_address_0.wordline_driver_array_0.in_5 a_3370_6011# w_2422_5715# sky130_fd_pr__pfet_01v8 ad=1.848n pd=0.128m as=3.276n ps=0.246m w=84 l=15
X426 bank_0.port_address_0.hierarchical_decoder_0.hierarchical_predecode2x4_1.and2_dec_0.pnand2_0.nmos_m1_w0_840_sactive_dli_0.S din0[1] a_1395_5355# din0[1] sky130_fd_pr__nfet_01v8 ad=1.848n pd=0.128m as=3.276n ps=0.246m w=84 l=15
X427 din0[1] control_logic_rw_0.dff_buf_array_0.dff_buf_0_0.pinv_0_0.A control_logic_rw_0.dff_buf_array_0.dff_buf_0_0.dff_0.net5 din0[1] sky130_fd_pr__nfet_01v8 ad=1.68n pd=0.122m as=2.352n ps=0.196m w=42 l=15
X428 a_4490_10451# bank_0.replica_bitcell_array_0.wl_0_13 bank_0.replica_bitcell_array_0.dummy_array_2_0.dummy_cell_1rw_3.qb din0[1] sky130_fd_pr__nfet_01v8 ad=1.428n pd=0.152m as=3.864n ps=0.21m w=42 l=15
X429 a_3483_9937# control_logic_rw_0.wl_en a_3424_9937# w_2422_9787# sky130_fd_pr__pfet_01v8 ad=3.192n pd=0.244m as=1.848n ps=0.128m w=84 l=15
X430 din0[1] bank_0.replica_bitcell_array_0.wl_0_10 din0[1] din0[1] sky130_fd_pr__nfet_01v8 ad=3.864n pd=0.21m as=0 ps=0 w=42 l=15
X431 control_logic_rw_0.dff_buf_array_0.dff_buf_0_1.dff_0.net4 din0[1] control_logic_rw_0.dff_buf_array_0.dff_buf_0_1.dff_0.net3 din0[1] sky130_fd_pr__nfet_01v8 ad=2.226n pd=0.148m as=2.73n ps=0.214m w=42 l=15
X432 a_n1742_n227# control_logic_rw_0.dff_buf_array_0.dout_bar_0 a_n1796_n227# din0[1] sky130_fd_pr__nfet_01v8 ad=1.764n pd=0.119m as=2.184n ps=0.19m w=56 l=15
X433 row_addr_dff_0.dff_3.net4 row_addr_dff_0.dff_3.clkb row_addr_dff_0.dff_3.net3 din0[1] sky130_fd_pr__pfet_01v8 ad=2.915n pd=0.161m as=3.52n ps=0.238m w=55 l=15
X434 a_3424_10083# bank_0.port_address_0.wordline_driver_array_0.in_13 a_3370_10083# w_2422_9787# sky130_fd_pr__pfet_01v8 ad=1.848n pd=0.128m as=3.276n ps=0.246m w=84 l=15
X435 din0[1] bank_0.replica_bitcell_array_0.bitcell_array_0.cell_1rw_5.q bank_0.replica_bitcell_array_0.bitcell_array_0.cell_1rw_5.qb din0[1] sky130_fd_pr__pfet_01v8 ad=1.925n pd=0.18m as=1.925n ps=0.18m w=55 l=15
X436 din0[1] din0[1] data_dff_0.dff_0.net5 din0[1] sky130_fd_pr__nfet_01v8 ad=1.68n pd=0.122m as=2.352n ps=0.196m w=42 l=15
X437 a_n1588_123# control_logic_rw_0.dff_buf_array_0.dout_bar_0 a_n1666_123# w_n2769_44# sky130_fd_pr__pfet_01v8 ad=3.528n pd=0.175m as=3.528n ps=0.175m w=112 l=15
X438 din0[1] bank_0.replica_bitcell_array_0.bitcell_array_0.cell_1rw_6.q bank_0.replica_bitcell_array_0.bitcell_array_0.cell_1rw_6.qb din0[1] sky130_fd_pr__nfet_01v8 ad=4.41n pd=0.322m as=3.864n ps=0.21m w=126 l=15
X439 a_3797_6521# din0[1] a_3743_6521# din0[1] sky130_fd_pr__nfet_01v8 ad=1.596n pd=0.16m as=1.638n ps=0.162m w=42 l=15
X440 din0[1] row_addr_dff_0.dff_2.net3 row_addr_dff_0.dff_2.net2 din0[1] sky130_fd_pr__nfet_01v8 ad=1.68n pd=0.122m as=2.226n ps=0.19m w=42 l=15
X441 din0[1] bank_0.replica_bitcell_array_0.dummy_array_2_0.dummy_cell_1rw_6.q bank_0.replica_bitcell_array_0.dummy_array_2_0.dummy_cell_1rw_6.qb din0[1] sky130_fd_pr__pfet_01v8 ad=1.925n pd=0.18m as=1.925n ps=0.18m w=55 l=15
X442 a_n4113_8181# control_logic_rw_0.delay_chain_0.pinv_11_19.Z a_n4166_8181# w_n5644_7860# sky130_fd_pr__pfet_01v8 ad=3.276n pd=0.246m as=3.192n ps=0.244m w=84 l=15
X443 a_5530_11469# bank_0.replica_bitcell_array_0.wl_0_15 bank_0.replica_bitcell_array_0.dummy_array_3_0.dummy_cell_1rw_1.qb din0[1] sky130_fd_pr__nfet_01v8 ad=1.428n pd=0.152m as=3.864n ps=0.21m w=42 l=15
X444 din0[1] bank_0.replica_bitcell_array_0.dummy_array_2_0.dummy_cell_1rw_7.q bank_0.replica_bitcell_array_0.dummy_array_2_0.dummy_cell_1rw_7.qb din0[1] sky130_fd_pr__nfet_01v8 ad=4.41n pd=0.322m as=3.864n ps=0.21m w=126 l=15
X445 a_n1997_927# control_logic_rw_0.dff_buf_array_0.dout_bar_0 a_n2051_927# w_n2769_857# sky130_fd_pr__pfet_01v8 ad=3.78n pd=0.183m as=4.68n ps=0.318m w=120 l=15
X446 a_5530_3325# bank_0.replica_bitcell_array_0.rbl_wl_0_0 bank_0.replica_bitcell_array_0.dummy_array_3_0.dummy_cell_1rw_17.qb din0[1] sky130_fd_pr__nfet_01v8 ad=1.428n pd=0.152m as=3.864n ps=0.21m w=42 l=15
X447 a_n4113_4969# control_logic_rw_0.delay_chain_0.pinv_11_34.Z a_n4166_4969# w_n5644_4500# sky130_fd_pr__pfet_01v8 ad=3.276n pd=0.246m as=3.192n ps=0.244m w=84 l=15
X448 bank_0.replica_bitcell_array_0.dummy_array_2_0.dummy_cell_1rw_1.q bank_0.replica_bitcell_array_0.dummy_array_2_0.dummy_cell_1rw_1.qb din0[1] din0[1] sky130_fd_pr__pfet_01v8 ad=1.925n pd=0.18m as=1.925n ps=0.18m w=55 l=15
X449 din0[1] bank_0.replica_bitcell_array_0.dummy_array_2_0.dummy_cell_1rw_3.q bank_0.replica_bitcell_array_0.dummy_array_2_0.dummy_cell_1rw_3.qb din0[1] sky130_fd_pr__pfet_01v8 ad=1.925n pd=0.18m as=1.925n ps=0.18m w=55 l=15
X450 din0[1] bank_0.replica_bitcell_array_0.wl_0_11 bank_0.replica_bitcell_array_0.bitcell_array_0.cell_1rw_20.qb din0[1] sky130_fd_pr__nfet_01v8 ad=1.428n pd=0.152m as=3.864n ps=0.21m w=42 l=15
X451 a_4852_1928# control_logic_rw_0.p_en_bar a_4793_1928# w_4605_1519# sky130_fd_pr__pfet_01v8 ad=3.192n pd=0.244m as=1.848n ps=0.128m w=84 l=15
X452 din0[1] bank_0.replica_bitcell_array_0.rbl_wl_0_0 din0[1] din0[1] sky130_fd_pr__nfet_01v8 ad=1.428n pd=0.152m as=0 ps=0 w=42 l=15
X453 row_addr_dff_0.dff_2.net1 row_addr_dff_0.dff_2.clkb addr0[1] din0[1] sky130_fd_pr__nfet_01v8 ad=2.226n pd=0.148m as=1.932n ps=0.176m w=42 l=15
X454 data_dff_0.dff_0.clkb din0[1] din0[1] din0[1] sky130_fd_pr__pfet_01v8 ad=2.53n pd=0.202m as=0.44n ps=71u w=55 l=15
X455 din0[1] bank_0.replica_bitcell_array_0.dummy_array_3_0.dummy_cell_1rw_3.q bank_0.replica_bitcell_array_0.dummy_array_3_0.dummy_cell_1rw_3.qb din0[1] sky130_fd_pr__pfet_01v8 ad=1.925n pd=0.18m as=1.925n ps=0.18m w=55 l=15
X456 din0[1] din0[1] din0[1] din0[1] sky130_fd_pr__nfet_01v8 ad=4.5n pd=0.29m as=0 ps=0 w=100 l=15
X457 din0[1] bank_0.replica_bitcell_array_0.dummy_array_0_0.dummy_cell_1rw_1.q bank_0.replica_bitcell_array_0.dummy_array_0_0.dummy_cell_1rw_1.qb din0[1] sky130_fd_pr__pfet_01v8 ad=1.925n pd=0.18m as=1.925n ps=0.18m w=55 l=15
X458 din0[1] data_dff_0.dff_0.net4 din0[1] din0[1] sky130_fd_pr__pfet_01v8 ad=2.2n pd=0.135m as=0 ps=0 w=55 l=15
X459 bank_0.replica_bitcell_array_0.bitcell_array_0.cell_1rw_15.q bank_0.replica_bitcell_array_0.bitcell_array_0.cell_1rw_15.qb din0[1] din0[1] sky130_fd_pr__nfet_01v8 ad=3.864n pd=0.21m as=4.41n ps=0.322m w=126 l=15
X460 a_3483_3467# control_logic_rw_0.wl_en bank_0.port_address_0.wordline_driver_array_0.wordline_driver_15.pnand2_0.nmos_m1_w0_840_sactive_dli_0.S din0[1] sky130_fd_pr__nfet_01v8 ad=3.192n pd=0.244m as=1.848n ps=0.128m w=84 l=15
X461 a_n1143_n919# control_logic_rw_0.pdriver_0_0.pinv_7_0.A a_n1197_n919# din0[1] sky130_fd_pr__nfet_01v8 ad=1.795n pd=0.12m as=2.223n ps=0.192m w=57 l=15
X462 a_n4113_7489# control_logic_rw_0.delay_chain_0.pinv_11_19.Z a_n4166_7489# din0[1] sky130_fd_pr__nfet_01v8 ad=1.638n pd=0.162m as=1.596n ps=0.16m w=42 l=15
X463 bank_0.replica_bitcell_array_0.bitcell_array_0.cell_1rw_31.q bank_0.replica_bitcell_array_0.bitcell_array_0.cell_1rw_31.qb din0[1] din0[1] sky130_fd_pr__pfet_01v8 ad=1.925n pd=0.18m as=1.925n ps=0.18m w=55 l=15
X464 bank_0.replica_bitcell_array_0.dummy_array_1_0.dummy_cell_1rw_0.qb din0[1] a_5270_2493# din0[1] sky130_fd_pr__nfet_01v8 ad=3.864n pd=0.21m as=1.428n ps=0.152m w=42 l=15
X465 bank_0.replica_bitcell_array_0.dummy_array_2_0.dummy_cell_1rw_16.q bank_0.replica_bitcell_array_0.dummy_array_2_0.dummy_cell_1rw_16.qb din0[1] din0[1] sky130_fd_pr__nfet_01v8 ad=3.864n pd=0.21m as=4.41n ps=0.322m w=126 l=15
X466 bank_0.replica_bitcell_array_0.bitcell_array_0.cell_1rw_3.q bank_0.replica_bitcell_array_0.wl_0_12 din0[1] din0[1] sky130_fd_pr__nfet_01v8 ad=3.864n pd=0.21m as=1.428n ps=0.152m w=42 l=15
X467 din0[1] bank_0.replica_bitcell_array_0.replica_column_0.replica_cell_1rw_9.q din0[1] din0[1] sky130_fd_pr__nfet_01v8 ad=3.864n pd=0.21m as=0 ps=0 w=126 l=15
X468 din0[1] bank_0.replica_bitcell_array_0.replica_column_0.replica_cell_1rw_14.q din0[1] din0[1] sky130_fd_pr__nfet_01v8 ad=3.864n pd=0.21m as=0 ps=0 w=126 l=15
X469 a_n1723_n681# control_logic_rw_0.pdriver_0_0.pinv_6_0.A a_n1777_n681# w_n2769_n767# sky130_fd_pr__pfet_01v8 ad=3.307n pd=0.168m as=4.095n ps=0.288m w=105 l=15
X470 a_n3917_n919# control_logic_rw_0.dff_buf_array_0.dff_buf_0_1.pinv_0_0.A a_n3971_n919# din0[1] sky130_fd_pr__nfet_01v8 ad=1.323n pd=0.105m as=1.638n ps=0.162m w=42 l=15
X471 data_dff_0.dff_0.clkb din0[1] din0[1] din0[1] sky130_fd_pr__nfet_01v8 ad=1.932n pd=0.176m as=0.336n ps=58u w=42 l=15
X472 din0[1] bank_0.replica_bitcell_array_0.bitcell_array_0.cell_1rw_0.q bank_0.replica_bitcell_array_0.bitcell_array_0.cell_1rw_0.qb din0[1] sky130_fd_pr__pfet_01v8 ad=1.925n pd=0.18m as=1.925n ps=0.18m w=55 l=15
X473 bank_0.replica_bitcell_array_0.replica_column_0.replica_cell_1rw_1.q din0[1] din0[1] din0[1] sky130_fd_pr__pfet_01v8 ad=1.925n pd=0.18m as=1.925n ps=0.18m w=55 l=15
X474 bank_0.replica_bitcell_array_0.dummy_array_2_0.dummy_cell_1rw_2.q bank_0.replica_bitcell_array_0.dummy_array_2_0.dummy_cell_1rw_2.qb din0[1] din0[1] sky130_fd_pr__nfet_01v8 ad=3.864n pd=0.21m as=4.41n ps=0.322m w=126 l=15
X475 a_3103_10487# din0[1] a_3049_10487# din0[1] sky130_fd_pr__nfet_01v8 ad=1.596n pd=0.16m as=1.638n ps=0.162m w=42 l=15
X476 a_2789_7901# bank_0.port_address_0.hierarchical_decoder_0.predecode_6 a_2730_7901# w_2422_7751# sky130_fd_pr__pfet_01v8 ad=3.192n pd=0.244m as=1.848n ps=0.128m w=84 l=15
X477 a_3797_7029# din0[1] a_3743_7029# w_2422_6733# sky130_fd_pr__pfet_01v8 ad=3.192n pd=0.244m as=3.276n ps=0.246m w=84 l=15
X478 a_n5055_5703# control_logic_rw_0.delay_chain_0.pinv_11_29.Z a_n5108_5703# din0[1] sky130_fd_pr__nfet_01v8 ad=1.638n pd=0.162m as=1.596n ps=0.16m w=42 l=15
X479 a_n3917_n513# control_logic_rw_0.dff_buf_array_0.dff_buf_0_0.pinv_0_0.A a_n3971_n513# w_n4225_n767# sky130_fd_pr__pfet_01v8 ad=2.646n pd=0.147m as=3.276n ps=0.246m w=84 l=15
X480 bank_0.replica_bitcell_array_0.dummy_array_2_0.dummy_cell_1rw_18.qb din0[1] a_4490_2493# din0[1] sky130_fd_pr__nfet_01v8 ad=3.864n pd=0.21m as=1.428n ps=0.152m w=42 l=15
X481 a_3483_9427# control_logic_rw_0.wl_en bank_0.port_address_0.wordline_driver_array_0.wordline_driver_4.pnand2_0.nmos_m1_w0_840_sactive_dli_0.S din0[1] sky130_fd_pr__nfet_01v8 ad=3.192n pd=0.244m as=1.848n ps=0.128m w=84 l=15
X482 a_n5055_3289# control_logic_rw_0.delay_chain_0.pinv_11_39.Z a_n5108_3289# w_n5644_2820# sky130_fd_pr__pfet_01v8 ad=3.276n pd=0.246m as=3.192n ps=0.244m w=84 l=15
X483 bank_0.replica_bitcell_array_0.dummy_array_2_0.dummy_cell_1rw_4.q bank_0.replica_bitcell_array_0.wl_0_12 a_4421_9619# din0[1] sky130_fd_pr__nfet_01v8 ad=3.864n pd=0.21m as=1.428n ps=0.152m w=42 l=15
X484 a_3424_8047# bank_0.port_address_0.wordline_driver_array_0.in_9 a_3370_8047# w_2422_7751# sky130_fd_pr__pfet_01v8 ad=1.848n pd=0.128m as=3.276n ps=0.246m w=84 l=15
X485 a_n4427_4821# control_logic_rw_0.delay_chain_0.pinv_11_34.Z a_n4480_4821# w_n5644_4500# sky130_fd_pr__pfet_01v8 ad=3.276n pd=0.246m as=3.192n ps=0.244m w=84 l=15
X486 din0[1] data_dff_0.dff_0.net4 din0[1] din0[1] sky130_fd_pr__nfet_01v8 ad=1.68n pd=0.122m as=0 ps=0 w=42 l=15
X487 din0[1] bank_0.replica_bitcell_array_0.wl_0_13 bank_0.replica_bitcell_array_0.bitcell_array_0.cell_1rw_2.q din0[1] sky130_fd_pr__nfet_01v8 ad=1.428n pd=0.152m as=3.864n ps=0.21m w=42 l=15
X488 a_3424_3829# bank_0.port_address_0.wordline_driver_array_0.in_0 a_3370_3829# w_2422_3679# sky130_fd_pr__pfet_01v8 ad=1.848n pd=0.128m as=3.276n ps=0.246m w=84 l=15
X489 din0[1] bank_0.replica_bitcell_array_0.dummy_array_1_0.dummy_cell_1rw_1.q bank_0.replica_bitcell_array_0.dummy_array_1_0.dummy_cell_1rw_1.qb din0[1] sky130_fd_pr__pfet_01v8 ad=1.925n pd=0.18m as=1.925n ps=0.18m w=55 l=15
X490 bank_0.replica_bitcell_array_0.replica_column_0.replica_cell_1rw_2.q din0[1] din0[1] din0[1] sky130_fd_pr__pfet_01v8 ad=1.925n pd=0.18m as=1.925n ps=0.18m w=55 l=15
X491 a_3103_4379# din0[1] a_3049_4379# din0[1] sky130_fd_pr__nfet_01v8 ad=1.596n pd=0.16m as=1.638n ps=0.162m w=42 l=15
X492 bank_0.port_address_0.hierarchical_decoder_0.and2_dec_1.pnand2_0.nmos_m1_w0_840_sactive_dli_0.S bank_0.port_address_0.hierarchical_decoder_0.predecode_2 a_2676_10593# din0[1] sky130_fd_pr__nfet_01v8 ad=1.848n pd=0.128m as=3.276n ps=0.246m w=84 l=15
X493 bank_0.replica_bitcell_array_0.dummy_array_3_0.dummy_cell_1rw_4.q bank_0.replica_bitcell_array_0.dummy_array_3_0.dummy_cell_1rw_4.qb din0[1] din0[1] sky130_fd_pr__pfet_01v8 ad=1.925n pd=0.18m as=1.925n ps=0.18m w=55 l=15
X494 bank_0.replica_bitcell_array_0.bitcell_array_0.cell_1rw_11.qb bank_0.replica_bitcell_array_0.wl_0_4 din0[1] din0[1] sky130_fd_pr__nfet_01v8 ad=3.864n pd=0.21m as=1.428n ps=0.152m w=42 l=15
X495 din0[1] bank_0.replica_bitcell_array_0.bitcell_array_0.cell_1rw_29.q bank_0.replica_bitcell_array_0.bitcell_array_0.cell_1rw_29.qb din0[1] sky130_fd_pr__nfet_01v8 ad=4.41n pd=0.322m as=3.864n ps=0.21m w=126 l=15
X496 din0[1] bank_0.replica_bitcell_array_0.dummy_array_3_0.dummy_cell_1rw_8.q bank_0.replica_bitcell_array_0.dummy_array_3_0.dummy_cell_1rw_8.qb din0[1] sky130_fd_pr__pfet_01v8 ad=1.925n pd=0.18m as=1.925n ps=0.18m w=55 l=15
X497 a_n519_n919# control_logic_rw_0.pdriver_0_0.pinv_7_0.A a_n597_n919# din0[1] sky130_fd_pr__nfet_01v8 ad=1.795n pd=0.12m as=1.795n ps=0.12m w=57 l=15
X498 bank_0.replica_bitcell_array_0.dummy_array_3_0.dummy_cell_1rw_17.q bank_0.replica_bitcell_array_0.dummy_array_3_0.dummy_cell_1rw_17.qb din0[1] din0[1] sky130_fd_pr__pfet_01v8 ad=1.925n pd=0.18m as=1.925n ps=0.18m w=55 l=15
X499 bank_0.replica_bitcell_array_0.bitcell_array_0.cell_1rw_26.q bank_0.replica_bitcell_array_0.bitcell_array_0.cell_1rw_26.qb din0[1] din0[1] sky130_fd_pr__pfet_01v8 ad=1.925n pd=0.18m as=1.925n ps=0.18m w=55 l=15
X500 din0[1] bank_0.replica_bitcell_array_0.bitcell_array_0.cell_1rw_1.q bank_0.replica_bitcell_array_0.bitcell_array_0.cell_1rw_1.qb din0[1] sky130_fd_pr__pfet_01v8 ad=1.925n pd=0.18m as=1.925n ps=0.18m w=55 l=15
X501 bank_0.replica_bitcell_array_0.replica_column_0.replica_cell_1rw_3.q din0[1] din0[1] din0[1] sky130_fd_pr__pfet_01v8 ad=1.925n pd=0.18m as=1.925n ps=0.18m w=55 l=15
X502 din0[1] bank_0.replica_bitcell_array_0.dummy_array_3_0.dummy_cell_1rw_4.q bank_0.replica_bitcell_array_0.dummy_array_3_0.dummy_cell_1rw_4.qb din0[1] sky130_fd_pr__nfet_01v8 ad=4.41n pd=0.322m as=3.864n ps=0.21m w=126 l=15
X503 a_3797_8557# din0[1] a_3743_8557# din0[1] sky130_fd_pr__nfet_01v8 ad=1.596n pd=0.16m as=1.638n ps=0.162m w=42 l=15
X504 a_1449_7901# bank_0.port_address_0.hierarchical_decoder_0.hierarchical_predecode2x4_0.pinv_1.Z a_1395_7901# w_1141_7751# sky130_fd_pr__pfet_01v8 ad=1.848n pd=0.128m as=3.276n ps=0.246m w=84 l=15
X505 din0[1] bank_0.replica_bitcell_array_0.dummy_array_3_0.dummy_cell_1rw_9.q bank_0.replica_bitcell_array_0.dummy_array_3_0.dummy_cell_1rw_9.qb din0[1] sky130_fd_pr__nfet_01v8 ad=4.41n pd=0.322m as=3.864n ps=0.21m w=126 l=15
X506 bank_0.replica_bitcell_array_0.dummy_array_2_0.dummy_cell_1rw_12.qb bank_0.replica_bitcell_array_0.wl_0_4 a_4490_5547# din0[1] sky130_fd_pr__nfet_01v8 ad=3.864n pd=0.21m as=1.428n ps=0.152m w=42 l=15
X507 a_3797_5865# din0[1] a_3743_5865# w_2422_5715# sky130_fd_pr__pfet_01v8 ad=3.192n pd=0.244m as=3.276n ps=0.246m w=84 l=15
X508 bank_0.replica_bitcell_array_0.dummy_array_3_0.dummy_cell_1rw_0.q bank_0.replica_bitcell_array_0.dummy_array_3_0.dummy_cell_1rw_0.qb din0[1] din0[1] sky130_fd_pr__pfet_01v8 ad=1.925n pd=0.18m as=1.925n ps=0.18m w=55 l=15
X509 bank_0.replica_bitcell_array_0.dummy_array_0_0.dummy_cell_1rw_0.q bank_0.replica_bitcell_array_0.dummy_array_0_0.dummy_cell_1rw_0.qb din0[1] din0[1] sky130_fd_pr__nfet_01v8 ad=3.864n pd=0.21m as=4.41n ps=0.322m w=126 l=15
X510 bank_0.port_address_0.wordline_driver_array_0.wordline_driver_3.pnand2_0.nmos_m1_w0_840_sactive_dli_0.S bank_0.port_address_0.wordline_driver_array_0.in_12 a_3370_9575# din0[1] sky130_fd_pr__nfet_01v8 ad=1.848n pd=0.128m as=3.276n ps=0.246m w=84 l=15
X511 din0[1] bank_0.replica_bitcell_array_0.replica_column_0.replica_cell_1rw_7.q din0[1] din0[1] sky130_fd_pr__pfet_01v8 ad=1.925n pd=0.18m as=0 ps=0 w=55 l=15
X512 a_5530_5361# bank_0.replica_bitcell_array_0.wl_0_3 bank_0.replica_bitcell_array_0.dummy_array_3_0.dummy_cell_1rw_13.qb din0[1] sky130_fd_pr__nfet_01v8 ad=1.428n pd=0.152m as=3.864n ps=0.21m w=42 l=15
X513 bank_0.replica_bitcell_array_0.replica_column_0.replica_cell_1rw_16.q din0[1] din0[1] din0[1] sky130_fd_pr__pfet_01v8 ad=1.925n pd=0.18m as=1.925n ps=0.18m w=55 l=15
X514 a_3424_6883# bank_0.port_address_0.wordline_driver_array_0.in_6 a_3370_6883# w_2422_6733# sky130_fd_pr__pfet_01v8 ad=1.848n pd=0.128m as=3.276n ps=0.246m w=84 l=15
X515 a_1822_6521# din0[1] a_1768_6521# din0[1] sky130_fd_pr__nfet_01v8 ad=1.596n pd=0.16m as=1.638n ps=0.162m w=42 l=15
X516 a_2789_4993# bank_0.port_address_0.hierarchical_decoder_0.predecode_4 a_2730_4993# w_2422_4697# sky130_fd_pr__pfet_01v8 ad=3.192n pd=0.244m as=1.848n ps=0.128m w=84 l=15
X517 a_n4741_4129# control_logic_rw_0.delay_chain_0.pinv_11_34.Z a_n4794_4129# din0[1] sky130_fd_pr__nfet_01v8 ad=1.638n pd=0.162m as=1.596n ps=0.16m w=42 l=15
X518 din0[1] bank_0.replica_bitcell_array_0.wl_0_3 din0[1] din0[1] sky130_fd_pr__nfet_01v8 ad=1.428n pd=0.152m as=0 ps=0 w=42 l=15
X519 bank_0.replica_bitcell_array_0.dummy_array_1_0.dummy_cell_1rw_1.q din0[1] a_4941_2493# din0[1] sky130_fd_pr__nfet_01v8 ad=3.864n pd=0.21m as=1.428n ps=0.152m w=42 l=15
X520 row_addr_dff_0.dff_0.net2 row_addr_dff_0.dff_0.clkb row_addr_dff_0.dff_0.net1 din0[1] sky130_fd_pr__pfet_01v8 ad=3.74n pd=0.246m as=2.915n ps=0.161m w=55 l=15
X521 a_3103_10593# din0[1] a_3049_10593# din0[1] sky130_fd_pr__nfet_01v8 ad=1.596n pd=0.16m as=1.638n ps=0.162m w=42 l=15
X522 a_1508_8047# row_addr_dff_0.dout_3 a_1449_8047# w_1141_7751# sky130_fd_pr__pfet_01v8 ad=3.192n pd=0.244m as=1.848n ps=0.128m w=84 l=15
X523 a_1508_3829# bank_0.port_address_0.hierarchical_decoder_0.hierarchical_predecode2x4_1.pinv_0.Z a_1449_3829# w_1141_3679# sky130_fd_pr__pfet_01v8 ad=3.192n pd=0.244m as=1.848n ps=0.128m w=84 l=15
X524 a_n1299_298# control_logic_rw_0.pdriver_1_0.pinv_6_0.A a_n1377_298# w_n2769_44# sky130_fd_pr__pfet_01v8 ad=3.307n pd=0.168m as=3.307n ps=0.168m w=105 l=15
X525 a_n5369_3141# control_logic_rw_0.delay_chain_0.pinv_11_44.Z a_n5422_3141# w_n5644_2820# sky130_fd_pr__pfet_01v8 ad=3.276n pd=0.246m as=3.192n ps=0.244m w=84 l=15
X526 a_n3369_n689# control_logic_rw_0.dff_buf_array_0.dout_bar_0 a_n3447_n689# w_n4225_n767# sky130_fd_pr__pfet_01v8 ad=4.256n pd=0.3m as=3.528n ps=0.175m w=112 l=15
X527 a_4421_11469# bank_0.replica_bitcell_array_0.wl_0_15 bank_0.replica_bitcell_array_0.dummy_array_2_0.dummy_cell_1rw_1.q din0[1] sky130_fd_pr__nfet_01v8 ad=1.428n pd=0.152m as=3.864n ps=0.21m w=42 l=15
X528 bank_0.replica_bitcell_array_0.bitcell_array_0.cell_1rw_27.q bank_0.replica_bitcell_array_0.bitcell_array_0.cell_1rw_27.qb din0[1] din0[1] sky130_fd_pr__nfet_01v8 ad=3.864n pd=0.21m as=4.41n ps=0.322m w=126 l=15
X529 a_3103_4485# din0[1] a_3049_4485# din0[1] sky130_fd_pr__nfet_01v8 ad=1.596n pd=0.16m as=1.638n ps=0.162m w=42 l=15
X530 a_n831_n691# control_logic_rw_0.pdriver_0_0.pinv_7_0.A a_n909_n691# w_n2769_n767# sky130_fd_pr__pfet_01v8 ad=3.622n pd=0.178m as=3.622n ps=0.178m w=115 l=15
X531 bank_0.replica_bitcell_array_0.dummy_array_0.dummy_cell_1rw_1.q bank_0.replica_bitcell_array_0.dummy_array_0.dummy_cell_1rw_1.qb din0[1] din0[1] sky130_fd_pr__nfet_01v8 ad=3.864n pd=0.21m as=4.41n ps=0.322m w=126 l=15
X532 a_5461_11469# bank_0.replica_bitcell_array_0.wl_0_15 bank_0.replica_bitcell_array_0.dummy_array_3_0.dummy_cell_1rw_1.q din0[1] sky130_fd_pr__nfet_01v8 ad=1.428n pd=0.152m as=3.864n ps=0.21m w=42 l=15
X533 bank_0.replica_bitcell_array_0.dummy_array_3_0.dummy_cell_1rw_11.q bank_0.replica_bitcell_array_0.dummy_array_3_0.dummy_cell_1rw_11.qb din0[1] din0[1] sky130_fd_pr__nfet_01v8 ad=3.864n pd=0.21m as=4.41n ps=0.322m w=126 l=15
X534 a_5112_1928# control_logic_rw_0.p_en_bar a_5053_1928# w_4605_1519# sky130_fd_pr__pfet_01v8 ad=3.192n pd=0.244m as=1.848n ps=0.128m w=84 l=15
X535 din0[1] bank_0.replica_bitcell_array_0.dummy_array_3_0.dummy_cell_1rw_15.q bank_0.replica_bitcell_array_0.dummy_array_3_0.dummy_cell_1rw_15.qb din0[1] sky130_fd_pr__pfet_01v8 ad=1.925n pd=0.18m as=1.925n ps=0.18m w=55 l=15
X536 control_logic_rw_0.dff_buf_array_0.dff_buf_0_0.dff_0.net3 control_logic_rw_0.dff_buf_array_0.dff_buf_0_0.dff_0.net1 din0[1] din0[1] sky130_fd_pr__nfet_01v8 ad=2.604n pd=0.208m as=1.68n ps=0.122m w=42 l=15
X537 din0[1] bank_0.replica_bitcell_array_0.dummy_array_2_0.dummy_cell_1rw_0.q bank_0.replica_bitcell_array_0.dummy_array_2_0.dummy_cell_1rw_0.qb din0[1] sky130_fd_pr__pfet_01v8 ad=1.925n pd=0.18m as=1.925n ps=0.18m w=55 l=15
X538 bank_0.replica_bitcell_array_0.bitcell_array_0.cell_1rw_27.q bank_0.replica_bitcell_array_0.wl_0_4 din0[1] din0[1] sky130_fd_pr__nfet_01v8 ad=3.864n pd=0.21m as=1.428n ps=0.152m w=42 l=15
X539 a_1449_4993# din0[1] a_1395_4993# w_1141_4697# sky130_fd_pr__pfet_01v8 ad=1.848n pd=0.128m as=3.276n ps=0.246m w=84 l=15
X540 a_n1118_n227# control_logic_rw_0.dff_buf_array_0.dout_bar_0 a_n1196_n227# din0[1] sky130_fd_pr__nfet_01v8 ad=2.128n pd=0.188m as=1.764n ps=0.119m w=56 l=15
X541 a_n5369_9861# control_logic_rw_0.delay_chain_0.out a_n5422_9861# w_n5644_9540# sky130_fd_pr__pfet_01v8 ad=3.276n pd=0.246m as=3.192n ps=0.244m w=84 l=15
X542 bank_0.replica_bitcell_array_0.dummy_array_3_0.dummy_cell_1rw_6.q bank_0.replica_bitcell_array_0.wl_0_10 a_5461_8601# din0[1] sky130_fd_pr__nfet_01v8 ad=3.864n pd=0.21m as=1.428n ps=0.152m w=42 l=15
X543 bank_0.replica_bitcell_array_0.replica_column_0.replica_cell_1rw_10.q din0[1] din0[1] din0[1] sky130_fd_pr__nfet_01v8 ad=3.864n pd=0.21m as=4.41n ps=0.322m w=126 l=15
X544 control_logic_rw_0.dff_buf_array_0.dff_buf_0_1.dff_0.net5 din0[1] control_logic_rw_0.dff_buf_array_0.dff_buf_0_1.dff_0.net4 din0[1] sky130_fd_pr__pfet_01v8 ad=4.345n pd=0.268m as=2.915n ps=0.161m w=55 l=15
X545 a_2789_11463# bank_0.port_address_0.hierarchical_decoder_0.predecode_7 bank_0.port_address_0.hierarchical_decoder_0.and2_dec_0.pnand2_0.nmos_m1_w0_840_sactive_dli_0.S din0[1] sky130_fd_pr__nfet_01v8 ad=3.192n pd=0.244m as=1.848n ps=0.128m w=84 l=15
X546 a_2789_9937# bank_0.port_address_0.hierarchical_decoder_0.predecode_7 a_2730_9937# w_2422_9787# sky130_fd_pr__pfet_01v8 ad=3.192n pd=0.244m as=1.848n ps=0.128m w=84 l=15
X547 a_1508_6883# bank_0.port_address_0.hierarchical_decoder_0.hierarchical_predecode2x4_0.pinv_0.Z a_1449_6883# w_1141_6733# sky130_fd_pr__pfet_01v8 ad=3.192n pd=0.244m as=1.848n ps=0.128m w=84 l=15
X548 a_2730_6011# bank_0.port_address_0.hierarchical_decoder_0.predecode_1 a_2676_6011# w_2422_5715# sky130_fd_pr__pfet_01v8 ad=1.848n pd=0.128m as=3.276n ps=0.246m w=84 l=15
X549 din0[1] bank_0.replica_bitcell_array_0.bitcell_array_0.cell_1rw_15.q bank_0.replica_bitcell_array_0.bitcell_array_0.cell_1rw_15.qb din0[1] sky130_fd_pr__nfet_01v8 ad=4.41n pd=0.322m as=3.864n ps=0.21m w=126 l=15
X550 din0[1] bank_0.replica_bitcell_array_0.dummy_array_3_0.dummy_cell_1rw_0.q bank_0.replica_bitcell_array_0.dummy_array_3_0.dummy_cell_1rw_0.qb din0[1] sky130_fd_pr__pfet_01v8 ad=1.925n pd=0.18m as=1.925n ps=0.18m w=55 l=15
X551 bank_0.replica_bitcell_array_0.dummy_array_2_0.dummy_cell_1rw_3.q bank_0.replica_bitcell_array_0.dummy_array_2_0.dummy_cell_1rw_3.qb din0[1] din0[1] sky130_fd_pr__nfet_01v8 ad=3.864n pd=0.21m as=4.41n ps=0.322m w=126 l=15
X552 din0[1] bank_0.replica_bitcell_array_0.replica_column_0.replica_cell_1rw_14.q din0[1] din0[1] sky130_fd_pr__pfet_01v8 ad=1.925n pd=0.18m as=0 ps=0 w=55 l=15
X553 bank_0.replica_bitcell_array_0.bitcell_array_0.cell_1rw_15.q bank_0.replica_bitcell_array_0.bitcell_array_0.cell_1rw_15.qb din0[1] din0[1] sky130_fd_pr__pfet_01v8 ad=1.925n pd=0.18m as=1.925n ps=0.18m w=55 l=15
X554 a_n5369_2449# control_logic_rw_0.delay_chain_0.pinv_11_44.Z a_n5422_2449# din0[1] sky130_fd_pr__nfet_01v8 ad=1.638n pd=0.162m as=1.596n ps=0.16m w=42 l=15
X555 bank_0.port_address_0.and2_dec_0_0.pnand2_0.nmos_m1_w0_840_sactive_dli_0.S control_logic_rw_0.wl_en a_3370_3319# din0[1] sky130_fd_pr__nfet_01v8 ad=1.848n pd=0.128m as=3.276n ps=0.246m w=84 l=15
X556 bank_0.replica_bitcell_array_0.replica_column_0.replica_cell_1rw_5.q bank_0.replica_bitcell_array_0.wl_0_10 din0[1] din0[1] sky130_fd_pr__nfet_01v8 ad=3.864n pd=0.21m as=1.428n ps=0.152m w=42 l=15
X557 din0[1] bank_0.replica_bitcell_array_0.bitcell_array_0.cell_1rw_22.q bank_0.replica_bitcell_array_0.bitcell_array_0.cell_1rw_22.qb din0[1] sky130_fd_pr__pfet_01v8 ad=1.925n pd=0.18m as=1.925n ps=0.18m w=55 l=15
X558 din0[1] bank_0.replica_bitcell_array_0.bitcell_array_0.cell_1rw_29.q bank_0.replica_bitcell_array_0.bitcell_array_0.cell_1rw_29.qb din0[1] sky130_fd_pr__pfet_01v8 ad=1.925n pd=0.18m as=1.925n ps=0.18m w=55 l=15
X559 a_1822_7029# din0[1] a_1768_7029# w_1141_6733# sky130_fd_pr__pfet_01v8 ad=3.192n pd=0.244m as=3.276n ps=0.246m w=84 l=15
X560 din0[1] bank_0.replica_bitcell_array_0.dummy_array_2_0.dummy_cell_1rw_16.q bank_0.replica_bitcell_array_0.dummy_array_2_0.dummy_cell_1rw_16.qb din0[1] sky130_fd_pr__nfet_01v8 ad=4.41n pd=0.322m as=3.864n ps=0.21m w=126 l=15
X561 din0[1] bank_0.replica_bitcell_array_0.bitcell_array_0.cell_1rw_25.q bank_0.replica_bitcell_array_0.bitcell_array_0.cell_1rw_25.qb din0[1] sky130_fd_pr__nfet_01v8 ad=4.41n pd=0.322m as=3.864n ps=0.21m w=126 l=15
X562 din0[1] bank_0.replica_bitcell_array_0.bitcell_array_0.cell_1rw_30.q bank_0.replica_bitcell_array_0.bitcell_array_0.cell_1rw_30.qb din0[1] sky130_fd_pr__nfet_01v8 ad=4.41n pd=0.322m as=3.864n ps=0.21m w=126 l=15
X563 bank_0.replica_bitcell_array_0.dummy_array_2_0.dummy_cell_1rw_16.q bank_0.replica_bitcell_array_0.dummy_array_2_0.dummy_cell_1rw_16.qb din0[1] din0[1] sky130_fd_pr__pfet_01v8 ad=1.925n pd=0.18m as=1.925n ps=0.18m w=55 l=15
X564 a_n1529_705# control_logic_rw_0.dff_buf_array_0.dout_bar_0 a_n1607_705# din0[1] sky130_fd_pr__nfet_01v8 ad=2.28n pd=0.196m as=1.89n ps=0.123m w=60 l=15
X565 din0[1] bank_0.replica_bitcell_array_0.dummy_array_3_0.dummy_cell_1rw_4.q bank_0.replica_bitcell_array_0.dummy_array_3_0.dummy_cell_1rw_4.qb din0[1] sky130_fd_pr__pfet_01v8 ad=1.925n pd=0.18m as=1.925n ps=0.18m w=55 l=15
X566 control_logic_rw_0.dff_buf_array_0.dff_buf_0_1.dff_0.net5 control_logic_rw_0.dff_buf_array_0.dff_buf_0_1.dff_0.clkb control_logic_rw_0.dff_buf_array_0.dff_buf_0_1.dff_0.net4 din0[1] sky130_fd_pr__nfet_01v8 ad=3.318n pd=0.242m as=2.226n ps=0.148m w=42 l=15
X567 bank_0.port_data_0.write_driver_array_0.write_driver_0.net5 din0[1] din0[1] din0[1] sky130_fd_pr__pfet_01v8 ad=2.75n pd=0.21m as=2.722n ps=0.154m w=55 l=15
X568 bank_0.replica_bitcell_array_0.dummy_array_3_0.dummy_cell_1rw_1.q bank_0.replica_bitcell_array_0.dummy_array_3_0.dummy_cell_1rw_1.qb din0[1] din0[1] sky130_fd_pr__nfet_01v8 ad=3.864n pd=0.21m as=4.41n ps=0.322m w=126 l=15
X569 bank_0.replica_bitcell_array_0.bitcell_array_0.cell_1rw_1.qb bank_0.replica_bitcell_array_0.wl_0_14 din0[1] din0[1] sky130_fd_pr__nfet_01v8 ad=3.864n pd=0.21m as=1.428n ps=0.152m w=42 l=15
X570 din0[1] bank_0.replica_bitcell_array_0.dummy_array_3_0.dummy_cell_1rw_5.q bank_0.replica_bitcell_array_0.dummy_array_3_0.dummy_cell_1rw_5.qb din0[1] sky130_fd_pr__nfet_01v8 ad=4.41n pd=0.322m as=3.864n ps=0.21m w=126 l=15
X571 din0[1] bank_0.replica_bitcell_array_0.wl_0_5 bank_0.replica_bitcell_array_0.bitcell_array_0.cell_1rw_10.q din0[1] sky130_fd_pr__nfet_01v8 ad=1.428n pd=0.152m as=3.864n ps=0.21m w=42 l=15
X572 a_5461_3325# bank_0.replica_bitcell_array_0.rbl_wl_0_0 bank_0.replica_bitcell_array_0.dummy_array_3_0.dummy_cell_1rw_17.q din0[1] sky130_fd_pr__nfet_01v8 ad=1.428n pd=0.152m as=3.864n ps=0.21m w=42 l=15
X573 din0[1] bank_0.replica_bitcell_array_0.replica_column_0.replica_cell_1rw_3.q din0[1] din0[1] sky130_fd_pr__pfet_01v8 ad=1.925n pd=0.18m as=0 ps=0 w=55 l=15
X574 bank_0.port_address_0.wordline_driver_array_0.wordline_driver_10.pnand2_0.nmos_m1_w0_840_sactive_dli_0.S bank_0.port_address_0.wordline_driver_array_0.in_5 a_3370_6373# din0[1] sky130_fd_pr__nfet_01v8 ad=1.848n pd=0.128m as=3.276n ps=0.246m w=84 l=15
X575 a_n1586_n513# control_logic_rw_0.dff_buf_array_0.dout_bar_0 a_n1664_n513# w_n2769_n767# sky130_fd_pr__pfet_01v8 ad=3.528n pd=0.175m as=3.528n ps=0.175m w=112 l=15
X576 din0[1] din0[1] bank_0.port_data_0.write_driver_array_0.write_driver_0.net5 din0[1] sky130_fd_pr__pfet_01v8 ad=1.65n pd=0.115m as=2.75n ps=0.21m w=55 l=15
X577 a_n4741_8329# control_logic_rw_0.delay_chain_0.pinv_11_9.Z a_n4794_8329# w_n5644_7860# sky130_fd_pr__pfet_01v8 ad=3.276n pd=0.246m as=3.192n ps=0.244m w=84 l=15
X578 a_4421_6379# bank_0.replica_bitcell_array_0.wl_0_5 bank_0.replica_bitcell_array_0.dummy_array_2_0.dummy_cell_1rw_11.q din0[1] sky130_fd_pr__nfet_01v8 ad=1.428n pd=0.152m as=3.864n ps=0.21m w=42 l=15
X579 din0[1] bank_0.replica_bitcell_array_0.rbl_wl_0_0 bank_0.replica_bitcell_array_0.replica_column_0.replica_cell_1rw_16.q din0[1] sky130_fd_pr__nfet_01v8 ad=1.428n pd=0.152m as=3.864n ps=0.21m w=42 l=15
X580 din0[1] bank_0.replica_bitcell_array_0.bitcell_array_0.cell_1rw_1.q bank_0.replica_bitcell_array_0.bitcell_array_0.cell_1rw_1.qb din0[1] sky130_fd_pr__nfet_01v8 ad=4.41n pd=0.322m as=3.864n ps=0.21m w=126 l=15
X581 bank_0.replica_bitcell_array_0.bitcell_array_0.cell_1rw_10.q bank_0.replica_bitcell_array_0.bitcell_array_0.cell_1rw_10.qb din0[1] din0[1] sky130_fd_pr__pfet_01v8 ad=1.925n pd=0.18m as=1.925n ps=0.18m w=55 l=15
X582 a_n2330_1957# control_logic_rw_0.pand3_0_0.pnand3_0_0.nmos_m1_w0_840_sactive_dli_0.G a_n2402_1923# w_n2769_1669# sky130_fd_pr__pfet_01v8 ad=0.544n pd=98u as=1.848n ps=0.128m w=38 l=28
X583 bank_0.replica_bitcell_array_0.dummy_array_0_0.dummy_cell_1rw_1.q bank_0.replica_bitcell_array_0.dummy_array_0_0.dummy_cell_1rw_1.qb din0[1] din0[1] sky130_fd_pr__pfet_01v8 ad=1.925n pd=0.18m as=1.925n ps=0.18m w=55 l=15
X584 bank_0.replica_bitcell_array_0.replica_column_0.dummy_cell_1rw_0.q bank_0.replica_bitcell_array_0.replica_column_0.dummy_cell_1rw_0.qb din0[1] din0[1] sky130_fd_pr__nfet_01v8 ad=3.864n pd=0.21m as=4.41n ps=0.322m w=126 l=15
X585 row_addr_dff_0.dff_2.net2 row_addr_dff_0.dff_2.clkb row_addr_dff_0.dff_2.net1 din0[1] sky130_fd_pr__pfet_01v8 ad=3.74n pd=0.246m as=2.915n ps=0.161m w=55 l=15
X586 a_n4427_4129# control_logic_rw_0.delay_chain_0.pinv_11_34.Z a_n4480_4129# din0[1] sky130_fd_pr__nfet_01v8 ad=1.638n pd=0.162m as=1.596n ps=0.16m w=42 l=15
X587 a_2789_3467# bank_0.port_address_0.hierarchical_decoder_0.predecode_4 bank_0.port_address_0.hierarchical_decoder_0.and2_dec_15.pnand2_0.nmos_m1_w0_840_sactive_dli_0.S din0[1] sky130_fd_pr__nfet_01v8 ad=3.192n pd=0.244m as=1.848n ps=0.128m w=84 l=15
X588 din0[1] control_logic_rw_0.dff_buf_array_0.dff_buf_0_0.dff_0.net3 control_logic_rw_0.dff_buf_array_0.dff_buf_0_0.dff_0.net2 din0[1] sky130_fd_pr__nfet_01v8 ad=1.68n pd=0.122m as=2.226n ps=0.19m w=42 l=15
X589 bank_0.replica_bitcell_array_0.dummy_array_0_0.dummy_cell_1rw_1.qb din0[1] a_5010_11655# din0[1] sky130_fd_pr__nfet_01v8 ad=3.864n pd=0.21m as=1.428n ps=0.152m w=42 l=15
X590 bank_0.replica_bitcell_array_0.dummy_array_2_0.dummy_cell_1rw_11.q bank_0.replica_bitcell_array_0.dummy_array_2_0.dummy_cell_1rw_11.qb din0[1] din0[1] sky130_fd_pr__pfet_01v8 ad=1.925n pd=0.18m as=1.925n ps=0.18m w=55 l=15
X591 row_addr_dff_0.dff_1.net3 row_addr_dff_0.dff_1.net1 din0[1] din0[1] sky130_fd_pr__pfet_01v8 ad=3.465n pd=0.236m as=2.2n ps=0.135m w=55 l=15
X592 bank_0.replica_bitcell_array_0.bitcell_array_0.cell_1rw_23.q bank_0.replica_bitcell_array_0.bitcell_array_0.cell_1rw_23.qb din0[1] din0[1] sky130_fd_pr__nfet_01v8 ad=3.864n pd=0.21m as=4.41n ps=0.322m w=126 l=15
X593 bank_0.replica_bitcell_array_0.bitcell_array_0.cell_1rw_28.q bank_0.replica_bitcell_array_0.bitcell_array_0.cell_1rw_28.qb din0[1] din0[1] sky130_fd_pr__nfet_01v8 ad=3.864n pd=0.21m as=4.41n ps=0.322m w=126 l=15
X594 a_n2461_n919# clk0 a_n2515_n919# din0[1] sky130_fd_pr__nfet_01v8 ad=1.596n pd=0.16m as=1.638n ps=0.162m w=42 l=15
X595 a_n2402_963# control_logic_rw_0.pand3_0.B a_n2461_963# w_n2769_857# sky130_fd_pr__pfet_01v8 ad=1.848n pd=0.128m as=1.848n ps=0.128m w=84 l=15
X596 a_n2461_n513# din0[1] a_n2515_n513# w_n2769_n767# sky130_fd_pr__pfet_01v8 ad=3.192n pd=0.244m as=3.276n ps=0.246m w=84 l=15
X597 a_2789_9427# bank_0.port_address_0.hierarchical_decoder_0.predecode_6 bank_0.port_address_0.hierarchical_decoder_0.and2_dec_4.pnand2_0.nmos_m1_w0_840_sactive_dli_0.S din0[1] sky130_fd_pr__nfet_01v8 ad=3.192n pd=0.244m as=1.848n ps=0.128m w=84 l=15
X598 data_dff_0.dff_1.net2 data_dff_0.dff_1.clkb data_dff_0.dff_1.net1 din0[1] sky130_fd_pr__pfet_01v8 ad=3.74n pd=0.246m as=2.915n ps=0.161m w=55 l=15
X599 a_n2147_299# control_logic_rw_0.pdriver_1_0.pinv_8_0.A a_n2201_299# w_n2769_44# sky130_fd_pr__pfet_01v8 ad=3.192n pd=0.244m as=3.276n ps=0.246m w=84 l=15
X600 a_n1221_589# control_logic_rw_0.pdriver_1_0.pinv_6_0.A a_n1299_589# din0[1] sky130_fd_pr__nfet_01v8 ad=1.638n pd=0.115m as=1.638n ps=0.115m w=52 l=15
X601 din0[1] bank_0.replica_bitcell_array_0.bitcell_array_0.cell_1rw_16.q bank_0.replica_bitcell_array_0.bitcell_array_0.cell_1rw_16.qb din0[1] sky130_fd_pr__nfet_01v8 ad=4.41n pd=0.322m as=3.864n ps=0.21m w=126 l=15
X602 a_2730_8047# bank_0.port_address_0.hierarchical_decoder_0.predecode_1 a_2676_8047# w_2422_7751# sky130_fd_pr__pfet_01v8 ad=1.848n pd=0.128m as=3.276n ps=0.246m w=84 l=15
X603 din0[1] bank_0.replica_bitcell_array_0.wl_0_15 bank_0.replica_bitcell_array_0.bitcell_array_0.cell_1rw_16.q din0[1] sky130_fd_pr__nfet_01v8 ad=1.428n pd=0.152m as=3.864n ps=0.21m w=42 l=15
X604 a_3483_5503# control_logic_rw_0.wl_en bank_0.port_address_0.wordline_driver_array_0.wordline_driver_11.pnand2_0.nmos_m1_w0_840_sactive_dli_0.S din0[1] sky130_fd_pr__nfet_01v8 ad=3.192n pd=0.244m as=1.848n ps=0.128m w=84 l=15
X605 bank_0.replica_bitcell_array_0.bitcell_array_0.cell_1rw_11.q bank_0.replica_bitcell_array_0.bitcell_array_0.cell_1rw_11.qb din0[1] din0[1] sky130_fd_pr__nfet_01v8 ad=3.864n pd=0.21m as=4.41n ps=0.322m w=126 l=15
X606 a_2730_3829# bank_0.port_address_0.hierarchical_decoder_0.predecode_0 a_2676_3829# w_2422_3679# sky130_fd_pr__pfet_01v8 ad=1.848n pd=0.128m as=3.276n ps=0.246m w=84 l=15
X607 bank_0.port_address_0.hierarchical_decoder_0.hierarchical_predecode2x4_1.and2_dec_3.pnand2_0.nmos_m1_w0_840_sactive_dli_0.S bank_0.port_address_0.hierarchical_decoder_0.hierarchical_predecode2x4_1.pinv_1.Z a_1395_3467# din0[1] sky130_fd_pr__nfet_01v8 ad=1.848n pd=0.128m as=3.276n ps=0.246m w=84 l=15
X608 din0[1] bank_0.replica_bitcell_array_0.dummy_array_3_0.dummy_cell_1rw_18.q bank_0.replica_bitcell_array_0.dummy_array_3_0.dummy_cell_1rw_18.qb din0[1] sky130_fd_pr__nfet_01v8 ad=4.41n pd=0.322m as=3.864n ps=0.21m w=126 l=15
X609 bank_0.replica_bitcell_array_0.dummy_array_0.dummy_cell_1rw_0.q bank_0.replica_bitcell_array_0.dummy_array_0.dummy_cell_1rw_0.qb din0[1] din0[1] sky130_fd_pr__nfet_01v8 ad=3.864n pd=0.21m as=4.41n ps=0.322m w=126 l=15
X610 a_n1664_n227# control_logic_rw_0.dff_buf_array_0.dout_bar_0 a_n1742_n227# din0[1] sky130_fd_pr__nfet_01v8 ad=1.764n pd=0.119m as=1.764n ps=0.119m w=56 l=15
X611 bank_0.replica_bitcell_array_0.bitcell_array_0.cell_1rw_23.qb bank_0.replica_bitcell_array_0.wl_0_8 din0[1] din0[1] sky130_fd_pr__nfet_01v8 ad=3.864n pd=0.21m as=1.428n ps=0.152m w=42 l=15
X612 a_n5369_6649# control_logic_rw_0.delay_chain_0.pinv_11_19.Z a_n5422_6649# w_n5644_6180# sky130_fd_pr__pfet_01v8 ad=3.276n pd=0.246m as=3.192n ps=0.244m w=84 l=15
X613 din0[1] data_dff_0.dff_0.net3 data_dff_0.dff_0.net2 din0[1] sky130_fd_pr__pfet_01v8 ad=2.2n pd=0.135m as=2.915n ps=0.216m w=55 l=15
X614 a_n3525_n227# control_logic_rw_0.dff_buf_array_0.dout_bar_0 a_n3579_n227# din0[1] sky130_fd_pr__nfet_01v8 ad=1.764n pd=0.119m as=2.184n ps=0.19m w=56 l=15
X615 a_2730_11101# bank_0.port_address_0.hierarchical_decoder_0.predecode_3 a_2676_11101# w_2422_10805# sky130_fd_pr__pfet_01v8 ad=1.848n pd=0.128m as=3.276n ps=0.246m w=84 l=15
X616 bank_0.replica_bitcell_array_0.dummy_array_2_0.dummy_cell_1rw_12.q bank_0.replica_bitcell_array_0.dummy_array_2_0.dummy_cell_1rw_12.qb din0[1] din0[1] sky130_fd_pr__nfet_01v8 ad=3.864n pd=0.21m as=4.41n ps=0.322m w=126 l=15
X617 bank_0.replica_bitcell_array_0.dummy_array_2_0.dummy_cell_1rw_17.q bank_0.replica_bitcell_array_0.dummy_array_2_0.dummy_cell_1rw_17.qb din0[1] din0[1] sky130_fd_pr__nfet_01v8 ad=3.864n pd=0.21m as=4.41n ps=0.322m w=126 l=15
X618 din0[1] bank_0.replica_bitcell_array_0.replica_column_0.replica_cell_1rw_10.q din0[1] din0[1] sky130_fd_pr__nfet_01v8 ad=3.864n pd=0.21m as=0 ps=0 w=126 l=15
X619 data_dff_0.dff_1.net2 din0[1] data_dff_0.dff_1.net1 din0[1] sky130_fd_pr__nfet_01v8 ad=2.856n pd=0.22m as=2.226n ps=0.148m w=42 l=15
X620 bank_0.port_address_0.hierarchical_decoder_0.and2_dec_3.pnand2_0.nmos_m1_w0_840_sactive_dli_0.S bank_0.port_address_0.hierarchical_decoder_0.predecode_0 a_2676_9575# din0[1] sky130_fd_pr__nfet_01v8 ad=1.848n pd=0.128m as=3.276n ps=0.246m w=84 l=15
X621 a_n1900_n107# control_logic_rw_0.dff_buf_array_0.dout_bar_0 a_n1978_n107# din0[1] sky130_fd_pr__nfet_01v8 ad=1.764n pd=0.119m as=1.764n ps=0.119m w=56 l=15
X622 a_2730_6883# bank_0.port_address_0.hierarchical_decoder_0.predecode_2 a_2676_6883# w_2422_6733# sky130_fd_pr__pfet_01v8 ad=1.848n pd=0.128m as=3.276n ps=0.246m w=84 l=15
X623 row_addr_dff_0.dff_0.net5 row_addr_dff_0.dff_3.clk row_addr_dff_0.dff_0.net4 din0[1] sky130_fd_pr__pfet_01v8 ad=4.345n pd=0.268m as=2.915n ps=0.161m w=55 l=15
X624 a_3103_6415# din0[1] a_3049_6415# din0[1] sky130_fd_pr__nfet_01v8 ad=1.596n pd=0.16m as=1.638n ps=0.162m w=42 l=15
X625 a_5461_5361# bank_0.replica_bitcell_array_0.wl_0_3 bank_0.replica_bitcell_array_0.dummy_array_3_0.dummy_cell_1rw_13.q din0[1] sky130_fd_pr__nfet_01v8 ad=1.428n pd=0.152m as=3.864n ps=0.21m w=42 l=15
X626 din0[1] data_dff_0.dff_0.net3 data_dff_0.dff_0.net2 din0[1] sky130_fd_pr__nfet_01v8 ad=1.68n pd=0.122m as=2.226n ps=0.19m w=42 l=15
X627 a_n1510_123# control_logic_rw_0.dff_buf_array_0.dout_bar_0 a_n1588_123# w_n2769_44# sky130_fd_pr__pfet_01v8 ad=3.528n pd=0.175m as=3.528n ps=0.175m w=112 l=15
X628 a_3103_11101# din0[1] a_3049_11101# w_2422_10805# sky130_fd_pr__pfet_01v8 ad=3.192n pd=0.244m as=3.276n ps=0.246m w=84 l=15
X629 a_n5369_9169# control_logic_rw_0.delay_chain_0.out a_n5422_9169# din0[1] sky130_fd_pr__nfet_01v8 ad=1.638n pd=0.162m as=1.596n ps=0.16m w=42 l=15
X630 bank_0.replica_bitcell_array_0.bitcell_array_0.cell_1rw_16.q bank_0.replica_bitcell_array_0.bitcell_array_0.cell_1rw_16.qb din0[1] din0[1] sky130_fd_pr__nfet_01v8 ad=3.864n pd=0.21m as=4.41n ps=0.322m w=126 l=15
X631 din0[1] bank_0.replica_bitcell_array_0.wl_0_14 din0[1] din0[1] sky130_fd_pr__nfet_01v8 ad=3.864n pd=0.21m as=0 ps=0 w=42 l=15
X632 din0[1] bank_0.replica_bitcell_array_0.wl_0_3 bank_0.replica_bitcell_array_0.replica_column_0.replica_cell_1rw_12.q din0[1] sky130_fd_pr__nfet_01v8 ad=1.428n pd=0.152m as=3.864n ps=0.21m w=42 l=15
X633 a_n1919_705# control_logic_rw_0.dff_buf_array_0.dout_bar_0 a_n1997_705# din0[1] sky130_fd_pr__nfet_01v8 ad=1.89n pd=0.123m as=1.89n ps=0.123m w=60 l=15
X634 control_logic_rw_0.dff_buf_array_0.dff_buf_0_0.dff_0.net2 control_logic_rw_0.dff_buf_array_0.dff_buf_0_0.dff_0.clkb control_logic_rw_0.dff_buf_array_0.dff_buf_0_0.dff_0.net1 din0[1] sky130_fd_pr__pfet_01v8 ad=3.74n pd=0.246m as=2.915n ps=0.161m w=55 l=15
X635 din0[1] bank_0.replica_bitcell_array_0.bitcell_array_0.cell_1rw_2.q bank_0.replica_bitcell_array_0.bitcell_array_0.cell_1rw_2.qb din0[1] sky130_fd_pr__nfet_01v8 ad=4.41n pd=0.322m as=3.864n ps=0.21m w=126 l=15
X636 a_739_3467# din0[1] a_685_3467# din0[1] sky130_fd_pr__nfet_01v8 ad=1.596n pd=0.16m as=1.638n ps=0.162m w=42 l=15
X637 a_n3917_n213# control_logic_rw_0.dff_buf_array_0.dff_buf_0_0.pinv_0_0.A a_n3971_n213# din0[1] sky130_fd_pr__nfet_01v8 ad=1.323n pd=0.105m as=1.638n ps=0.162m w=42 l=15
X638 din0[1] din0[1] din0[1] din0[1] sky130_fd_pr__nfet_01v8 ad=1.678n pd=0.148m as=0 ps=0 w=100 l=15
X639 a_n4427_8329# control_logic_rw_0.delay_chain_0.pinv_11_9.Z a_n4480_8329# w_n5644_7860# sky130_fd_pr__pfet_01v8 ad=3.276n pd=0.246m as=3.192n ps=0.244m w=84 l=15
X640 a_3797_7901# din0[1] a_3743_7901# w_2422_7751# sky130_fd_pr__pfet_01v8 ad=3.192n pd=0.244m as=3.276n ps=0.246m w=84 l=15
X641 din0[1] din0[1] din0[1] din0[1] sky130_fd_pr__nfet_01v8 ad=2.604n pd=0.158m as=0 ps=0 w=84 l=15
X642 a_n1065_n919# control_logic_rw_0.pdriver_0_0.pinv_7_0.A a_n1143_n919# din0[1] sky130_fd_pr__nfet_01v8 ad=1.795n pd=0.12m as=1.795n ps=0.12m w=57 l=15
X643 din0[1] bank_0.replica_bitcell_array_0.replica_column_0.replica_cell_1rw_1.q din0[1] din0[1] sky130_fd_pr__nfet_01v8 ad=3.864n pd=0.21m as=0 ps=0 w=126 l=15
X644 row_addr_dff_0.dff_3.net3 row_addr_dff_0.dff_3.net1 din0[1] din0[1] sky130_fd_pr__pfet_01v8 ad=3.465n pd=0.236m as=2.2n ps=0.135m w=55 l=15
X645 din0[1] din0[1] din0[1] din0[1] sky130_fd_pr__pfet_01v8 ad=1.65n pd=0.115m as=0 ps=0 w=55 l=15
X646 a_n4741_8181# control_logic_rw_0.delay_chain_0.pinv_11_14.Z a_n4794_8181# w_n5644_7860# sky130_fd_pr__pfet_01v8 ad=3.276n pd=0.246m as=3.192n ps=0.244m w=84 l=15
X647 a_n1645_n681# control_logic_rw_0.pdriver_0_0.pinv_6_0.A a_n1723_n681# w_n2769_n767# sky130_fd_pr__pfet_01v8 ad=3.307n pd=0.168m as=3.307n ps=0.168m w=105 l=15
X648 a_n3839_n919# control_logic_rw_0.dff_buf_array_0.dff_buf_0_1.pinv_0_0.A a_n3917_n919# din0[1] sky130_fd_pr__nfet_01v8 ad=1.596n pd=0.16m as=1.323n ps=0.105m w=42 l=15
X649 a_n1723_n919# control_logic_rw_0.pdriver_0_0.pinv_6_0.A a_n1777_n919# din0[1] sky130_fd_pr__nfet_01v8 ad=1.638n pd=0.115m as=2.028n ps=0.182m w=52 l=15
X650 a_n4741_4969# control_logic_rw_0.delay_chain_0.pinv_11_29.Z a_n4794_4969# w_n5644_4500# sky130_fd_pr__pfet_01v8 ad=3.276n pd=0.246m as=3.192n ps=0.244m w=84 l=15
X651 a_n3839_n513# control_logic_rw_0.dff_buf_array_0.dff_buf_0_0.pinv_0_0.A a_n3917_n513# w_n4225_n767# sky130_fd_pr__pfet_01v8 ad=3.192n pd=0.244m as=2.646n ps=0.147m w=84 l=15
X652 control_logic_rw_0.dff_buf_array_0.dff_buf_0_0.dff_0.net1 control_logic_rw_0.dff_buf_array_0.dff_buf_0_0.dff_0.clkb web0 din0[1] sky130_fd_pr__nfet_01v8 ad=2.226n pd=0.148m as=1.932n ps=0.176m w=42 l=15
X653 a_n1774_1111# control_logic_rw_0.pdriver_4_0.pinv_8_0.A a_n1828_1111# w_n2769_857# sky130_fd_pr__pfet_01v8 ad=3.192n pd=0.244m as=3.276n ps=0.246m w=84 l=15
X654 a_3424_2957# control_logic_rw_0.wl_en a_3370_2957# w_3116_2703# sky130_fd_pr__pfet_01v8 ad=1.848n pd=0.128m as=3.276n ps=0.246m w=84 l=15
X655 bank_0.replica_bitcell_array_0.dummy_array_3_0.dummy_cell_1rw_0.qb din0[1] a_5530_11655# din0[1] sky130_fd_pr__nfet_01v8 ad=3.864n pd=0.21m as=1.428n ps=0.152m w=42 l=15
X656 a_n2147_n919# control_logic_rw_0.pdriver_0_0.pinv_4_0.A a_n2201_n919# din0[1] sky130_fd_pr__nfet_01v8 ad=1.323n pd=0.105m as=1.638n ps=0.162m w=42 l=15
X657 bank_0.replica_bitcell_array_0.dummy_array_3_0.dummy_cell_1rw_16.qb bank_0.replica_bitcell_array_0.wl_0_0 a_5530_3511# din0[1] sky130_fd_pr__nfet_01v8 ad=3.864n pd=0.21m as=1.428n ps=0.152m w=42 l=15
X658 a_3483_9065# control_logic_rw_0.wl_en a_3424_9065# w_2422_8769# sky130_fd_pr__pfet_01v8 ad=3.192n pd=0.244m as=1.848n ps=0.128m w=84 l=15
X659 a_3483_7539# control_logic_rw_0.wl_en bank_0.port_address_0.wordline_driver_array_0.wordline_driver_7.pnand2_0.nmos_m1_w0_840_sactive_dli_0.S din0[1] sky130_fd_pr__nfet_01v8 ad=3.192n pd=0.244m as=1.848n ps=0.128m w=84 l=15
X660 bank_0.replica_bitcell_array_0.bitcell_array_0.cell_1rw_7.q bank_0.replica_bitcell_array_0.bitcell_array_0.cell_1rw_7.qb din0[1] din0[1] sky130_fd_pr__nfet_01v8 ad=3.864n pd=0.21m as=4.41n ps=0.322m w=126 l=15
X661 a_3103_6521# din0[1] a_3049_6521# din0[1] sky130_fd_pr__nfet_01v8 ad=1.596n pd=0.16m as=1.638n ps=0.162m w=42 l=15
X662 bank_0.replica_bitcell_array_0.bitcell_array_0.cell_1rw_12.q bank_0.replica_bitcell_array_0.bitcell_array_0.cell_1rw_12.qb din0[1] din0[1] sky130_fd_pr__nfet_01v8 ad=3.864n pd=0.21m as=4.41n ps=0.322m w=126 l=15
X663 a_n2147_n513# control_logic_rw_0.pinv_3_1.Z a_n2201_n513# w_n2769_n767# sky130_fd_pr__pfet_01v8 ad=1.33n pd=0.135m as=3.276n ps=0.246m w=84 l=15
X664 a_n2402_1369# control_logic_rw_0.pnand2_1_0.nmos_m1_w0_840_sactive_dli_0.G control_logic_rw_0.pnand2_1_0.nmos_m1_w0_840_sactive_dli_0.S din0[1] sky130_fd_pr__nfet_01v8 ad=3.192n pd=0.244m as=1.848n ps=0.128m w=84 l=15
X665 din0[1] row_addr_dff_0.dout_2 row_addr_dff_0.dff_1.net5 din0[1] sky130_fd_pr__pfet_01v8 ad=2.2n pd=0.135m as=3.08n ps=0.222m w=55 l=15
X666 a_3483_4847# control_logic_rw_0.wl_en a_3424_4847# w_2422_4697# sky130_fd_pr__pfet_01v8 ad=3.192n pd=0.244m as=1.848n ps=0.128m w=84 l=15
X667 a_n4113_4023# control_logic_rw_0.delay_chain_0.pinv_11_44.Z a_n4166_4023# din0[1] sky130_fd_pr__nfet_01v8 ad=1.638n pd=0.162m as=1.596n ps=0.16m w=42 l=15
X668 din0[1] din0[1] din0[1] din0[1] sky130_fd_pr__pfet_01v8 ad=2.302n pd=0.147m as=0 ps=0 w=25 l=3
X669 din0[1] row_addr_dff_0.dff_0.net3 row_addr_dff_0.dff_0.net2 din0[1] sky130_fd_pr__pfet_01v8 ad=2.2n pd=0.135m as=2.915n ps=0.216m w=55 l=15
X670 bank_0.replica_bitcell_array_0.bitcell_array_0.cell_1rw_23.q bank_0.replica_bitcell_array_0.bitcell_array_0.cell_1rw_23.qb din0[1] din0[1] sky130_fd_pr__pfet_01v8 ad=1.925n pd=0.18m as=1.925n ps=0.18m w=55 l=15
X671 din0[1] bank_0.replica_bitcell_array_0.wl_0_0 din0[1] din0[1] sky130_fd_pr__nfet_01v8 ad=3.864n pd=0.21m as=0 ps=0 w=42 l=15
X672 din0[1] bank_0.replica_bitcell_array_0.dummy_array_2_0.dummy_cell_1rw_1.q bank_0.replica_bitcell_array_0.dummy_array_2_0.dummy_cell_1rw_1.qb din0[1] sky130_fd_pr__nfet_01v8 ad=4.41n pd=0.322m as=3.864n ps=0.21m w=126 l=15
X673 bank_0.replica_bitcell_array_0.dummy_array_2_0.dummy_cell_1rw_8.q bank_0.replica_bitcell_array_0.dummy_array_2_0.dummy_cell_1rw_8.qb din0[1] din0[1] sky130_fd_pr__nfet_01v8 ad=3.864n pd=0.21m as=4.41n ps=0.322m w=126 l=15
X674 bank_0.replica_bitcell_array_0.dummy_array_2_0.dummy_cell_1rw_13.q bank_0.replica_bitcell_array_0.dummy_array_2_0.dummy_cell_1rw_13.qb din0[1] din0[1] sky130_fd_pr__nfet_01v8 ad=3.864n pd=0.21m as=4.41n ps=0.322m w=126 l=15
X675 a_3797_4993# din0[1] a_3743_4993# w_2422_4697# sky130_fd_pr__pfet_01v8 ad=3.192n pd=0.244m as=3.276n ps=0.246m w=84 l=15
X676 din0[1] bank_0.replica_bitcell_array_0.bitcell_array_0.cell_1rw_15.q bank_0.replica_bitcell_array_0.bitcell_array_0.cell_1rw_15.qb din0[1] sky130_fd_pr__pfet_01v8 ad=1.925n pd=0.18m as=1.925n ps=0.18m w=55 l=15
X677 a_n441_n919# control_logic_rw_0.pdriver_0_0.pinv_7_0.A a_n519_n919# din0[1] sky130_fd_pr__nfet_01v8 ad=1.795n pd=0.12m as=1.795n ps=0.12m w=57 l=15
X678 row_addr_dff_0.dout_2 row_addr_dff_0.dff_1.net4 din0[1] din0[1] sky130_fd_pr__nfet_01v8 ad=1.68n pd=0.164m as=1.68n ps=0.122m w=42 l=15
X679 a_3483_10593# control_logic_rw_0.wl_en bank_0.port_address_0.wordline_driver_array_0.wordline_driver_1.pnand2_0.nmos_m1_w0_840_sactive_dli_0.S din0[1] sky130_fd_pr__nfet_01v8 ad=3.192n pd=0.244m as=1.848n ps=0.128m w=84 l=15
X680 a_n4741_7489# control_logic_rw_0.delay_chain_0.pinv_11_14.Z a_n4794_7489# din0[1] sky130_fd_pr__nfet_01v8 ad=1.638n pd=0.162m as=1.596n ps=0.16m w=42 l=15
X681 din0[1] bank_0.replica_bitcell_array_0.bitcell_array_0.cell_1rw_11.q bank_0.replica_bitcell_array_0.bitcell_array_0.cell_1rw_11.qb din0[1] sky130_fd_pr__nfet_01v8 ad=4.41n pd=0.322m as=3.864n ps=0.21m w=126 l=15
X682 din0[1] bank_0.replica_bitcell_array_0.dummy_array_0.dummy_cell_1rw_0.q bank_0.replica_bitcell_array_0.dummy_array_0.dummy_cell_1rw_0.qb din0[1] sky130_fd_pr__nfet_01v8 ad=4.41n pd=0.322m as=3.864n ps=0.21m w=126 l=15
X683 din0[1] bank_0.replica_bitcell_array_0.dummy_array_3_0.dummy_cell_1rw_1.q bank_0.replica_bitcell_array_0.dummy_array_3_0.dummy_cell_1rw_1.qb din0[1] sky130_fd_pr__nfet_01v8 ad=4.41n pd=0.322m as=3.864n ps=0.21m w=126 l=15
X684 bank_0.port_address_0.hierarchical_decoder_0.and2_dec_10.pnand2_0.nmos_m1_w0_840_sactive_dli_0.S bank_0.port_address_0.hierarchical_decoder_0.predecode_1 a_2676_6373# din0[1] sky130_fd_pr__nfet_01v8 ad=1.848n pd=0.128m as=3.276n ps=0.246m w=84 l=15
X685 din0[1] din0[1] din0[1] din0[1] sky130_fd_pr__nfet_01v8 ad=1.678n pd=0.148m as=0 ps=0 w=60 l=12
X686 row_addr_dff_0.dff_0.net1 row_addr_dff_0.dff_3.clk addr0[3] din0[1] sky130_fd_pr__pfet_01v8 ad=2.915n pd=0.161m as=2.53n ps=0.202m w=55 l=15
X687 din0[1] bank_0.replica_bitcell_array_0.dummy_array_2_0.dummy_cell_1rw_16.q bank_0.replica_bitcell_array_0.dummy_array_2_0.dummy_cell_1rw_16.qb din0[1] sky130_fd_pr__pfet_01v8 ad=1.925n pd=0.18m as=1.925n ps=0.18m w=55 l=15
X688 din0[1] din0[1] din0[1] din0[1] sky130_fd_pr__nfet_01v8 ad=1.782n pd=0.134m as=0 ps=0 w=23 l=3
X689 din0[1] bank_0.replica_bitcell_array_0.dummy_array_2_0.dummy_cell_1rw_12.q bank_0.replica_bitcell_array_0.dummy_array_2_0.dummy_cell_1rw_12.qb din0[1] sky130_fd_pr__nfet_01v8 ad=4.41n pd=0.322m as=3.864n ps=0.21m w=126 l=15
X690 din0[1] bank_0.replica_bitcell_array_0.dummy_array_2_0.dummy_cell_1rw_17.q bank_0.replica_bitcell_array_0.dummy_array_2_0.dummy_cell_1rw_17.qb din0[1] sky130_fd_pr__nfet_01v8 ad=4.41n pd=0.322m as=3.864n ps=0.21m w=126 l=15
X691 row_addr_dff_0.dff_2.net5 row_addr_dff_0.dff_3.clk row_addr_dff_0.dff_2.net4 din0[1] sky130_fd_pr__pfet_01v8 ad=4.345n pd=0.268m as=2.915n ps=0.161m w=55 l=15
X692 a_3797_10487# din0[1] a_3743_10487# din0[1] sky130_fd_pr__nfet_01v8 ad=1.596n pd=0.16m as=1.638n ps=0.162m w=42 l=15
X693 bank_0.replica_bitcell_array_0.bitcell_array_0.cell_1rw_3.qb bank_0.replica_bitcell_array_0.wl_0_12 din0[1] din0[1] sky130_fd_pr__nfet_01v8 ad=3.864n pd=0.21m as=1.428n ps=0.152m w=42 l=15
X694 din0[1] bank_0.replica_bitcell_array_0.bitcell_array_0.cell_1rw_26.q bank_0.replica_bitcell_array_0.bitcell_array_0.cell_1rw_26.qb din0[1] sky130_fd_pr__nfet_01v8 ad=4.41n pd=0.322m as=3.864n ps=0.21m w=126 l=15
X695 din0[1] bank_0.replica_bitcell_array_0.wl_0_1 bank_0.replica_bitcell_array_0.bitcell_array_0.cell_1rw_30.qb din0[1] sky130_fd_pr__nfet_01v8 ad=1.428n pd=0.152m as=3.864n ps=0.21m w=42 l=15
X696 bank_0.replica_bitcell_array_0.dummy_array_2_0.dummy_cell_1rw_4.qb bank_0.replica_bitcell_array_0.wl_0_12 a_4490_9619# din0[1] sky130_fd_pr__nfet_01v8 ad=3.864n pd=0.21m as=1.428n ps=0.152m w=42 l=15
X697 din0[1] bank_0.replica_bitcell_array_0.wl_0_9 bank_0.replica_bitcell_array_0.bitcell_array_0.cell_1rw_6.q din0[1] sky130_fd_pr__nfet_01v8 ad=1.428n pd=0.152m as=3.864n ps=0.21m w=42 l=15
X698 a_3797_9937# din0[1] a_3743_9937# w_2422_9787# sky130_fd_pr__pfet_01v8 ad=3.192n pd=0.244m as=3.276n ps=0.246m w=84 l=15
X699 a_3103_7029# din0[1] a_3049_7029# w_2422_6733# sky130_fd_pr__pfet_01v8 ad=3.192n pd=0.244m as=3.276n ps=0.246m w=84 l=15
X700 a_n753_n691# control_logic_rw_0.pdriver_0_0.pinv_7_0.A a_n831_n691# w_n2769_n767# sky130_fd_pr__pfet_01v8 ad=3.622n pd=0.178m as=3.622n ps=0.178m w=115 l=15
X701 a_n1607_927# control_logic_rw_0.dff_buf_array_0.dout_bar_0 a_n1685_927# w_n2769_857# sky130_fd_pr__pfet_01v8 ad=3.78n pd=0.183m as=3.78n ps=0.183m w=120 l=15
X702 a_5530_9433# bank_0.replica_bitcell_array_0.wl_0_11 bank_0.replica_bitcell_array_0.dummy_array_3_0.dummy_cell_1rw_5.qb din0[1] sky130_fd_pr__nfet_01v8 ad=1.428n pd=0.152m as=3.864n ps=0.21m w=42 l=15
X703 data_dff_0.dff_0.net5 din0[1] data_dff_0.dff_0.net4 din0[1] sky130_fd_pr__pfet_01v8 ad=4.345n pd=0.268m as=2.915n ps=0.161m w=55 l=15
X704 a_n1900_123# control_logic_rw_0.dff_buf_array_0.dout_bar_0 a_n1978_123# w_n2769_44# sky130_fd_pr__pfet_01v8 ad=3.528n pd=0.175m as=3.528n ps=0.175m w=112 l=15
X705 din0[1] bank_0.replica_bitcell_array_0.replica_column_0.replica_cell_1rw_2.q din0[1] din0[1] sky130_fd_pr__nfet_01v8 ad=3.864n pd=0.21m as=0 ps=0 w=126 l=15
X706 a_4421_8415# bank_0.replica_bitcell_array_0.wl_0_9 bank_0.replica_bitcell_array_0.dummy_array_2_0.dummy_cell_1rw_7.q din0[1] sky130_fd_pr__nfet_01v8 ad=1.428n pd=0.152m as=3.864n ps=0.21m w=42 l=15
X707 din0[1] din0[1] din0[1] din0[1] sky130_fd_pr__nfet_01v8 ad=1.597n pd=0.134m as=0 ps=0 w=84 l=15
X708 a_n1221_298# control_logic_rw_0.pdriver_1_0.pinv_6_0.A a_n1299_298# w_n2769_44# sky130_fd_pr__pfet_01v8 ad=3.307n pd=0.168m as=3.307n ps=0.168m w=105 l=15
X709 din0[1] bank_0.replica_bitcell_array_0.wl_0_11 din0[1] din0[1] sky130_fd_pr__nfet_01v8 ad=1.428n pd=0.152m as=0 ps=0 w=42 l=15
X710 a_1822_7901# din0[1] a_1768_7901# w_1141_7751# sky130_fd_pr__pfet_01v8 ad=3.192n pd=0.244m as=3.276n ps=0.246m w=84 l=15
X711 a_n5055_9063# control_logic_rw_0.delay_chain_0.pinv_11_9.Z a_n5108_9063# din0[1] sky130_fd_pr__nfet_01v8 ad=1.638n pd=0.162m as=1.596n ps=0.16m w=42 l=15
X712 din0[1] bank_0.replica_bitcell_array_0.wl_0_7 bank_0.replica_bitcell_array_0.bitcell_array_0.cell_1rw_24.qb din0[1] sky130_fd_pr__nfet_01v8 ad=1.428n pd=0.152m as=3.864n ps=0.21m w=42 l=15
X713 din0[1] bank_0.replica_bitcell_array_0.bitcell_array_0.cell_1rw_10.q bank_0.replica_bitcell_array_0.bitcell_array_0.cell_1rw_10.qb din0[1] sky130_fd_pr__pfet_01v8 ad=1.925n pd=0.18m as=1.925n ps=0.18m w=55 l=15
X714 bank_0.replica_bitcell_array_0.bitcell_array_0.cell_1rw_13.q bank_0.replica_bitcell_array_0.wl_0_2 din0[1] din0[1] sky130_fd_pr__nfet_01v8 ad=3.864n pd=0.21m as=1.428n ps=0.152m w=42 l=15
X715 bank_0.replica_bitcell_array_0.replica_column_0.replica_cell_1rw_1.q bank_0.replica_bitcell_array_0.wl_0_14 din0[1] din0[1] sky130_fd_pr__nfet_01v8 ad=3.864n pd=0.21m as=1.428n ps=0.152m w=42 l=15
X716 a_2789_5503# bank_0.port_address_0.hierarchical_decoder_0.predecode_5 bank_0.port_address_0.hierarchical_decoder_0.and2_dec_11.pnand2_0.nmos_m1_w0_840_sactive_dli_0.S din0[1] sky130_fd_pr__nfet_01v8 ad=3.192n pd=0.244m as=1.848n ps=0.128m w=84 l=15
X717 a_n2343_2181# control_logic_rw_0.pand3_0_0.pnand3_0_0.nmos_m1_w0_840_sactive_dli_0.G control_logic_rw_0.pand3_0_0.pnand3_0_0.nmos_m1_w0_840_sactive_dactive_0.D din0[1] sky130_fd_pr__nfet_01v8 ad=3.192n pd=0.244m as=1.848n ps=0.128m w=84 l=15
X718 a_n4427_8181# control_logic_rw_0.delay_chain_0.pinv_11_14.Z a_n4480_8181# w_n5644_7860# sky130_fd_pr__pfet_01v8 ad=3.276n pd=0.246m as=3.192n ps=0.244m w=84 l=15
X719 control_logic_rw_0.pand2_0.pnand2_0_0.nmos_m1_w0_840_sactive_dli_0.S din0[1] a_n2515_n107# din0[1] sky130_fd_pr__nfet_01v8 ad=1.848n pd=0.128m as=3.276n ps=0.246m w=84 l=15
X720 bank_0.replica_bitcell_array_0.bitcell_array_0.cell_1rw_19.q bank_0.replica_bitcell_array_0.bitcell_array_0.cell_1rw_19.qb din0[1] din0[1] sky130_fd_pr__nfet_01v8 ad=3.864n pd=0.21m as=4.41n ps=0.322m w=126 l=15
X721 a_3103_8557# din0[1] a_3049_8557# din0[1] sky130_fd_pr__nfet_01v8 ad=1.596n pd=0.16m as=1.638n ps=0.162m w=42 l=15
X722 a_3483_4337# control_logic_rw_0.wl_en bank_0.port_address_0.wordline_driver_array_0.wordline_driver_14.pnand2_0.nmos_m1_w0_840_sactive_dli_0.S din0[1] sky130_fd_pr__nfet_01v8 ad=3.192n pd=0.244m as=1.848n ps=0.128m w=84 l=15
X723 data_dff_0.dff_0.net5 data_dff_0.dff_0.clkb data_dff_0.dff_0.net4 din0[1] sky130_fd_pr__nfet_01v8 ad=3.318n pd=0.242m as=2.226n ps=0.148m w=42 l=15
X724 control_logic_rw_0.dff_buf_array_0.dff_buf_0_0.pinv_0_0.A control_logic_rw_0.dff_buf_array_0.dff_buf_0_0.dff_0.net4 din0[1] din0[1] sky130_fd_pr__nfet_01v8 ad=1.68n pd=0.164m as=1.68n ps=0.122m w=42 l=15
X725 din0[1] bank_0.replica_bitcell_array_0.dummy_array_0.dummy_cell_1rw_1.q bank_0.replica_bitcell_array_0.dummy_array_0.dummy_cell_1rw_1.qb din0[1] sky130_fd_pr__pfet_01v8 ad=1.925n pd=0.18m as=1.925n ps=0.18m w=55 l=15
X726 bank_0.replica_bitcell_array_0.bitcell_array_0.cell_1rw_24.q bank_0.replica_bitcell_array_0.bitcell_array_0.cell_1rw_24.qb din0[1] din0[1] sky130_fd_pr__nfet_01v8 ad=3.864n pd=0.21m as=4.41n ps=0.322m w=126 l=15
X727 din0[1] bank_0.replica_bitcell_array_0.dummy_array_2_0.dummy_cell_1rw_11.q bank_0.replica_bitcell_array_0.dummy_array_2_0.dummy_cell_1rw_11.qb din0[1] sky130_fd_pr__pfet_01v8 ad=1.925n pd=0.18m as=1.925n ps=0.18m w=55 l=15
X728 a_3103_5865# din0[1] a_3049_5865# w_2422_5715# sky130_fd_pr__pfet_01v8 ad=3.192n pd=0.244m as=3.276n ps=0.246m w=84 l=15
X729 a_n4427_4969# control_logic_rw_0.delay_chain_0.pinv_11_29.Z a_n4480_4969# w_n5644_4500# sky130_fd_pr__pfet_01v8 ad=3.276n pd=0.246m as=3.192n ps=0.244m w=84 l=15
X730 bank_0.replica_bitcell_array_0.dummy_array_2_0.dummy_cell_1rw_14.q bank_0.replica_bitcell_array_0.wl_0_2 a_4421_4529# din0[1] sky130_fd_pr__nfet_01v8 ad=3.864n pd=0.21m as=1.428n ps=0.152m w=42 l=15
X731 a_5313_1712# control_logic_rw_0.p_en_bar a_5259_1712# w_4605_1519# sky130_fd_pr__pfet_01v8 ad=3.192n pd=0.244m as=3.276n ps=0.246m w=84 l=15
X732 a_3797_10593# din0[1] a_3743_10593# din0[1] sky130_fd_pr__nfet_01v8 ad=1.596n pd=0.16m as=1.638n ps=0.162m w=42 l=15
X733 din0[1] din0[1] row_addr_dff_0.dff_3.net5 din0[1] sky130_fd_pr__pfet_01v8 ad=2.2n pd=0.135m as=3.08n ps=0.222m w=55 l=15
X734 data_dff_0.dff_1.net1 din0[1] din0[0] din0[1] sky130_fd_pr__pfet_01v8 ad=2.915n pd=0.161m as=2.53n ps=0.202m w=55 l=15
X735 din0[1] row_addr_dff_0.dff_2.net3 row_addr_dff_0.dff_2.net2 din0[1] sky130_fd_pr__pfet_01v8 ad=2.2n pd=0.135m as=2.915n ps=0.216m w=55 l=15
X736 bank_0.replica_bitcell_array_0.bitcell_array_0.cell_1rw_19.q bank_0.replica_bitcell_array_0.wl_0_12 din0[1] din0[1] sky130_fd_pr__nfet_01v8 ad=3.864n pd=0.21m as=1.428n ps=0.152m w=42 l=15
X737 bank_0.replica_bitcell_array_0.dummy_array_3_0.dummy_cell_1rw_14.q bank_0.replica_bitcell_array_0.dummy_array_3_0.dummy_cell_1rw_14.qb din0[1] din0[1] sky130_fd_pr__pfet_01v8 ad=1.925n pd=0.18m as=1.925n ps=0.18m w=55 l=15
X738 din0[1] bank_0.replica_bitcell_array_0.bitcell_array_0.cell_1rw_4.q bank_0.replica_bitcell_array_0.bitcell_array_0.cell_1rw_4.qb din0[1] sky130_fd_pr__pfet_01v8 ad=1.925n pd=0.18m as=1.925n ps=0.18m w=55 l=15
X739 din0[1] bank_0.replica_bitcell_array_0.bitcell_array_0.cell_1rw_11.q bank_0.replica_bitcell_array_0.bitcell_array_0.cell_1rw_11.qb din0[1] sky130_fd_pr__pfet_01v8 ad=1.925n pd=0.18m as=1.925n ps=0.18m w=55 l=15
X740 din0[1] bank_0.replica_bitcell_array_0.dummy_array_3_0.dummy_cell_1rw_18.q bank_0.replica_bitcell_array_0.dummy_array_3_0.dummy_cell_1rw_18.qb din0[1] sky130_fd_pr__pfet_01v8 ad=1.925n pd=0.18m as=1.925n ps=0.18m w=55 l=15
X741 bank_0.replica_bitcell_array_0.dummy_array_2_0.dummy_cell_1rw_0.q din0[1] a_4421_11655# din0[1] sky130_fd_pr__nfet_01v8 ad=3.864n pd=0.21m as=1.428n ps=0.152m w=42 l=15
X742 din0[1] bank_0.replica_bitcell_array_0.bitcell_array_0.cell_1rw_7.q bank_0.replica_bitcell_array_0.bitcell_array_0.cell_1rw_7.qb din0[1] sky130_fd_pr__nfet_01v8 ad=4.41n pd=0.322m as=3.864n ps=0.21m w=126 l=15
X743 din0[1] bank_0.replica_bitcell_array_0.bitcell_array_0.cell_1rw_12.q bank_0.replica_bitcell_array_0.bitcell_array_0.cell_1rw_12.qb din0[1] sky130_fd_pr__nfet_01v8 ad=4.41n pd=0.322m as=3.864n ps=0.21m w=126 l=15
X744 din0[1] din0[1] din0[1] din0[1] sky130_fd_pr__pfet_01v8 ad=2.75n pd=0.21m as=0 ps=0 w=55 l=15
X745 din0[1] din0[1] din0[1] din0[1] sky130_fd_pr__nfet_01v8 ad=1.823n pd=0.193m as=0 ps=0 w=18 l=3
X746 bank_0.replica_bitcell_array_0.replica_column_0.replica_cell_1rw_13.q din0[1] din0[1] din0[1] sky130_fd_pr__pfet_01v8 ad=1.925n pd=0.18m as=1.925n ps=0.18m w=55 l=15
X747 din0[1] bank_0.replica_bitcell_array_0.dummy_array_3_0.dummy_cell_1rw_14.q bank_0.replica_bitcell_array_0.dummy_array_3_0.dummy_cell_1rw_14.qb din0[1] sky130_fd_pr__nfet_01v8 ad=4.41n pd=0.322m as=3.864n ps=0.21m w=126 l=15
X748 a_3797_3467# din0[1] a_3743_3467# din0[1] sky130_fd_pr__nfet_01v8 ad=1.596n pd=0.16m as=1.638n ps=0.162m w=42 l=15
X749 bank_0.replica_bitcell_array_0.dummy_array_3_0.dummy_cell_1rw_0.q din0[1] a_5461_11655# din0[1] sky130_fd_pr__nfet_01v8 ad=3.864n pd=0.21m as=1.428n ps=0.152m w=42 l=15
X750 row_addr_dff_0.dff_1.clkb row_addr_dff_0.dff_3.clk din0[1] din0[1] sky130_fd_pr__nfet_01v8 ad=1.932n pd=0.176m as=1.932n ps=0.176m w=42 l=15
X751 row_addr_dff_0.dff_2.net1 row_addr_dff_0.dff_3.clk addr0[1] din0[1] sky130_fd_pr__pfet_01v8 ad=2.915n pd=0.161m as=2.53n ps=0.202m w=55 l=15
X752 din0[1] bank_0.replica_bitcell_array_0.dummy_array_2_0.dummy_cell_1rw_5.q bank_0.replica_bitcell_array_0.dummy_array_2_0.dummy_cell_1rw_5.qb din0[1] sky130_fd_pr__pfet_01v8 ad=1.925n pd=0.18m as=1.925n ps=0.18m w=55 l=15
X753 bank_0.replica_bitcell_array_0.bitcell_array_0.cell_1rw_7.q bank_0.replica_bitcell_array_0.bitcell_array_0.cell_1rw_7.qb din0[1] din0[1] sky130_fd_pr__pfet_01v8 ad=1.925n pd=0.18m as=1.925n ps=0.18m w=55 l=15
X754 a_3483_7391# control_logic_rw_0.wl_en bank_0.port_address_0.wordline_driver_array_0.wordline_driver_8.pnand2_0.nmos_m1_w0_840_sactive_dli_0.S din0[1] sky130_fd_pr__nfet_01v8 ad=3.192n pd=0.244m as=1.848n ps=0.128m w=84 l=15
X755 din0[1] bank_0.replica_bitcell_array_0.dummy_array_2_0.dummy_cell_1rw_12.q bank_0.replica_bitcell_array_0.dummy_array_2_0.dummy_cell_1rw_12.qb din0[1] sky130_fd_pr__pfet_01v8 ad=1.925n pd=0.18m as=1.925n ps=0.18m w=55 l=15
X756 a_1822_4993# din0[1] a_1768_4993# w_1141_4697# sky130_fd_pr__pfet_01v8 ad=3.192n pd=0.244m as=3.276n ps=0.246m w=84 l=15
X757 a_n1508_n513# control_logic_rw_0.dff_buf_array_0.dout_bar_0 a_n1586_n513# w_n2769_n767# sky130_fd_pr__pfet_01v8 ad=3.528n pd=0.175m as=3.528n ps=0.175m w=112 l=15
X758 bank_0.port_address_0.wordline_driver_array_0.wordline_driver_13.pnand2_0.nmos_m1_w0_840_sactive_dli_0.S bank_0.port_address_0.wordline_driver_array_0.in_2 a_3370_4485# din0[1] sky130_fd_pr__nfet_01v8 ad=1.848n pd=0.128m as=3.276n ps=0.246m w=84 l=15
X759 data_dff_0.dff_1.net1 data_dff_0.dff_1.clkb din0[0] din0[1] sky130_fd_pr__nfet_01v8 ad=2.226n pd=0.148m as=1.932n ps=0.176m w=42 l=15
X760 din0[1] bank_0.replica_bitcell_array_0.replica_column_0.dummy_cell_1rw_1.q bank_0.replica_bitcell_array_0.replica_column_0.dummy_cell_1rw_1.qb din0[1] sky130_fd_pr__pfet_01v8 ad=1.925n pd=0.18m as=1.925n ps=0.18m w=55 l=15
X761 din0[1] bank_0.replica_bitcell_array_0.dummy_array_2_0.dummy_cell_1rw_8.q bank_0.replica_bitcell_array_0.dummy_array_2_0.dummy_cell_1rw_8.qb din0[1] sky130_fd_pr__nfet_01v8 ad=4.41n pd=0.322m as=3.864n ps=0.21m w=126 l=15
X762 a_n4427_7489# control_logic_rw_0.delay_chain_0.pinv_11_14.Z a_n4480_7489# din0[1] sky130_fd_pr__nfet_01v8 ad=1.638n pd=0.162m as=1.596n ps=0.16m w=42 l=15
X763 din0[1] bank_0.replica_bitcell_array_0.dummy_array_2_0.dummy_cell_1rw_13.q bank_0.replica_bitcell_array_0.dummy_array_2_0.dummy_cell_1rw_13.qb din0[1] sky130_fd_pr__nfet_01v8 ad=4.41n pd=0.322m as=3.864n ps=0.21m w=126 l=15
X764 bank_0.port_address_0.hierarchical_decoder_0.and2_dec_0.pnand2_0.nmos_m1_w0_840_sactive_dli_0.S bank_0.port_address_0.hierarchical_decoder_0.predecode_3 a_2676_11463# din0[1] sky130_fd_pr__nfet_01v8 ad=1.848n pd=0.128m as=3.276n ps=0.246m w=84 l=15
X765 bank_0.replica_bitcell_array_0.dummy_array_2_0.dummy_cell_1rw_8.q bank_0.replica_bitcell_array_0.dummy_array_2_0.dummy_cell_1rw_8.qb din0[1] din0[1] sky130_fd_pr__pfet_01v8 ad=1.925n pd=0.18m as=1.925n ps=0.18m w=55 l=15
X766 a_n2461_n213# din0[1] a_n2515_n213# din0[1] sky130_fd_pr__nfet_01v8 ad=1.596n pd=0.16m as=1.638n ps=0.162m w=42 l=15
X767 a_n5369_5703# control_logic_rw_0.delay_chain_0.pinv_11_29.Z a_n5422_5703# din0[1] sky130_fd_pr__nfet_01v8 ad=1.638n pd=0.162m as=1.596n ps=0.16m w=42 l=15
X768 a_n5369_3289# control_logic_rw_0.delay_chain_0.pinv_11_39.Z a_n5422_3289# w_n5644_2820# sky130_fd_pr__pfet_01v8 ad=3.276n pd=0.246m as=3.192n ps=0.244m w=84 l=15
X769 bank_0.replica_bitcell_array_0.dummy_array_3_0.dummy_cell_1rw_9.q bank_0.replica_bitcell_array_0.dummy_array_3_0.dummy_cell_1rw_9.qb din0[1] din0[1] sky130_fd_pr__pfet_01v8 ad=1.925n pd=0.18m as=1.925n ps=0.18m w=55 l=15
X770 din0[1] din0[1] din0[1] din0[1] sky130_fd_pr__nfet_01v8 ad=1.89n pd=0.174m as=0 ps=0 w=42 l=15
X771 bank_0.replica_bitcell_array_0.replica_column_0.replica_cell_1rw_8.q din0[1] din0[1] din0[1] sky130_fd_pr__pfet_01v8 ad=1.925n pd=0.18m as=1.925n ps=0.18m w=55 l=15
X772 control_logic_rw_0.dff_buf_array_0.dff_buf_0_1.dff_0.clkb din0[1] din0[1] din0[1] sky130_fd_pr__pfet_01v8 ad=2.53n pd=0.202m as=2.53n ps=0.202m w=55 l=15
X773 a_2789_9065# bank_0.port_address_0.hierarchical_decoder_0.predecode_6 a_2730_9065# w_2422_8769# sky130_fd_pr__pfet_01v8 ad=3.192n pd=0.244m as=1.848n ps=0.128m w=84 l=15
X774 a_2789_7539# bank_0.port_address_0.hierarchical_decoder_0.predecode_6 bank_0.port_address_0.hierarchical_decoder_0.and2_dec_7.pnand2_0.nmos_m1_w0_840_sactive_dli_0.S din0[1] sky130_fd_pr__nfet_01v8 ad=3.192n pd=0.244m as=1.848n ps=0.128m w=84 l=15
X775 bank_0.replica_bitcell_array_0.bitcell_array_0.cell_1rw_9.q bank_0.replica_bitcell_array_0.wl_0_6 din0[1] din0[1] sky130_fd_pr__nfet_01v8 ad=3.864n pd=0.21m as=1.428n ps=0.152m w=42 l=15
X776 din0[1] bank_0.replica_bitcell_array_0.wl_0_5 bank_0.replica_bitcell_array_0.bitcell_array_0.cell_1rw_10.qb din0[1] sky130_fd_pr__nfet_01v8 ad=1.428n pd=0.152m as=3.864n ps=0.21m w=42 l=15
X777 a_1508_4485# row_addr_dff_0.dout_1 bank_0.port_address_0.hierarchical_decoder_0.hierarchical_predecode2x4_1.and2_dec_1.pnand2_0.nmos_m1_w0_840_sactive_dli_0.S din0[1] sky130_fd_pr__nfet_01v8 ad=3.192n pd=0.244m as=1.848n ps=0.128m w=84 l=15
X778 bank_0.replica_bitcell_array_0.dummy_array_3_0.dummy_cell_1rw_16.q bank_0.replica_bitcell_array_0.wl_0_0 a_5461_3511# din0[1] sky130_fd_pr__nfet_01v8 ad=3.864n pd=0.21m as=1.428n ps=0.152m w=42 l=15
X779 a_2789_4847# bank_0.port_address_0.hierarchical_decoder_0.predecode_4 a_2730_4847# w_2422_4697# sky130_fd_pr__pfet_01v8 ad=3.192n pd=0.244m as=1.848n ps=0.128m w=84 l=15
X780 a_n1978_n107# control_logic_rw_0.dff_buf_array_0.dout_bar_0 a_n2056_n107# din0[1] sky130_fd_pr__nfet_01v8 ad=1.764n pd=0.119m as=1.764n ps=0.119m w=56 l=15
X781 din0[1] din0[1] din0[1] din0[1] sky130_fd_pr__nfet_01v8 ad=0.56n pd=77u as=0 ps=0 w=42 l=15
X782 bank_0.replica_bitcell_array_0.bitcell_array_0.cell_1rw_20.q bank_0.replica_bitcell_array_0.bitcell_array_0.cell_1rw_20.qb din0[1] din0[1] sky130_fd_pr__nfet_01v8 ad=3.864n pd=0.21m as=4.41n ps=0.322m w=126 l=15
X783 bank_0.replica_bitcell_array_0.dummy_array_2_0.dummy_cell_1rw_10.q bank_0.replica_bitcell_array_0.wl_0_6 a_4421_6565# din0[1] sky130_fd_pr__nfet_01v8 ad=3.864n pd=0.21m as=1.428n ps=0.152m w=42 l=15
X784 data_dff_0.dff_1.net5 din0[1] din0[1] din0[1] sky130_fd_pr__pfet_01v8 ad=4.345n pd=0.268m as=2.915n ps=0.161m w=55 l=15
X785 a_n1801_299# control_logic_rw_0.pdriver_1_0.pinv_8_0.Z a_n1855_299# w_n2769_44# sky130_fd_pr__pfet_01v8 ad=2.646n pd=0.147m as=3.276n ps=0.246m w=84 l=15
X786 a_4490_6379# bank_0.replica_bitcell_array_0.wl_0_5 bank_0.replica_bitcell_array_0.dummy_array_2_0.dummy_cell_1rw_11.qb din0[1] sky130_fd_pr__nfet_01v8 ad=1.428n pd=0.152m as=3.864n ps=0.21m w=42 l=15
X787 bank_0.replica_bitcell_array_0.replica_column_0.replica_cell_1rw_15.q bank_0.replica_bitcell_array_0.wl_0_0 din0[1] din0[1] sky130_fd_pr__nfet_01v8 ad=3.864n pd=0.21m as=1.428n ps=0.152m w=42 l=15
X788 control_logic_rw_0.dff_buf_array_0.dff_buf_0_1.dff_0.clkb din0[1] din0[1] din0[1] sky130_fd_pr__nfet_01v8 ad=1.932n pd=0.176m as=1.932n ps=0.176m w=42 l=15
X789 a_n1143_589# control_logic_rw_0.pdriver_1_0.pinv_6_0.A a_n1221_589# din0[1] sky130_fd_pr__nfet_01v8 ad=1.976n pd=0.18m as=1.638n ps=0.115m w=52 l=15
X790 bank_0.replica_bitcell_array_0.dummy_array_3_0.dummy_cell_1rw_10.q bank_0.replica_bitcell_array_0.dummy_array_3_0.dummy_cell_1rw_10.qb din0[1] din0[1] sky130_fd_pr__pfet_01v8 ad=1.925n pd=0.18m as=1.925n ps=0.18m w=55 l=15
X791 a_3483_11101# control_logic_rw_0.wl_en a_3424_11101# w_2422_10805# sky130_fd_pr__pfet_01v8 ad=3.192n pd=0.244m as=1.848n ps=0.128m w=84 l=15
X792 a_n1586_n227# control_logic_rw_0.dff_buf_array_0.dout_bar_0 a_n1664_n227# din0[1] sky130_fd_pr__nfet_01v8 ad=1.764n pd=0.119m as=1.764n ps=0.119m w=56 l=15
X793 din0[1] bank_0.replica_bitcell_array_0.dummy_array_3_0.dummy_cell_1rw_7.q bank_0.replica_bitcell_array_0.dummy_array_3_0.dummy_cell_1rw_7.qb din0[1] sky130_fd_pr__pfet_01v8 ad=1.925n pd=0.18m as=1.925n ps=0.18m w=55 l=15
X794 din0[1] bank_0.replica_bitcell_array_0.dummy_array_3_0.dummy_cell_1rw_14.q bank_0.replica_bitcell_array_0.dummy_array_3_0.dummy_cell_1rw_14.qb din0[1] sky130_fd_pr__pfet_01v8 ad=1.925n pd=0.18m as=1.925n ps=0.18m w=55 l=15
X795 row_addr_dff_0.dff_1.net4 row_addr_dff_0.dff_3.clk row_addr_dff_0.dff_1.net3 din0[1] sky130_fd_pr__nfet_01v8 ad=2.226n pd=0.148m as=2.73n ps=0.214m w=42 l=15
X796 bank_0.replica_bitcell_array_0.bitcell_array_0.cell_1rw_3.q bank_0.replica_bitcell_array_0.bitcell_array_0.cell_1rw_3.qb din0[1] din0[1] sky130_fd_pr__nfet_01v8 ad=3.864n pd=0.21m as=4.41n ps=0.322m w=126 l=15
X797 bank_0.port_address_0.hierarchical_decoder_0.hierarchical_predecode2x4_0.and2_dec_1.pnand2_0.nmos_m1_w0_840_sactive_dli_0.S bank_0.port_address_0.hierarchical_decoder_0.hierarchical_predecode2x4_0.pinv_1.Z a_1395_7539# din0[1] sky130_fd_pr__nfet_01v8 ad=1.848n pd=0.128m as=3.276n ps=0.246m w=84 l=15
X798 bank_0.replica_bitcell_array_0.bitcell_array_0.cell_1rw_8.q bank_0.replica_bitcell_array_0.bitcell_array_0.cell_1rw_8.qb din0[1] din0[1] sky130_fd_pr__nfet_01v8 ad=3.864n pd=0.21m as=4.41n ps=0.322m w=126 l=15
X799 bank_0.replica_bitcell_array_0.replica_column_0.replica_cell_1rw_9.q din0[1] din0[1] din0[1] sky130_fd_pr__pfet_01v8 ad=1.925n pd=0.18m as=1.925n ps=0.18m w=55 l=15
X800 din0[1] bank_0.replica_bitcell_array_0.dummy_array_3_0.dummy_cell_1rw_10.q bank_0.replica_bitcell_array_0.dummy_array_3_0.dummy_cell_1rw_10.qb din0[1] sky130_fd_pr__nfet_01v8 ad=4.41n pd=0.322m as=3.864n ps=0.21m w=126 l=15
X801 a_n5055_4821# control_logic_rw_0.delay_chain_0.pinv_11_34.Z a_n5108_4821# w_n5644_4500# sky130_fd_pr__pfet_01v8 ad=3.276n pd=0.246m as=3.192n ps=0.244m w=84 l=15
X802 a_1449_4847# bank_0.port_address_0.hierarchical_decoder_0.hierarchical_predecode2x4_1.pinv_1.Z a_1395_4847# w_1141_4697# sky130_fd_pr__pfet_01v8 ad=1.848n pd=0.128m as=3.276n ps=0.246m w=84 l=15
X803 a_n1822_n107# control_logic_rw_0.dff_buf_array_0.dout_bar_0 a_n1900_n107# din0[1] sky130_fd_pr__nfet_01v8 ad=1.764n pd=0.119m as=1.764n ps=0.119m w=56 l=15
X804 din0[1] row_addr_dff_0.dff_3.net4 din0[1] din0[1] sky130_fd_pr__nfet_01v8 ad=1.68n pd=0.122m as=0 ps=0 w=42 l=15
X805 din0[1] bank_0.replica_bitcell_array_0.dummy_array_3_0.dummy_cell_1rw_15.q bank_0.replica_bitcell_array_0.dummy_array_3_0.dummy_cell_1rw_15.qb din0[1] sky130_fd_pr__nfet_01v8 ad=4.41n pd=0.322m as=3.864n ps=0.21m w=126 l=15
X806 data_dff_0.dff_1.net5 data_dff_0.dff_1.clkb din0[1] din0[1] sky130_fd_pr__nfet_01v8 ad=3.318n pd=0.242m as=2.226n ps=0.148m w=42 l=15
X807 din0[1] bank_0.replica_bitcell_array_0.wl_0_13 bank_0.replica_bitcell_array_0.bitcell_array_0.cell_1rw_18.qb din0[1] sky130_fd_pr__nfet_01v8 ad=1.428n pd=0.152m as=3.864n ps=0.21m w=42 l=15
X808 din0[1] bank_0.replica_bitcell_array_0.replica_column_0.replica_cell_1rw_6.q din0[1] din0[1] sky130_fd_pr__pfet_01v8 ad=1.925n pd=0.18m as=0 ps=0 w=55 l=15
X809 din0[1] bank_0.replica_bitcell_array_0.replica_column_0.replica_cell_1rw_13.q din0[1] din0[1] sky130_fd_pr__pfet_01v8 ad=1.925n pd=0.18m as=0 ps=0 w=55 l=15
X810 din0[1] data_dff_0.dff_1.net3 data_dff_0.dff_1.net2 din0[1] sky130_fd_pr__pfet_01v8 ad=2.2n pd=0.135m as=2.915n ps=0.216m w=55 l=15
X811 bank_0.replica_bitcell_array_0.dummy_array_2_0.dummy_cell_1rw_4.q bank_0.replica_bitcell_array_0.dummy_array_2_0.dummy_cell_1rw_4.qb din0[1] din0[1] sky130_fd_pr__nfet_01v8 ad=3.864n pd=0.21m as=4.41n ps=0.322m w=126 l=15
X812 bank_0.replica_bitcell_array_0.dummy_array_2_0.dummy_cell_1rw_9.q bank_0.replica_bitcell_array_0.dummy_array_2_0.dummy_cell_1rw_9.qb din0[1] din0[1] sky130_fd_pr__nfet_01v8 ad=3.864n pd=0.21m as=4.41n ps=0.322m w=126 l=15
X813 a_n2088_n255# control_logic_rw_0.pand2_1.pnand2_0_0.nmos_m1_w0_840_sactive_dli_0.G control_logic_rw_0.pand2_1.pnand2_0_0.nmos_m1_w0_840_sactive_dli_0.S din0[1] sky130_fd_pr__nfet_01v8 ad=3.192n pd=0.244m as=1.848n ps=0.128m w=84 l=15
X814 a_1822_3467# din0[1] a_1768_3467# din0[1] sky130_fd_pr__nfet_01v8 ad=1.596n pd=0.16m as=1.638n ps=0.162m w=42 l=15
X815 din0[1] control_logic_rw_0.dff_buf_array_0.dff_buf_0_1.pinv_0_0.A control_logic_rw_0.dff_buf_array_0.dff_buf_0_1.dff_0.net5 din0[1] sky130_fd_pr__pfet_01v8 ad=2.2n pd=0.135m as=3.08n ps=0.222m w=55 l=15
X816 bank_0.replica_bitcell_array_0.dummy_array_0_0.dummy_cell_1rw_1.q din0[1] a_4941_11655# din0[1] sky130_fd_pr__nfet_01v8 ad=3.864n pd=0.21m as=1.428n ps=0.152m w=42 l=15
X817 din0[1] bank_0.replica_bitcell_array_0.wl_0_5 bank_0.replica_bitcell_array_0.bitcell_array_0.cell_1rw_26.q din0[1] sky130_fd_pr__nfet_01v8 ad=1.428n pd=0.152m as=3.864n ps=0.21m w=42 l=15
X818 a_n3839_n213# control_logic_rw_0.dff_buf_array_0.dff_buf_0_0.pinv_0_0.A a_n3917_n213# din0[1] sky130_fd_pr__nfet_01v8 ad=1.596n pd=0.16m as=1.323n ps=0.105m w=42 l=15
X819 din0[1] din0[1] din0[1] din0[1] sky130_fd_pr__pfet_01v8 ad=0.696n pd=90u as=0 ps=0 w=19 l=1
X820 bank_0.replica_bitcell_array_0.dummy_array_3_0.dummy_cell_1rw_5.q bank_0.replica_bitcell_array_0.dummy_array_3_0.dummy_cell_1rw_5.qb din0[1] din0[1] sky130_fd_pr__pfet_01v8 ad=1.925n pd=0.18m as=1.925n ps=0.18m w=55 l=15
X821 din0[1] din0[1] din0[1] din0[1] sky130_fd_pr__nfet_01v8 ad=1.485n pd=0.134m as=0 ps=0 w=84 l=15
X822 a_n1432_123# control_logic_rw_0.dff_buf_array_0.dout_bar_0 a_n1510_123# w_n2769_44# sky130_fd_pr__pfet_01v8 ad=4.256n pd=0.3m as=3.528n ps=0.175m w=112 l=15
X823 a_5461_9433# bank_0.replica_bitcell_array_0.wl_0_11 bank_0.replica_bitcell_array_0.dummy_array_3_0.dummy_cell_1rw_5.q din0[1] sky130_fd_pr__nfet_01v8 ad=1.428n pd=0.152m as=3.864n ps=0.21m w=42 l=15
X824 din0[1] data_dff_0.dff_1.net3 data_dff_0.dff_1.net2 din0[1] sky130_fd_pr__nfet_01v8 ad=1.68n pd=0.122m as=2.226n ps=0.19m w=42 l=15
X825 a_n1841_705# control_logic_rw_0.dff_buf_array_0.dout_bar_0 a_n1919_705# din0[1] sky130_fd_pr__nfet_01v8 ad=1.89n pd=0.123m as=1.89n ps=0.123m w=60 l=15
X826 bank_0.replica_bitcell_array_0.dummy_array_1_0.dummy_cell_1rw_1.q bank_0.replica_bitcell_array_0.dummy_array_1_0.dummy_cell_1rw_1.qb din0[1] din0[1] sky130_fd_pr__nfet_01v8 ad=3.864n pd=0.21m as=4.41n ps=0.322m w=126 l=15
X827 row_addr_dff_0.dout_3 row_addr_dff_0.dff_0.net4 din0[1] din0[1] sky130_fd_pr__nfet_01v8 ad=1.68n pd=0.164m as=1.68n ps=0.122m w=42 l=15
X828 din0[1] bank_0.replica_bitcell_array_0.wl_0_11 bank_0.replica_bitcell_array_0.replica_column_0.replica_cell_1rw_4.q din0[1] sky130_fd_pr__nfet_01v8 ad=1.428n pd=0.152m as=3.864n ps=0.21m w=42 l=15
X829 bank_0.replica_bitcell_array_0.replica_column_0.replica_cell_1rw_4.q din0[1] din0[1] din0[1] sky130_fd_pr__pfet_01v8 ad=1.925n pd=0.18m as=1.925n ps=0.18m w=55 l=15
X830 a_n4113_7383# control_logic_rw_0.delay_chain_0.pinv_11_24.Z a_n4166_7383# din0[1] sky130_fd_pr__nfet_01v8 ad=1.638n pd=0.162m as=1.596n ps=0.16m w=42 l=15
X831 a_n4113_6501# control_logic_rw_0.delay_chain_0.pinv_11_29.Z a_n4166_6501# w_n5644_6180# sky130_fd_pr__pfet_01v8 ad=3.276n pd=0.246m as=3.192n ps=0.244m w=84 l=15
X832 a_n1645_n919# control_logic_rw_0.pdriver_0_0.pinv_6_0.A a_n1723_n919# din0[1] sky130_fd_pr__nfet_01v8 ad=1.638n pd=0.115m as=1.638n ps=0.115m w=52 l=15
X833 a_n987_n919# control_logic_rw_0.pdriver_0_0.pinv_7_0.A a_n1065_n919# din0[1] sky130_fd_pr__nfet_01v8 ad=1.795n pd=0.12m as=1.795n ps=0.12m w=57 l=15
X834 a_n2402_1160# control_logic_rw_0.pnand2_1_0.nmos_m1_w0_840_sactive_dli_0.G a_n2418_1160# w_n2769_857# sky130_fd_pr__pfet_01v8 ad=17p pd=36u as=17p ps=36u w=17 l=15
X835 a_3483_3975# control_logic_rw_0.wl_en a_3424_3975# w_2422_3679# sky130_fd_pr__pfet_01v8 ad=3.192n pd=0.244m as=1.848n ps=0.128m w=84 l=15
X836 din0[1] control_logic_rw_0.dff_buf_array_0.dff_buf_0_1.pinv_0_0.A control_logic_rw_0.dff_buf_array_0.dff_buf_0_1.dff_0.net5 din0[1] sky130_fd_pr__nfet_01v8 ad=1.68n pd=0.122m as=2.352n ps=0.196m w=42 l=15
X837 a_2789_4337# bank_0.port_address_0.hierarchical_decoder_0.predecode_4 bank_0.port_address_0.hierarchical_decoder_0.and2_dec_14.pnand2_0.nmos_m1_w0_840_sactive_dli_0.S din0[1] sky130_fd_pr__nfet_01v8 ad=3.192n pd=0.244m as=1.848n ps=0.128m w=84 l=15
X838 a_n2069_n919# control_logic_rw_0.pdriver_0_0.pinv_4_0.A a_n2147_n919# din0[1] sky130_fd_pr__nfet_01v8 ad=1.596n pd=0.16m as=1.323n ps=0.105m w=42 l=15
X839 a_3797_11101# din0[1] a_3743_11101# w_2422_10805# sky130_fd_pr__pfet_01v8 ad=3.192n pd=0.244m as=3.276n ps=0.246m w=84 l=15
X840 din0[1] bank_0.replica_bitcell_array_0.wl_0_15 bank_0.replica_bitcell_array_0.bitcell_array_0.cell_1rw_0.qb din0[1] sky130_fd_pr__nfet_01v8 ad=1.428n pd=0.152m as=3.864n ps=0.21m w=42 l=15
X841 bank_0.replica_bitcell_array_0.dummy_array_1_0.dummy_cell_1rw_1.qb din0[1] a_5010_2493# din0[1] sky130_fd_pr__nfet_01v8 ad=3.864n pd=0.21m as=1.428n ps=0.152m w=42 l=15
X842 bank_0.replica_bitcell_array_0.dummy_array_3_0.dummy_cell_1rw_6.q bank_0.replica_bitcell_array_0.dummy_array_3_0.dummy_cell_1rw_6.qb din0[1] din0[1] sky130_fd_pr__nfet_01v8 ad=3.864n pd=0.21m as=4.41n ps=0.322m w=126 l=15
X843 a_n363_n919# control_logic_rw_0.pdriver_0_0.pinv_7_0.A a_n441_n919# din0[1] sky130_fd_pr__nfet_01v8 ad=2.166n pd=0.19m as=1.795n ps=0.12m w=57 l=15
X844 data_dff_0.dff_1.net3 data_dff_0.dff_1.net1 din0[1] din0[1] sky130_fd_pr__pfet_01v8 ad=3.465n pd=0.236m as=2.2n ps=0.135m w=55 l=15
X845 a_n2402_1923# control_logic_rw_0.dff_buf_array_0.dout_bar_0 a_n2461_1923# w_n2769_1669# sky130_fd_pr__pfet_01v8 ad=1.848n pd=0.128m as=1.848n ps=0.128m w=84 l=15
X846 bank_0.replica_bitcell_array_0.replica_column_0.replica_cell_1rw_5.q din0[1] din0[1] din0[1] sky130_fd_pr__nfet_01v8 ad=3.864n pd=0.21m as=4.41n ps=0.322m w=126 l=15
X847 bank_0.replica_bitcell_array_0.dummy_array_3_0.dummy_cell_1rw_8.qb bank_0.replica_bitcell_array_0.wl_0_8 a_5530_7583# din0[1] sky130_fd_pr__nfet_01v8 ad=3.864n pd=0.21m as=1.428n ps=0.152m w=42 l=15
X848 a_2789_7391# bank_0.port_address_0.hierarchical_decoder_0.predecode_5 bank_0.port_address_0.hierarchical_decoder_0.and2_dec_8.pnand2_0.nmos_m1_w0_840_sactive_dli_0.S din0[1] sky130_fd_pr__nfet_01v8 ad=3.192n pd=0.244m as=1.848n ps=0.128m w=84 l=15
X849 bank_0.replica_bitcell_array_0.bitcell_array_0.cell_1rw_4.q bank_0.replica_bitcell_array_0.bitcell_array_0.cell_1rw_4.qb din0[1] din0[1] sky130_fd_pr__nfet_01v8 ad=3.864n pd=0.21m as=4.41n ps=0.322m w=126 l=15
X850 a_n4113_5809# control_logic_rw_0.delay_chain_0.pinv_11_29.Z a_n4166_5809# din0[1] sky130_fd_pr__nfet_01v8 ad=1.638n pd=0.162m as=1.596n ps=0.16m w=42 l=15
X851 bank_0.port_address_0.hierarchical_decoder_0.and2_dec_13.pnand2_0.nmos_m1_w0_840_sactive_dli_0.S bank_0.port_address_0.hierarchical_decoder_0.predecode_2 a_2676_4485# din0[1] sky130_fd_pr__nfet_01v8 ad=1.848n pd=0.128m as=3.276n ps=0.246m w=84 l=15
X852 bank_0.port_address_0.hierarchical_decoder_0.hierarchical_predecode2x4_1.and2_dec_2.pnand2_0.nmos_m1_w0_840_sactive_dli_0.S din0[1] a_1395_4337# din0[1] sky130_fd_pr__nfet_01v8 ad=1.848n pd=0.128m as=3.276n ps=0.246m w=84 l=15
X853 a_3483_8919# control_logic_rw_0.wl_en a_3424_8919# w_2422_8769# sky130_fd_pr__pfet_01v8 ad=3.192n pd=0.244m as=1.848n ps=0.128m w=84 l=15
X854 a_3797_8451# din0[1] a_3743_8451# din0[1] sky130_fd_pr__nfet_01v8 ad=1.596n pd=0.16m as=1.638n ps=0.162m w=42 l=15
X855 a_3103_7901# din0[1] a_3049_7901# w_2422_7751# sky130_fd_pr__pfet_01v8 ad=3.192n pd=0.244m as=3.276n ps=0.246m w=84 l=15
X856 din0[1] bank_0.replica_bitcell_array_0.wl_0_8 din0[1] din0[1] sky130_fd_pr__nfet_01v8 ad=3.864n pd=0.21m as=0 ps=0 w=42 l=15
X857 control_logic_rw_0.dff_buf_array_0.dff_buf_0_0.dff_0.net4 control_logic_rw_0.dff_buf_array_0.dff_buf_0_0.dff_0.clkb control_logic_rw_0.dff_buf_array_0.dff_buf_0_0.dff_0.net3 din0[1] sky130_fd_pr__pfet_01v8 ad=2.915n pd=0.161m as=3.52n ps=0.238m w=55 l=15
X858 bank_0.replica_bitcell_array_0.bitcell_array_0.cell_1rw_27.qb bank_0.replica_bitcell_array_0.wl_0_4 din0[1] din0[1] sky130_fd_pr__nfet_01v8 ad=3.864n pd=0.21m as=1.428n ps=0.152m w=42 l=15
X859 row_addr_dff_0.dff_3.clkb row_addr_dff_0.dff_3.clk din0[1] din0[1] sky130_fd_pr__nfet_01v8 ad=1.932n pd=0.176m as=1.932n ps=0.176m w=42 l=15
X860 bank_0.replica_bitcell_array_0.dummy_array_2_0.dummy_cell_1rw_5.q bank_0.replica_bitcell_array_0.dummy_array_2_0.dummy_cell_1rw_5.qb din0[1] din0[1] sky130_fd_pr__nfet_01v8 ad=3.864n pd=0.21m as=4.41n ps=0.322m w=126 l=15
X861 din0[1] bank_0.replica_bitcell_array_0.bitcell_array_0.cell_1rw_7.q bank_0.replica_bitcell_array_0.bitcell_array_0.cell_1rw_7.qb din0[1] sky130_fd_pr__pfet_01v8 ad=1.925n pd=0.18m as=1.925n ps=0.18m w=55 l=15
X862 a_n4741_4023# control_logic_rw_0.delay_chain_0.pinv_11_39.Z a_n4794_4023# din0[1] sky130_fd_pr__nfet_01v8 ad=1.638n pd=0.162m as=1.596n ps=0.16m w=42 l=15
X863 data_dff_0.dff_1.net3 data_dff_0.dff_1.net1 din0[1] din0[1] sky130_fd_pr__nfet_01v8 ad=2.604n pd=0.208m as=1.68n ps=0.122m w=42 l=15
X864 din0[1] bank_0.replica_bitcell_array_0.bitcell_array_0.cell_1rw_3.q bank_0.replica_bitcell_array_0.bitcell_array_0.cell_1rw_3.qb din0[1] sky130_fd_pr__nfet_01v8 ad=4.41n pd=0.322m as=3.864n ps=0.21m w=126 l=15
X865 din0[1] bank_0.replica_bitcell_array_0.bitcell_array_0.cell_1rw_8.q bank_0.replica_bitcell_array_0.bitcell_array_0.cell_1rw_8.qb din0[1] sky130_fd_pr__nfet_01v8 ad=4.41n pd=0.322m as=3.864n ps=0.21m w=126 l=15
X866 din0[1] din0[1] din0[1] din0[1] sky130_fd_pr__nfet_01v8 ad=4.2n pd=0.268m as=0 ps=0 w=84 l=15
X867 a_5313_1928# control_logic_rw_0.p_en_bar a_5259_1928# w_4605_1519# sky130_fd_pr__pfet_01v8 ad=1.848n pd=0.128m as=3.276n ps=0.246m w=84 l=15
X868 bank_0.port_address_0.hierarchical_decoder_0.hierarchical_predecode2x4_0.and2_dec_2.pnand2_0.nmos_m1_w0_840_sactive_dli_0.S row_addr_dff_0.dout_2 a_1395_7391# din0[1] sky130_fd_pr__nfet_01v8 ad=1.848n pd=0.128m as=3.276n ps=0.246m w=84 l=15
X869 a_3797_5503# din0[1] a_3743_5503# din0[1] sky130_fd_pr__nfet_01v8 ad=1.596n pd=0.16m as=1.638n ps=0.162m w=42 l=15
X870 a_n675_n691# control_logic_rw_0.pdriver_0_0.pinv_7_0.A a_n753_n691# w_n2769_n767# sky130_fd_pr__pfet_01v8 ad=3.622n pd=0.178m as=3.622n ps=0.178m w=115 l=15
X871 din0[1] bank_0.replica_bitcell_array_0.bitcell_array_0.cell_1rw_16.q bank_0.replica_bitcell_array_0.bitcell_array_0.cell_1rw_16.qb din0[1] sky130_fd_pr__pfet_01v8 ad=1.925n pd=0.18m as=1.925n ps=0.18m w=55 l=15
X872 bank_0.replica_bitcell_array_0.dummy_array_2_0.dummy_cell_1rw_2.q bank_0.replica_bitcell_array_0.dummy_array_2_0.dummy_cell_1rw_2.qb din0[1] din0[1] sky130_fd_pr__pfet_01v8 ad=1.925n pd=0.18m as=1.925n ps=0.18m w=55 l=15
X873 din0[1] bank_0.replica_bitcell_array_0.dummy_array_2_0.dummy_cell_1rw_8.q bank_0.replica_bitcell_array_0.dummy_array_2_0.dummy_cell_1rw_8.qb din0[1] sky130_fd_pr__pfet_01v8 ad=1.925n pd=0.18m as=1.925n ps=0.18m w=55 l=15
X874 a_5530_10451# bank_0.replica_bitcell_array_0.wl_0_13 bank_0.replica_bitcell_array_0.dummy_array_3_0.dummy_cell_1rw_3.qb din0[1] sky130_fd_pr__nfet_01v8 ad=1.428n pd=0.152m as=3.864n ps=0.21m w=42 l=15
X875 din0[1] bank_0.replica_bitcell_array_0.dummy_array_2_0.dummy_cell_1rw_4.q bank_0.replica_bitcell_array_0.dummy_array_2_0.dummy_cell_1rw_4.qb din0[1] sky130_fd_pr__nfet_01v8 ad=4.41n pd=0.322m as=3.864n ps=0.21m w=126 l=15
X876 bank_0.port_address_0.wordline_driver_array_0.wordline_driver_9.pnand2_0.nmos_m1_w0_840_sactive_dli_0.S bank_0.port_address_0.wordline_driver_array_0.in_6 a_3370_6521# din0[1] sky130_fd_pr__nfet_01v8 ad=1.848n pd=0.128m as=3.276n ps=0.246m w=84 l=15
X877 din0[1] bank_0.replica_bitcell_array_0.dummy_array_2_0.dummy_cell_1rw_9.q bank_0.replica_bitcell_array_0.dummy_array_2_0.dummy_cell_1rw_9.qb din0[1] sky130_fd_pr__nfet_01v8 ad=4.41n pd=0.322m as=3.864n ps=0.21m w=126 l=15
X878 bank_0.port_address_0.wordline_driver_array_0.wordline_driver_1.pnand2_0.nmos_m1_w0_840_sactive_dli_0.S bank_0.port_address_0.wordline_driver_array_0.in_14 a_3370_10593# din0[1] sky130_fd_pr__nfet_01v8 ad=1.848n pd=0.128m as=3.276n ps=0.246m w=84 l=15
X879 row_addr_dff_0.dout_1 row_addr_dff_0.dff_2.net4 din0[1] din0[1] sky130_fd_pr__nfet_01v8 ad=1.68n pd=0.164m as=1.68n ps=0.122m w=42 l=15
X880 bank_0.replica_bitcell_array_0.dummy_array_2_0.dummy_cell_1rw_3.q bank_0.replica_bitcell_array_0.dummy_array_2_0.dummy_cell_1rw_3.qb din0[1] din0[1] sky130_fd_pr__pfet_01v8 ad=1.925n pd=0.18m as=1.925n ps=0.18m w=55 l=15
X881 a_3103_4993# din0[1] a_3049_4993# w_2422_4697# sky130_fd_pr__pfet_01v8 ad=3.192n pd=0.244m as=3.276n ps=0.246m w=84 l=15
X882 a_n5055_4129# control_logic_rw_0.delay_chain_0.pinv_11_34.Z a_n5108_4129# din0[1] sky130_fd_pr__nfet_01v8 ad=1.638n pd=0.162m as=1.596n ps=0.16m w=42 l=15
X883 a_n1529_927# control_logic_rw_0.dff_buf_array_0.dout_bar_0 a_n1607_927# w_n2769_857# sky130_fd_pr__pfet_01v8 ad=4.56n pd=0.316m as=3.78n ps=0.183m w=120 l=15
X884 row_addr_dff_0.dff_0.clkb row_addr_dff_0.dff_3.clk din0[1] din0[1] sky130_fd_pr__nfet_01v8 ad=1.932n pd=0.176m as=1.932n ps=0.176m w=42 l=15
X885 a_n3447_n919# control_logic_rw_0.dff_buf_array_0.dout_bar_0 a_n3525_n919# din0[1] sky130_fd_pr__nfet_01v8 ad=1.764n pd=0.119m as=1.764n ps=0.119m w=56 l=15
X886 a_n1822_123# control_logic_rw_0.dff_buf_array_0.dout_bar_0 a_n1900_123# w_n2769_44# sky130_fd_pr__pfet_01v8 ad=3.528n pd=0.175m as=3.528n ps=0.175m w=112 l=15
X887 din0[1] bank_0.replica_bitcell_array_0.bitcell_array_0.cell_1rw_17.q bank_0.replica_bitcell_array_0.bitcell_array_0.cell_1rw_17.qb din0[1] sky130_fd_pr__pfet_01v8 ad=1.925n pd=0.18m as=1.925n ps=0.18m w=55 l=15
X888 a_n1143_298# control_logic_rw_0.pdriver_1_0.pinv_6_0.A a_n1221_298# w_n2769_44# sky130_fd_pr__pfet_01v8 ad=3.99n pd=0.286m as=3.307n ps=0.168m w=105 l=15
X889 bank_0.replica_bitcell_array_0.dummy_array_1_0.dummy_cell_1rw_0.q bank_0.replica_bitcell_array_0.dummy_array_1_0.dummy_cell_1rw_0.qb din0[1] din0[1] sky130_fd_pr__nfet_01v8 ad=3.864n pd=0.21m as=4.41n ps=0.322m w=126 l=15
X890 a_n3447_n513# control_logic_rw_0.dff_buf_array_0.dout_bar_0 a_n3525_n513# w_n4225_n767# sky130_fd_pr__pfet_01v8 ad=3.528n pd=0.175m as=3.528n ps=0.175m w=112 l=15
X891 din0[1] din0[1] din0[1] din0[1] sky130_fd_pr__nfet_01v8 ad=1.597n pd=0.134m as=0 ps=0 w=54 l=15
X892 bank_0.replica_bitcell_array_0.dummy_array_0_0.dummy_cell_1rw_0.q bank_0.replica_bitcell_array_0.dummy_array_0_0.dummy_cell_1rw_0.qb din0[1] din0[1] sky130_fd_pr__pfet_01v8 ad=1.925n pd=0.18m as=1.925n ps=0.18m w=55 l=15
X893 din0[1] bank_0.replica_bitcell_array_0.bitcell_array_0.cell_1rw_14.q bank_0.replica_bitcell_array_0.bitcell_array_0.cell_1rw_14.qb din0[1] sky130_fd_pr__pfet_01v8 ad=1.925n pd=0.18m as=1.925n ps=0.18m w=55 l=15
X894 bank_0.replica_bitcell_array_0.dummy_array_1_0.dummy_cell_1rw_1.q bank_0.replica_bitcell_array_0.dummy_array_1_0.dummy_cell_1rw_1.qb din0[1] din0[1] sky130_fd_pr__pfet_01v8 ad=1.925n pd=0.18m as=1.925n ps=0.18m w=55 l=15
X895 a_n2088_n464# control_logic_rw_0.pand2_1.pnand2_0_0.nmos_m1_w0_840_sactive_dli_0.G a_n2104_n464# w_n2769_n767# sky130_fd_pr__pfet_01v8 ad=17p pd=36u as=17p ps=36u w=17 l=15
X896 bank_0.replica_bitcell_array_0.dummy_array_3_0.dummy_cell_1rw_1.q bank_0.replica_bitcell_array_0.dummy_array_3_0.dummy_cell_1rw_1.qb din0[1] din0[1] sky130_fd_pr__pfet_01v8 ad=1.925n pd=0.18m as=1.925n ps=0.18m w=55 l=15
X897 bank_0.replica_bitcell_array_0.bitcell_array_0.cell_1rw_5.q bank_0.replica_bitcell_array_0.wl_0_10 din0[1] din0[1] sky130_fd_pr__nfet_01v8 ad=3.864n pd=0.21m as=1.428n ps=0.152m w=42 l=15
X898 bank_0.replica_bitcell_array_0.dummy_array_2_0.dummy_cell_1rw_18.q bank_0.replica_bitcell_array_0.dummy_array_2_0.dummy_cell_1rw_18.qb din0[1] din0[1] sky130_fd_pr__nfet_01v8 ad=3.864n pd=0.21m as=4.41n ps=0.322m w=126 l=15
X899 din0[1] bank_0.replica_bitcell_array_0.wl_0_9 bank_0.replica_bitcell_array_0.bitcell_array_0.cell_1rw_6.qb din0[1] sky130_fd_pr__nfet_01v8 ad=1.428n pd=0.152m as=3.864n ps=0.21m w=42 l=15
X900 a_1508_6521# bank_0.port_address_0.hierarchical_decoder_0.hierarchical_predecode2x4_0.pinv_0.Z bank_0.port_address_0.hierarchical_decoder_0.hierarchical_predecode2x4_0.and2_dec_3.pnand2_0.nmos_m1_w0_840_sactive_dli_0.S din0[1] sky130_fd_pr__nfet_01v8 ad=3.192n pd=0.244m as=1.848n ps=0.128m w=84 l=15
X901 din0[1] data_dff_0.dff_1.clkb data_dff_0.dff_1.net3 din0[1] sky130_fd_pr__pfet_01v8 ad=2.915n pd=0.161m as=3.52n ps=0.238m w=55 l=15
X902 a_n1919_1923# control_logic_rw_0.dff_buf_array_0.dout_1 a_n1997_1923# w_n2769_1669# sky130_fd_pr__pfet_01v8 ad=3.192n pd=0.244m as=2.646n ps=0.147m w=84 l=15
X903 din0[1] bank_0.replica_bitcell_array_0.dummy_array_2_0.dummy_cell_1rw_15.q bank_0.replica_bitcell_array_0.dummy_array_2_0.dummy_cell_1rw_15.qb din0[1] sky130_fd_pr__pfet_01v8 ad=1.925n pd=0.18m as=1.925n ps=0.18m w=55 l=15
X904 din0[1] bank_0.replica_bitcell_array_0.wl_0_15 din0[1] din0[1] sky130_fd_pr__nfet_01v8 ad=1.428n pd=0.152m as=0 ps=0 w=42 l=15
X905 a_2789_10955# bank_0.port_address_0.hierarchical_decoder_0.predecode_7 a_2730_10955# w_2422_10805# sky130_fd_pr__pfet_01v8 ad=3.192n pd=0.244m as=1.848n ps=0.128m w=84 l=15
X906 a_3483_8409# control_logic_rw_0.wl_en bank_0.port_address_0.wordline_driver_array_0.wordline_driver_6.pnand2_0.nmos_m1_w0_840_sactive_dli_0.S din0[1] sky130_fd_pr__nfet_01v8 ad=3.192n pd=0.244m as=1.848n ps=0.128m w=84 l=15
X907 a_n1430_n513# control_logic_rw_0.dff_buf_array_0.dout_bar_0 a_n1508_n513# w_n2769_n767# sky130_fd_pr__pfet_01v8 ad=3.528n pd=0.175m as=3.528n ps=0.175m w=112 l=15
X908 a_3103_9937# din0[1] a_3049_9937# w_2422_9787# sky130_fd_pr__pfet_01v8 ad=3.192n pd=0.244m as=3.276n ps=0.246m w=84 l=15
X909 bank_0.replica_bitcell_array_0.dummy_array_2_0.dummy_cell_1rw_6.q bank_0.replica_bitcell_array_0.wl_0_10 a_4421_8601# din0[1] sky130_fd_pr__nfet_01v8 ad=3.864n pd=0.21m as=1.428n ps=0.152m w=42 l=15
X910 a_4490_8415# bank_0.replica_bitcell_array_0.wl_0_9 bank_0.replica_bitcell_array_0.dummy_array_2_0.dummy_cell_1rw_7.qb din0[1] sky130_fd_pr__nfet_01v8 ad=1.428n pd=0.152m as=3.864n ps=0.21m w=42 l=15
X911 a_3424_7029# bank_0.port_address_0.wordline_driver_array_0.in_7 a_3370_7029# w_2422_6733# sky130_fd_pr__pfet_01v8 ad=1.848n pd=0.128m as=3.276n ps=0.246m w=84 l=15
X912 control_logic_rw_0.dff_buf_array_0.dff_buf_0_1.dff_0.net3 control_logic_rw_0.dff_buf_array_0.dff_buf_0_1.dff_0.net1 din0[1] din0[1] sky130_fd_pr__pfet_01v8 ad=3.465n pd=0.236m as=2.2n ps=0.135m w=55 l=15
X913 bank_0.replica_bitcell_array_0.bitcell_array_0.cell_1rw_27.q bank_0.replica_bitcell_array_0.bitcell_array_0.cell_1rw_27.qb din0[1] din0[1] sky130_fd_pr__pfet_01v8 ad=1.925n pd=0.18m as=1.925n ps=0.18m w=55 l=15
X914 din0[1] bank_0.replica_bitcell_array_0.bitcell_array_0.cell_1rw_28.q bank_0.replica_bitcell_array_0.bitcell_array_0.cell_1rw_28.qb din0[1] sky130_fd_pr__pfet_01v8 ad=1.925n pd=0.18m as=1.925n ps=0.18m w=55 l=15
X915 row_addr_dff_0.dff_3.net4 row_addr_dff_0.dff_3.clk row_addr_dff_0.dff_3.net3 din0[1] sky130_fd_pr__nfet_01v8 ad=2.226n pd=0.148m as=2.73n ps=0.214m w=42 l=15
X916 bank_0.replica_bitcell_array_0.dummy_array_3_0.dummy_cell_1rw_6.q bank_0.replica_bitcell_array_0.dummy_array_3_0.dummy_cell_1rw_6.qb din0[1] din0[1] sky130_fd_pr__pfet_01v8 ad=1.925n pd=0.18m as=1.925n ps=0.18m w=55 l=15
X917 bank_0.replica_bitcell_array_0.bitcell_array_0.cell_1rw_13.qb bank_0.replica_bitcell_array_0.wl_0_2 din0[1] din0[1] sky130_fd_pr__nfet_01v8 ad=3.864n pd=0.21m as=1.428n ps=0.152m w=42 l=15
X918 din0[1] bank_0.replica_bitcell_array_0.bitcell_array_0.cell_1rw_3.q bank_0.replica_bitcell_array_0.bitcell_array_0.cell_1rw_3.qb din0[1] sky130_fd_pr__pfet_01v8 ad=1.925n pd=0.18m as=1.925n ps=0.18m w=55 l=15
X919 din0[1] bank_0.replica_bitcell_array_0.replica_column_0.replica_cell_1rw_5.q din0[1] din0[1] sky130_fd_pr__nfet_01v8 ad=3.864n pd=0.21m as=0 ps=0 w=126 l=15
X920 a_n909_n919# control_logic_rw_0.pdriver_0_0.pinv_7_0.A a_n987_n919# din0[1] sky130_fd_pr__nfet_01v8 ad=1.795n pd=0.12m as=1.795n ps=0.12m w=57 l=15
X921 din0[1] din0[1] data_dff_0.dff_1.net3 din0[1] sky130_fd_pr__nfet_01v8 ad=2.226n pd=0.148m as=2.73n ps=0.214m w=42 l=15
X922 din0[1] din0[1] din0[1] din0[1] sky130_fd_pr__nfet_01v8 ad=1.89n pd=0.174m as=0 ps=0 w=42 l=27
X923 a_3483_11463# control_logic_rw_0.wl_en bank_0.port_address_0.wordline_driver_array_0.wordline_driver_0.pnand2_0.nmos_m1_w0_840_sactive_dli_0.S din0[1] sky130_fd_pr__nfet_01v8 ad=3.192n pd=0.244m as=1.848n ps=0.128m w=84 l=15
X924 din0[1] bank_0.replica_bitcell_array_0.replica_column_0.replica_cell_1rw_2.q din0[1] din0[1] sky130_fd_pr__pfet_01v8 ad=1.925n pd=0.18m as=0 ps=0 w=55 l=15
X925 a_1822_8451# din0[1] a_1768_8451# din0[1] sky130_fd_pr__nfet_01v8 ad=1.596n pd=0.16m as=1.638n ps=0.162m w=42 l=15
X926 bank_0.replica_bitcell_array_0.bitcell_array_0.cell_1rw_28.q bank_0.replica_bitcell_array_0.bitcell_array_0.cell_1rw_28.qb din0[1] din0[1] sky130_fd_pr__pfet_01v8 ad=1.925n pd=0.18m as=1.925n ps=0.18m w=55 l=15
X927 din0[1] bank_0.replica_bitcell_array_0.bitcell_array_0.cell_1rw_4.q bank_0.replica_bitcell_array_0.bitcell_array_0.cell_1rw_4.qb din0[1] sky130_fd_pr__nfet_01v8 ad=4.41n pd=0.322m as=3.864n ps=0.21m w=126 l=15
X928 a_3797_9065# din0[1] a_3743_9065# w_2422_8769# sky130_fd_pr__pfet_01v8 ad=3.192n pd=0.244m as=3.276n ps=0.246m w=84 l=15
X929 bank_0.replica_bitcell_array_0.replica_column_0.replica_cell_1rw_5.q din0[1] din0[1] din0[1] sky130_fd_pr__pfet_01v8 ad=1.925n pd=0.18m as=1.925n ps=0.18m w=55 l=15
X930 a_3797_7539# din0[1] a_3743_7539# din0[1] sky130_fd_pr__nfet_01v8 ad=1.596n pd=0.16m as=1.638n ps=0.162m w=42 l=15
X931 din0[1] bank_0.replica_bitcell_array_0.dummy_array_3_0.dummy_cell_1rw_11.q bank_0.replica_bitcell_array_0.dummy_array_3_0.dummy_cell_1rw_11.qb din0[1] sky130_fd_pr__nfet_01v8 ad=4.41n pd=0.322m as=3.864n ps=0.21m w=126 l=15
X932 bank_0.replica_bitcell_array_0.dummy_array_2_0.dummy_cell_1rw_14.qb bank_0.replica_bitcell_array_0.wl_0_2 a_4490_4529# din0[1] sky130_fd_pr__nfet_01v8 ad=3.864n pd=0.21m as=1.428n ps=0.152m w=42 l=15
X933 a_5201_3325# bank_0.replica_bitcell_array_0.rbl_wl_0_0 bank_0.replica_bitcell_array_0.dummy_array_0.dummy_cell_1rw_0.q din0[1] sky130_fd_pr__nfet_01v8 ad=1.428n pd=0.152m as=3.864n ps=0.21m w=42 l=15
X934 bank_0.replica_bitcell_array_0.dummy_array_3_0.dummy_cell_1rw_2.q bank_0.replica_bitcell_array_0.dummy_array_3_0.dummy_cell_1rw_2.qb din0[1] din0[1] sky130_fd_pr__nfet_01v8 ad=3.864n pd=0.21m as=4.41n ps=0.322m w=126 l=15
X935 din0[1] bank_0.replica_bitcell_array_0.dummy_array_2_0.dummy_cell_1rw_4.q bank_0.replica_bitcell_array_0.dummy_array_2_0.dummy_cell_1rw_4.qb din0[1] sky130_fd_pr__pfet_01v8 ad=1.925n pd=0.18m as=1.925n ps=0.18m w=55 l=15
X936 a_3797_4847# din0[1] a_3743_4847# w_2422_4697# sky130_fd_pr__pfet_01v8 ad=3.192n pd=0.244m as=3.276n ps=0.246m w=84 l=15
X937 a_n4427_4023# control_logic_rw_0.delay_chain_0.pinv_11_39.Z a_n4480_4023# din0[1] sky130_fd_pr__nfet_01v8 ad=1.638n pd=0.162m as=1.596n ps=0.16m w=42 l=15
X938 control_logic_rw_0.dff_buf_array_0.dff_buf_0_1.dff_0.net3 control_logic_rw_0.dff_buf_array_0.dff_buf_0_1.dff_0.net1 din0[1] din0[1] sky130_fd_pr__nfet_01v8 ad=2.604n pd=0.208m as=1.68n ps=0.122m w=42 l=15
X939 bank_0.port_address_0.wordline_driver_array_0.wordline_driver_5.pnand2_0.nmos_m1_w0_840_sactive_dli_0.S bank_0.port_address_0.wordline_driver_array_0.in_10 a_3370_8557# din0[1] sky130_fd_pr__nfet_01v8 ad=1.848n pd=0.128m as=3.276n ps=0.246m w=84 l=15
X940 a_5530_4343# bank_0.replica_bitcell_array_0.wl_0_1 bank_0.replica_bitcell_array_0.dummy_array_3_0.dummy_cell_1rw_15.qb din0[1] sky130_fd_pr__nfet_01v8 ad=1.428n pd=0.152m as=3.864n ps=0.21m w=42 l=15
X941 din0[1] bank_0.replica_bitcell_array_0.dummy_array_2_0.dummy_cell_1rw_5.q bank_0.replica_bitcell_array_0.dummy_array_2_0.dummy_cell_1rw_5.qb din0[1] sky130_fd_pr__nfet_01v8 ad=4.41n pd=0.322m as=3.864n ps=0.21m w=126 l=15
X942 a_3424_5865# bank_0.port_address_0.wordline_driver_array_0.in_4 a_3370_5865# w_2422_5715# sky130_fd_pr__pfet_01v8 ad=1.848n pd=0.128m as=3.276n ps=0.246m w=84 l=15
X943 a_2789_3975# bank_0.port_address_0.hierarchical_decoder_0.predecode_4 a_2730_3975# w_2422_3679# sky130_fd_pr__pfet_01v8 ad=3.192n pd=0.244m as=1.848n ps=0.128m w=84 l=15
X944 din0[1] din0[1] din0[1] din0[1] sky130_fd_pr__nfet_01v8 ad=2.751n pd=0.165m as=0 ps=0 w=42 l=15
X945 a_4421_3325# bank_0.replica_bitcell_array_0.rbl_wl_0_0 bank_0.replica_bitcell_array_0.dummy_array_2_0.dummy_cell_1rw_17.q din0[1] sky130_fd_pr__nfet_01v8 ad=1.428n pd=0.152m as=3.864n ps=0.21m w=42 l=15
X946 din0[1] bank_0.replica_bitcell_array_0.wl_0_1 din0[1] din0[1] sky130_fd_pr__nfet_01v8 ad=1.428n pd=0.152m as=0 ps=0 w=42 l=15
X947 din0[1] bank_0.replica_bitcell_array_0.dummy_array_2_0.dummy_cell_1rw_1.q bank_0.replica_bitcell_array_0.dummy_array_2_0.dummy_cell_1rw_1.qb din0[1] sky130_fd_pr__pfet_01v8 ad=1.925n pd=0.18m as=1.925n ps=0.18m w=55 l=15
X948 a_1508_7029# bank_0.port_address_0.hierarchical_decoder_0.hierarchical_predecode2x4_0.pinv_0.Z a_1449_7029# w_1141_6733# sky130_fd_pr__pfet_01v8 ad=3.192n pd=0.244m as=1.848n ps=0.128m w=84 l=15
X949 a_n2147_599# control_logic_rw_0.pdriver_1_0.pinv_8_0.A a_n2201_599# din0[1] sky130_fd_pr__nfet_01v8 ad=1.596n pd=0.16m as=1.638n ps=0.162m w=42 l=15
X950 row_addr_dff_0.dff_0.net4 row_addr_dff_0.dff_3.clk row_addr_dff_0.dff_0.net3 din0[1] sky130_fd_pr__nfet_01v8 ad=2.226n pd=0.148m as=2.73n ps=0.214m w=42 l=15
X951 a_n5055_8329# control_logic_rw_0.delay_chain_0.pinv_11_9.Z a_n5108_8329# w_n5644_7860# sky130_fd_pr__pfet_01v8 ad=3.276n pd=0.246m as=3.192n ps=0.244m w=84 l=15
X952 din0[1] bank_0.replica_bitcell_array_0.wl_0_9 bank_0.replica_bitcell_array_0.bitcell_array_0.cell_1rw_22.q din0[1] sky130_fd_pr__nfet_01v8 ad=1.428n pd=0.152m as=3.864n ps=0.21m w=42 l=15
X953 bank_0.replica_bitcell_array_0.bitcell_array_0.cell_1rw_22.q bank_0.replica_bitcell_array_0.bitcell_array_0.cell_1rw_22.qb din0[1] din0[1] sky130_fd_pr__pfet_01v8 ad=1.925n pd=0.18m as=1.925n ps=0.18m w=55 l=15
X954 din0[1] bank_0.replica_bitcell_array_0.dummy_array_3_0.dummy_cell_1rw_1.q bank_0.replica_bitcell_array_0.dummy_array_3_0.dummy_cell_1rw_1.qb din0[1] sky130_fd_pr__pfet_01v8 ad=1.925n pd=0.18m as=1.925n ps=0.18m w=55 l=15
X955 row_addr_dff_0.dff_2.clkb row_addr_dff_0.dff_3.clk din0[1] din0[1] sky130_fd_pr__nfet_01v8 ad=1.932n pd=0.176m as=1.932n ps=0.176m w=42 l=15
X956 a_4421_10451# bank_0.replica_bitcell_array_0.wl_0_13 bank_0.replica_bitcell_array_0.dummy_array_2_0.dummy_cell_1rw_3.q din0[1] sky130_fd_pr__nfet_01v8 ad=1.428n pd=0.152m as=3.864n ps=0.21m w=42 l=15
X957 bank_0.replica_bitcell_array_0.bitcell_array_0.cell_1rw_29.q bank_0.replica_bitcell_array_0.bitcell_array_0.cell_1rw_29.qb din0[1] din0[1] sky130_fd_pr__nfet_01v8 ad=3.864n pd=0.21m as=4.41n ps=0.322m w=126 l=15
X958 din0[1] din0[1] data_dff_0.dff_1.net5 din0[1] sky130_fd_pr__pfet_01v8 ad=2.302n pd=0.147m as=3.08n ps=0.222m w=55 l=15
X959 a_3103_3467# din0[1] a_3049_3467# din0[1] sky130_fd_pr__nfet_01v8 ad=1.596n pd=0.16m as=1.638n ps=0.162m w=42 l=15
X960 bank_0.replica_bitcell_array_0.bitcell_array_0.cell_1rw_0.q bank_0.replica_bitcell_array_0.bitcell_array_0.cell_1rw_0.qb din0[1] din0[1] sky130_fd_pr__nfet_01v8 ad=3.864n pd=0.21m as=4.41n ps=0.322m w=126 l=15
X961 a_5530_7397# bank_0.replica_bitcell_array_0.wl_0_7 bank_0.replica_bitcell_array_0.dummy_array_3_0.dummy_cell_1rw_9.qb din0[1] sky130_fd_pr__nfet_01v8 ad=1.428n pd=0.152m as=3.864n ps=0.21m w=42 l=15
X962 a_5461_10451# bank_0.replica_bitcell_array_0.wl_0_13 bank_0.replica_bitcell_array_0.dummy_array_3_0.dummy_cell_1rw_3.q din0[1] sky130_fd_pr__nfet_01v8 ad=1.428n pd=0.152m as=3.864n ps=0.21m w=42 l=15
X963 din0[1] control_logic_rw_0.dff_buf_array_0.dff_buf_0_1.dff_0.net3 control_logic_rw_0.dff_buf_array_0.dff_buf_0_1.dff_0.net2 din0[1] sky130_fd_pr__pfet_01v8 ad=2.2n pd=0.135m as=2.915n ps=0.216m w=55 l=15
X964 din0[1] bank_0.replica_bitcell_array_0.dummy_array_3_0.dummy_cell_1rw_17.q bank_0.replica_bitcell_array_0.dummy_array_3_0.dummy_cell_1rw_17.qb din0[1] sky130_fd_pr__pfet_01v8 ad=1.925n pd=0.18m as=1.925n ps=0.18m w=55 l=15
X965 din0[1] bank_0.replica_bitcell_array_0.dummy_array_2_0.dummy_cell_1rw_2.q bank_0.replica_bitcell_array_0.dummy_array_2_0.dummy_cell_1rw_2.qb din0[1] sky130_fd_pr__pfet_01v8 ad=1.925n pd=0.18m as=1.925n ps=0.18m w=55 l=15
X966 din0[1] bank_0.replica_bitcell_array_0.wl_0_7 din0[1] din0[1] sky130_fd_pr__nfet_01v8 ad=1.428n pd=0.152m as=0 ps=0 w=42 l=15
X967 bank_0.replica_bitcell_array_0.bitcell_array_0.cell_1rw_29.q bank_0.replica_bitcell_array_0.wl_0_2 din0[1] din0[1] sky130_fd_pr__nfet_01v8 ad=3.864n pd=0.21m as=1.428n ps=0.152m w=42 l=15
X968 a_1449_3975# din0[1] a_1395_3975# w_1141_3679# sky130_fd_pr__pfet_01v8 ad=1.848n pd=0.128m as=3.276n ps=0.246m w=84 l=15
X969 a_n1508_n227# control_logic_rw_0.dff_buf_array_0.dout_bar_0 a_n1586_n227# din0[1] sky130_fd_pr__nfet_01v8 ad=1.764n pd=0.119m as=1.764n ps=0.119m w=56 l=15
X970 a_n1919_927# control_logic_rw_0.dff_buf_array_0.dout_bar_0 a_n1997_927# w_n2769_857# sky130_fd_pr__pfet_01v8 ad=3.78n pd=0.183m as=3.78n ps=0.183m w=120 l=15
X971 row_addr_dff_0.dff_1.net2 row_addr_dff_0.dff_1.clkb row_addr_dff_0.dff_1.net1 din0[1] sky130_fd_pr__pfet_01v8 ad=3.74n pd=0.246m as=2.915n ps=0.161m w=55 l=15
X972 bank_0.replica_bitcell_array_0.dummy_array_3_0.dummy_cell_1rw_8.q bank_0.replica_bitcell_array_0.wl_0_8 a_5461_7583# din0[1] sky130_fd_pr__nfet_01v8 ad=3.864n pd=0.21m as=1.428n ps=0.152m w=42 l=15
X973 a_n2056_123# control_logic_rw_0.dff_buf_array_0.dout_bar_0 a_n2110_123# w_n2769_44# sky130_fd_pr__pfet_01v8 ad=3.528n pd=0.175m as=4.368n ps=0.302m w=112 l=15
X974 a_n2461_963# control_logic_rw_0.dff_buf_array_0.dout_bar_0 a_n2515_963# w_n2769_857# sky130_fd_pr__pfet_01v8 ad=1.848n pd=0.128m as=3.276n ps=0.246m w=84 l=15
X975 din0[1] bank_0.replica_bitcell_array_0.bitcell_array_0.cell_1rw_17.q bank_0.replica_bitcell_array_0.bitcell_array_0.cell_1rw_17.qb din0[1] sky130_fd_pr__nfet_01v8 ad=4.41n pd=0.322m as=3.864n ps=0.21m w=126 l=15
X976 a_2789_10445# bank_0.port_address_0.hierarchical_decoder_0.predecode_7 bank_0.port_address_0.hierarchical_decoder_0.and2_dec_2.pnand2_0.nmos_m1_w0_840_sactive_dli_0.S din0[1] sky130_fd_pr__nfet_01v8 ad=3.192n pd=0.244m as=1.848n ps=0.128m w=84 l=15
X977 a_2789_8919# bank_0.port_address_0.hierarchical_decoder_0.predecode_6 a_2730_8919# w_2422_8769# sky130_fd_pr__pfet_01v8 ad=3.192n pd=0.244m as=1.848n ps=0.128m w=84 l=15
X978 a_n1744_n107# control_logic_rw_0.dff_buf_array_0.dout_bar_0 a_n1822_n107# din0[1] sky130_fd_pr__nfet_01v8 ad=1.764n pd=0.119m as=1.764n ps=0.119m w=56 l=15
X979 a_n1723_299# control_logic_rw_0.pdriver_1_0.pinv_8_0.Z a_n1801_299# w_n2769_44# sky130_fd_pr__pfet_01v8 ad=3.192n pd=0.244m as=2.646n ps=0.147m w=84 l=15
X980 din0[1] bank_0.replica_bitcell_array_0.dummy_array_1_0.dummy_cell_1rw_0.q bank_0.replica_bitcell_array_0.dummy_array_1_0.dummy_cell_1rw_0.qb din0[1] sky130_fd_pr__nfet_01v8 ad=4.41n pd=0.322m as=3.864n ps=0.21m w=126 l=15
X981 bank_0.replica_bitcell_array_0.replica_column_0.dummy_cell_1rw_0.q bank_0.replica_bitcell_array_0.replica_column_0.dummy_cell_1rw_0.qb din0[1] din0[1] sky130_fd_pr__pfet_01v8 ad=1.925n pd=0.18m as=1.925n ps=0.18m w=55 l=15
X982 bank_0.replica_bitcell_array_0.dummy_array_2_0.dummy_cell_1rw_0.q bank_0.replica_bitcell_array_0.dummy_array_2_0.dummy_cell_1rw_0.qb din0[1] din0[1] sky130_fd_pr__nfet_01v8 ad=3.864n pd=0.21m as=4.41n ps=0.322m w=126 l=15
X983 din0[1] bank_0.replica_bitcell_array_0.dummy_array_3_0.dummy_cell_1rw_2.q bank_0.replica_bitcell_array_0.dummy_array_3_0.dummy_cell_1rw_2.qb din0[1] sky130_fd_pr__pfet_01v8 ad=1.925n pd=0.18m as=1.925n ps=0.18m w=55 l=15
X984 din0[1] din0[1] data_dff_0.dff_1.net5 din0[1] sky130_fd_pr__nfet_01v8 ad=1.782n pd=0.134m as=2.352n ps=0.196m w=42 l=15
X985 din0[1] bank_0.replica_bitcell_array_0.replica_column_0.replica_cell_1rw_16.q din0[1] din0[1] sky130_fd_pr__pfet_01v8 ad=1.925n pd=0.18m as=0 ps=0 w=55 l=15
X986 bank_0.replica_bitcell_array_0.dummy_array_1_0.dummy_cell_1rw_0.q bank_0.replica_bitcell_array_0.dummy_array_1_0.dummy_cell_1rw_0.qb din0[1] din0[1] sky130_fd_pr__pfet_01v8 ad=1.925n pd=0.18m as=1.925n ps=0.18m w=55 l=15
X987 bank_0.replica_bitcell_array_0.bitcell_array_0.cell_1rw_16.q bank_0.replica_bitcell_array_0.bitcell_array_0.cell_1rw_16.qb din0[1] din0[1] sky130_fd_pr__pfet_01v8 ad=1.925n pd=0.18m as=1.925n ps=0.18m w=55 l=15
X988 bank_0.replica_bitcell_array_0.replica_column_0.replica_cell_1rw_7.q bank_0.replica_bitcell_array_0.wl_0_8 din0[1] din0[1] sky130_fd_pr__nfet_01v8 ad=3.864n pd=0.21m as=1.428n ps=0.152m w=42 l=15
X989 a_n4113_3141# din0[1] a_n4166_3141# w_n5644_2820# sky130_fd_pr__pfet_01v8 ad=3.276n pd=0.246m as=3.192n ps=0.244m w=84 l=15
X990 bank_0.replica_bitcell_array_0.dummy_array_3_0.dummy_cell_1rw_7.q bank_0.replica_bitcell_array_0.dummy_array_3_0.dummy_cell_1rw_7.qb din0[1] din0[1] sky130_fd_pr__nfet_01v8 ad=3.864n pd=0.21m as=4.41n ps=0.322m w=126 l=15
X991 din0[1] bank_0.replica_bitcell_array_0.bitcell_array_0.cell_1rw_24.q bank_0.replica_bitcell_array_0.bitcell_array_0.cell_1rw_24.qb din0[1] sky130_fd_pr__pfet_01v8 ad=1.925n pd=0.18m as=1.925n ps=0.18m w=55 l=15
X992 din0[1] bank_0.replica_bitcell_array_0.dummy_array_2_0.dummy_cell_1rw_18.q bank_0.replica_bitcell_array_0.dummy_array_2_0.dummy_cell_1rw_18.qb din0[1] sky130_fd_pr__nfet_01v8 ad=4.41n pd=0.322m as=3.864n ps=0.21m w=126 l=15
X993 a_n5369_9063# control_logic_rw_0.delay_chain_0.pinv_11_9.Z a_n5422_9063# din0[1] sky130_fd_pr__nfet_01v8 ad=1.638n pd=0.162m as=1.596n ps=0.16m w=42 l=15
X994 bank_0.replica_bitcell_array_0.bitcell_array_0.cell_1rw_9.qb bank_0.replica_bitcell_array_0.wl_0_6 din0[1] din0[1] sky130_fd_pr__nfet_01v8 ad=3.864n pd=0.21m as=1.428n ps=0.152m w=42 l=15
X995 din0[1] control_logic_rw_0.dff_buf_array_0.dff_buf_0_1.dff_0.net3 control_logic_rw_0.dff_buf_array_0.dff_buf_0_1.dff_0.net2 din0[1] sky130_fd_pr__nfet_01v8 ad=1.68n pd=0.122m as=2.226n ps=0.19m w=42 l=15
X996 bank_0.replica_bitcell_array_0.dummy_array_2_0.dummy_cell_1rw_18.q bank_0.replica_bitcell_array_0.dummy_array_2_0.dummy_cell_1rw_18.qb din0[1] din0[1] sky130_fd_pr__pfet_01v8 ad=1.925n pd=0.18m as=1.925n ps=0.18m w=55 l=15
X997 bank_0.replica_bitcell_array_0.replica_column_0.replica_cell_1rw_6.q din0[1] din0[1] din0[1] sky130_fd_pr__nfet_01v8 ad=3.864n pd=0.21m as=4.41n ps=0.322m w=126 l=15
X998 bank_0.replica_bitcell_array_0.dummy_array_3_0.dummy_cell_1rw_15.q bank_0.replica_bitcell_array_0.dummy_array_3_0.dummy_cell_1rw_15.qb din0[1] din0[1] sky130_fd_pr__pfet_01v8 ad=1.925n pd=0.18m as=1.925n ps=0.18m w=55 l=15
X999 control_logic_rw_0.dff_buf_array_0.dff_buf_0_0.dff_0.net5 din0[1] control_logic_rw_0.dff_buf_array_0.dff_buf_0_0.dff_0.net4 din0[1] sky130_fd_pr__pfet_01v8 ad=4.345n pd=0.268m as=2.915n ps=0.161m w=55 l=15
X1000 bank_0.port_address_0.hierarchical_decoder_0.and2_dec_9.pnand2_0.nmos_m1_w0_840_sactive_dli_0.S bank_0.port_address_0.hierarchical_decoder_0.predecode_2 a_2676_6521# din0[1] sky130_fd_pr__nfet_01v8 ad=1.848n pd=0.128m as=3.276n ps=0.246m w=84 l=15
X1001 control_logic_rw_0.pand3_0_0.pnand3_0_0.nmos_m1_w0_840_sactive_dactive_0.D control_logic_rw_0.dff_buf_array_0.dout_bar_0 control_logic_rw_0.pand3_0_0.pnand3_0_0.nmos_m1_w0_840_sactive_dactive_0.S din0[1] sky130_fd_pr__nfet_01v8 ad=1.848n pd=0.128m as=1.848n ps=0.128m w=84 l=15
X1002 bank_0.replica_bitcell_array_0.dummy_array_3_0.dummy_cell_1rw_3.q bank_0.replica_bitcell_array_0.dummy_array_3_0.dummy_cell_1rw_3.qb din0[1] din0[1] sky130_fd_pr__nfet_01v8 ad=3.864n pd=0.21m as=4.41n ps=0.322m w=126 l=15
X1003 a_n4113_9861# control_logic_rw_0.delay_chain_0.pinv_11_9.Z a_n4166_9861# w_n5644_9540# sky130_fd_pr__pfet_01v8 ad=3.276n pd=0.246m as=3.192n ps=0.244m w=84 l=15
X1004 bank_0.replica_bitcell_array_0.dummy_array_2_0.dummy_cell_1rw_10.qb bank_0.replica_bitcell_array_0.wl_0_6 a_4490_6565# din0[1] sky130_fd_pr__nfet_01v8 ad=3.864n pd=0.21m as=1.428n ps=0.152m w=42 l=15
X1005 din0[1] bank_0.replica_bitcell_array_0.wl_0_3 bank_0.replica_bitcell_array_0.bitcell_array_0.cell_1rw_12.q din0[1] sky130_fd_pr__nfet_01v8 ad=1.428n pd=0.152m as=3.864n ps=0.21m w=42 l=15
X1006 din0[1] bank_0.replica_bitcell_array_0.wl_0_15 bank_0.replica_bitcell_array_0.replica_column_0.replica_cell_1rw_0.q din0[1] sky130_fd_pr__nfet_01v8 ad=1.428n pd=0.152m as=3.864n ps=0.21m w=42 l=15
X1007 bank_0.replica_bitcell_array_0.bitcell_array_0.cell_1rw_11.q bank_0.replica_bitcell_array_0.bitcell_array_0.cell_1rw_11.qb din0[1] din0[1] sky130_fd_pr__pfet_01v8 ad=1.925n pd=0.18m as=1.925n ps=0.18m w=55 l=15
X1008 bank_0.port_address_0.wordline_driver_array_0.wordline_driver_12.pnand2_0.nmos_m1_w0_840_sactive_dli_0.S bank_0.port_address_0.wordline_driver_array_0.in_3 a_3370_5355# din0[1] sky130_fd_pr__nfet_01v8 ad=1.848n pd=0.128m as=3.276n ps=0.246m w=84 l=15
X1009 bank_0.replica_bitcell_array_0.replica_column_0.replica_cell_1rw_14.q din0[1] din0[1] din0[1] sky130_fd_pr__pfet_01v8 ad=1.925n pd=0.18m as=1.925n ps=0.18m w=55 l=15
X1010 a_3424_11101# bank_0.port_address_0.wordline_driver_array_0.in_15 a_3370_11101# w_2422_10805# sky130_fd_pr__pfet_01v8 ad=1.848n pd=0.128m as=3.276n ps=0.246m w=84 l=15
X1011 din0[1] bank_0.replica_bitcell_array_0.bitcell_array_0.cell_1rw_25.q bank_0.replica_bitcell_array_0.bitcell_array_0.cell_1rw_25.qb din0[1] sky130_fd_pr__pfet_01v8 ad=1.925n pd=0.18m as=1.925n ps=0.18m w=55 l=15
X1012 a_4421_5361# bank_0.replica_bitcell_array_0.wl_0_3 bank_0.replica_bitcell_array_0.dummy_array_2_0.dummy_cell_1rw_13.q din0[1] sky130_fd_pr__nfet_01v8 ad=1.428n pd=0.152m as=3.864n ps=0.21m w=42 l=15
X1013 a_739_3975# row_addr_dff_0.dout_1 a_685_3975# w_431_3679# sky130_fd_pr__pfet_01v8 ad=3.192n pd=0.244m as=3.276n ps=0.246m w=84 l=15
X1014 bank_0.replica_bitcell_array_0.bitcell_array_0.cell_1rw_17.q bank_0.replica_bitcell_array_0.bitcell_array_0.cell_1rw_17.qb din0[1] din0[1] sky130_fd_pr__nfet_01v8 ad=3.864n pd=0.21m as=4.41n ps=0.322m w=126 l=15
X1015 din0[1] bank_0.replica_bitcell_array_0.bitcell_array_0.cell_1rw_21.q bank_0.replica_bitcell_array_0.bitcell_array_0.cell_1rw_21.qb din0[1] sky130_fd_pr__nfet_01v8 ad=4.41n pd=0.322m as=3.864n ps=0.21m w=126 l=15
X1016 a_1822_7539# din0[1] a_1768_7539# din0[1] sky130_fd_pr__nfet_01v8 ad=1.596n pd=0.16m as=1.638n ps=0.162m w=42 l=15
X1017 bank_0.replica_bitcell_array_0.dummy_array_2_0.dummy_cell_1rw_12.q bank_0.replica_bitcell_array_0.dummy_array_2_0.dummy_cell_1rw_12.qb din0[1] din0[1] sky130_fd_pr__pfet_01v8 ad=1.925n pd=0.18m as=1.925n ps=0.18m w=55 l=15
X1018 a_1822_4847# din0[1] a_1768_4847# w_1141_4697# sky130_fd_pr__pfet_01v8 ad=3.192n pd=0.244m as=3.276n ps=0.246m w=84 l=15
X1019 a_n4113_2449# din0[1] a_n4166_2449# din0[1] sky130_fd_pr__nfet_01v8 ad=1.638n pd=0.162m as=1.596n ps=0.16m w=42 l=15
X1020 din0[1] bank_0.replica_bitcell_array_0.replica_column_0.dummy_cell_1rw_0.q bank_0.replica_bitcell_array_0.replica_column_0.dummy_cell_1rw_0.qb din0[1] sky130_fd_pr__pfet_01v8 ad=1.925n pd=0.18m as=1.925n ps=0.18m w=55 l=15
X1021 bank_0.replica_bitcell_array_0.bitcell_array_0.cell_1rw_12.q bank_0.replica_bitcell_array_0.bitcell_array_0.cell_1rw_12.qb din0[1] din0[1] sky130_fd_pr__pfet_01v8 ad=1.925n pd=0.18m as=1.925n ps=0.18m w=55 l=15
X1022 row_addr_dff_0.dff_1.net3 row_addr_dff_0.dff_1.net1 din0[1] din0[1] sky130_fd_pr__nfet_01v8 ad=2.604n pd=0.208m as=1.68n ps=0.122m w=42 l=15
X1023 row_addr_dff_0.dff_2.net4 row_addr_dff_0.dff_3.clk row_addr_dff_0.dff_2.net3 din0[1] sky130_fd_pr__nfet_01v8 ad=2.226n pd=0.148m as=2.73n ps=0.214m w=42 l=15
X1024 a_n1774_1411# control_logic_rw_0.pdriver_4_0.pinv_8_0.A a_n1828_1411# din0[1] sky130_fd_pr__nfet_01v8 ad=1.596n pd=0.16m as=1.638n ps=0.162m w=42 l=15
X1025 a_n1489_n681# control_logic_rw_0.pdriver_0_0.pinv_6_0.A a_n1567_n681# w_n2769_n767# sky130_fd_pr__pfet_01v8 ad=3.99n pd=0.286m as=3.307n ps=0.168m w=105 l=15
X1026 a_n1763_705# control_logic_rw_0.dff_buf_array_0.dout_bar_0 a_n1841_705# din0[1] sky130_fd_pr__nfet_01v8 ad=1.89n pd=0.123m as=1.89n ps=0.123m w=60 l=15
X1027 bank_0.replica_bitcell_array_0.dummy_array_2_0.dummy_cell_1rw_13.q bank_0.replica_bitcell_array_0.dummy_array_2_0.dummy_cell_1rw_13.qb din0[1] din0[1] sky130_fd_pr__pfet_01v8 ad=1.925n pd=0.18m as=1.925n ps=0.18m w=55 l=15
X1028 bank_0.replica_bitcell_array_0.bitcell_array_0.cell_1rw_25.q bank_0.replica_bitcell_array_0.bitcell_array_0.cell_1rw_25.qb din0[1] din0[1] sky130_fd_pr__nfet_01v8 ad=3.864n pd=0.21m as=4.41n ps=0.322m w=126 l=15
X1029 bank_0.replica_bitcell_array_0.bitcell_array_0.cell_1rw_30.q bank_0.replica_bitcell_array_0.bitcell_array_0.cell_1rw_30.qb din0[1] din0[1] sky130_fd_pr__nfet_01v8 ad=3.864n pd=0.21m as=4.41n ps=0.322m w=126 l=15
X1030 bank_0.port_data_0.sense_amp_array_0.sense_amp_1.net1 bank_0.port_data_0.sense_amp_array_0.sense_amp_1.net1 din0[1] din0[1] sky130_fd_pr__pfet_01v8 ad=2.2n pd=0.19m as=2.475n ps=0.2m w=55 l=15
X1031 bank_0.replica_bitcell_array_0.bitcell_array_0.cell_1rw_6.q bank_0.replica_bitcell_array_0.bitcell_array_0.cell_1rw_6.qb din0[1] din0[1] sky130_fd_pr__pfet_01v8 ad=1.925n pd=0.18m as=1.925n ps=0.18m w=55 l=15
X1032 bank_0.replica_bitcell_array_0.bitcell_array_0.cell_1rw_25.q bank_0.replica_bitcell_array_0.wl_0_6 din0[1] din0[1] sky130_fd_pr__nfet_01v8 ad=3.864n pd=0.21m as=1.428n ps=0.152m w=42 l=15
X1033 din0[1] din0[1] din0[1] din0[1] sky130_fd_pr__nfet_01v8 ad=1.26n pd=0.102m as=0 ps=0 w=42 l=15
X1034 din0[1] bank_0.port_data_0.sense_amp_array_0.sense_amp_1.net1 din0[1] din0[1] sky130_fd_pr__pfet_01v8 ad=4.5n pd=0.29m as=0 ps=0 w=100 l=15
X1035 bank_0.replica_bitcell_array_0.replica_column_0.replica_cell_1rw_0.q din0[1] din0[1] din0[1] sky130_fd_pr__nfet_01v8 ad=3.864n pd=0.21m as=4.41n ps=0.322m w=126 l=15
X1036 bank_0.replica_bitcell_array_0.dummy_array_2_0.dummy_cell_1rw_2.qb bank_0.replica_bitcell_array_0.wl_0_14 a_4490_10637# din0[1] sky130_fd_pr__nfet_01v8 ad=3.864n pd=0.21m as=1.428n ps=0.152m w=42 l=15
X1037 a_n5055_8181# control_logic_rw_0.delay_chain_0.pinv_11_14.Z a_n5108_8181# w_n5644_7860# sky130_fd_pr__pfet_01v8 ad=3.276n pd=0.246m as=3.192n ps=0.244m w=84 l=15
X1038 a_2789_8409# bank_0.port_address_0.hierarchical_decoder_0.predecode_6 bank_0.port_address_0.hierarchical_decoder_0.and2_dec_6.pnand2_0.nmos_m1_w0_840_sactive_dli_0.S din0[1] sky130_fd_pr__nfet_01v8 ad=3.192n pd=0.244m as=1.848n ps=0.128m w=84 l=15
X1039 control_logic_rw_0.pand3_0.pnand3_0_0.nmos_m1_w0_840_sactive_dactive_0.D control_logic_rw_0.pand3_0.B control_logic_rw_0.pand3_0.pnand3_0_0.nmos_m1_w0_840_sactive_dactive_0.S din0[1] sky130_fd_pr__nfet_01v8 ad=1.848n pd=0.128m as=1.848n ps=0.128m w=84 l=15
X1040 row_addr_dff_0.dff_3.net2 row_addr_dff_0.dff_3.clkb row_addr_dff_0.dff_3.net1 din0[1] sky130_fd_pr__pfet_01v8 ad=3.74n pd=0.246m as=2.915n ps=0.161m w=55 l=15
X1041 a_2730_7029# bank_0.port_address_0.hierarchical_decoder_0.predecode_3 a_2676_7029# w_2422_6733# sky130_fd_pr__pfet_01v8 ad=1.848n pd=0.128m as=3.276n ps=0.246m w=84 l=15
X1042 a_3483_6011# control_logic_rw_0.wl_en a_3424_6011# w_2422_5715# sky130_fd_pr__pfet_01v8 ad=3.192n pd=0.244m as=1.848n ps=0.128m w=84 l=15
X1043 a_1508_5355# row_addr_dff_0.dout_1 bank_0.port_address_0.hierarchical_decoder_0.hierarchical_predecode2x4_1.and2_dec_0.pnand2_0.nmos_m1_w0_840_sactive_dli_0.S din0[1] sky130_fd_pr__nfet_01v8 ad=3.192n pd=0.244m as=1.848n ps=0.128m w=84 l=15
X1044 din0[1] bank_0.replica_bitcell_array_0.wl_0_13 bank_0.replica_bitcell_array_0.bitcell_array_0.cell_1rw_18.q din0[1] sky130_fd_pr__nfet_01v8 ad=1.428n pd=0.152m as=3.864n ps=0.21m w=42 l=15
X1045 din0[1] bank_0.replica_bitcell_array_0.bitcell_array_0.cell_1rw_18.q bank_0.replica_bitcell_array_0.bitcell_array_0.cell_1rw_18.qb din0[1] sky130_fd_pr__nfet_01v8 ad=4.41n pd=0.322m as=3.864n ps=0.21m w=126 l=15
X1046 a_n4741_7383# control_logic_rw_0.delay_chain_0.pinv_11_19.Z a_n4794_7383# din0[1] sky130_fd_pr__nfet_01v8 ad=1.638n pd=0.162m as=1.596n ps=0.16m w=42 l=15
X1047 a_n4741_6501# control_logic_rw_0.delay_chain_0.pinv_11_24.Z a_n4794_6501# w_n5644_6180# sky130_fd_pr__pfet_01v8 ad=3.276n pd=0.246m as=3.192n ps=0.244m w=84 l=15
X1048 a_n5055_4969# control_logic_rw_0.delay_chain_0.pinv_11_29.Z a_n5108_4969# w_n5644_4500# sky130_fd_pr__pfet_01v8 ad=3.276n pd=0.246m as=3.192n ps=0.244m w=84 l=15
X1049 bank_0.replica_bitcell_array_0.bitcell_array_0.cell_1rw_13.q bank_0.replica_bitcell_array_0.bitcell_array_0.cell_1rw_13.qb din0[1] din0[1] sky130_fd_pr__nfet_01v8 ad=3.864n pd=0.21m as=4.41n ps=0.322m w=126 l=15
X1050 bank_0.replica_bitcell_array_0.dummy_array_2_0.dummy_cell_1rw_7.q bank_0.replica_bitcell_array_0.dummy_array_2_0.dummy_cell_1rw_7.qb din0[1] din0[1] sky130_fd_pr__pfet_01v8 ad=1.925n pd=0.18m as=1.925n ps=0.18m w=55 l=15
X1051 bank_0.port_data_0.write_driver_array_0.write_driver_0.net6 din0[1] din0[1] din0[1] sky130_fd_pr__pfet_01v8 ad=2.75n pd=0.21m as=2.722n ps=0.154m w=55 l=15
X1052 bank_0.replica_bitcell_array_0.dummy_array_2_0.dummy_cell_1rw_14.q bank_0.replica_bitcell_array_0.dummy_array_2_0.dummy_cell_1rw_14.qb din0[1] din0[1] sky130_fd_pr__nfet_01v8 ad=3.864n pd=0.21m as=4.41n ps=0.322m w=126 l=15
X1053 control_logic_rw_0.dff_buf_array_0.dff_buf_0_1.dff_0.net1 din0[1] csb0 din0[1] sky130_fd_pr__pfet_01v8 ad=2.915n pd=0.161m as=2.53n ps=0.202m w=55 l=15
X1054 din0[1] bank_0.replica_bitcell_array_0.dummy_array_2_0.dummy_cell_1rw_2.q bank_0.replica_bitcell_array_0.dummy_array_2_0.dummy_cell_1rw_2.qb din0[1] sky130_fd_pr__nfet_01v8 ad=4.41n pd=0.322m as=3.864n ps=0.21m w=126 l=15
X1055 a_n2056_n107# control_logic_rw_0.dff_buf_array_0.dout_bar_0 a_n2110_n107# din0[1] sky130_fd_pr__nfet_01v8 ad=1.764n pd=0.119m as=2.184n ps=0.19m w=56 l=15
X1056 a_n2088_1111# control_logic_rw_0.delay_chain_0.out a_n2142_1111# w_n2769_857# sky130_fd_pr__pfet_01v8 ad=3.192n pd=0.244m as=3.276n ps=0.246m w=84 l=15
X1057 a_3103_11505# din0[1] a_3049_11505# din0[1] sky130_fd_pr__nfet_01v8 ad=1.596n pd=0.16m as=1.638n ps=0.162m w=42 l=15
X1058 din0[1] bank_0.replica_bitcell_array_0.dummy_array_3_0.dummy_cell_1rw_2.q bank_0.replica_bitcell_array_0.dummy_array_3_0.dummy_cell_1rw_2.qb din0[1] sky130_fd_pr__nfet_01v8 ad=4.41n pd=0.322m as=3.864n ps=0.21m w=126 l=15
X1059 din0[1] din0[1] bank_0.port_data_0.write_driver_array_0.write_driver_0.net6 din0[1] sky130_fd_pr__pfet_01v8 ad=2.75n pd=0.21m as=2.75n ps=0.21m w=55 l=15
X1060 bank_0.port_address_0.hierarchical_decoder_0.and2_dec_5.pnand2_0.nmos_m1_w0_840_sactive_dli_0.S bank_0.port_address_0.hierarchical_decoder_0.predecode_2 a_2676_8557# din0[1] sky130_fd_pr__nfet_01v8 ad=1.848n pd=0.128m as=3.276n ps=0.246m w=84 l=15
X1061 bank_0.port_address_0.hierarchical_decoder_0.hierarchical_predecode2x4_0.and2_dec_0.pnand2_0.nmos_m1_w0_840_sactive_dli_0.S row_addr_dff_0.dout_2 a_1395_8409# din0[1] sky130_fd_pr__nfet_01v8 ad=1.848n pd=0.128m as=3.276n ps=0.246m w=84 l=15
X1062 bank_0.replica_bitcell_array_0.dummy_array_0_0.dummy_cell_1rw_0.qb din0[1] a_5270_11655# din0[1] sky130_fd_pr__nfet_01v8 ad=3.864n pd=0.21m as=1.428n ps=0.152m w=42 l=15
X1063 a_2730_5865# bank_0.port_address_0.hierarchical_decoder_0.predecode_0 a_2676_5865# w_2422_5715# sky130_fd_pr__pfet_01v8 ad=1.848n pd=0.128m as=3.276n ps=0.246m w=84 l=15
X1064 a_n5055_7489# control_logic_rw_0.delay_chain_0.pinv_11_14.Z a_n5108_7489# din0[1] sky130_fd_pr__nfet_01v8 ad=1.638n pd=0.162m as=1.596n ps=0.16m w=42 l=15
X1065 a_5461_4343# bank_0.replica_bitcell_array_0.wl_0_1 bank_0.replica_bitcell_array_0.dummy_array_3_0.dummy_cell_1rw_15.q din0[1] sky130_fd_pr__nfet_01v8 ad=1.428n pd=0.152m as=3.864n ps=0.21m w=42 l=15
X1066 bank_0.replica_bitcell_array_0.bitcell_array_0.cell_1rw_19.qb bank_0.replica_bitcell_array_0.wl_0_12 din0[1] din0[1] sky130_fd_pr__nfet_01v8 ad=3.864n pd=0.21m as=1.428n ps=0.152m w=42 l=15
X1067 a_n597_n691# control_logic_rw_0.pdriver_0_0.pinv_7_0.A a_n675_n691# w_n2769_n767# sky130_fd_pr__pfet_01v8 ad=3.622n pd=0.178m as=3.622n ps=0.178m w=115 l=15
X1068 a_n4741_5809# control_logic_rw_0.delay_chain_0.pinv_11_24.Z a_n4794_5809# din0[1] sky130_fd_pr__nfet_01v8 ad=1.638n pd=0.162m as=1.596n ps=0.16m w=42 l=15
X1069 control_logic_rw_0.dff_buf_array_0.dff_buf_0_1.dff_0.net1 control_logic_rw_0.dff_buf_array_0.dff_buf_0_1.dff_0.clkb csb0 din0[1] sky130_fd_pr__nfet_01v8 ad=2.226n pd=0.148m as=1.932n ps=0.176m w=42 l=15
X1070 bank_0.replica_bitcell_array_0.bitcell_array_0.cell_1rw_18.q bank_0.replica_bitcell_array_0.bitcell_array_0.cell_1rw_18.qb din0[1] din0[1] sky130_fd_pr__nfet_01v8 ad=3.864n pd=0.21m as=4.41n ps=0.322m w=126 l=15
X1071 din0[1] bank_0.replica_bitcell_array_0.replica_column_0.replica_cell_1rw_6.q din0[1] din0[1] sky130_fd_pr__nfet_01v8 ad=3.864n pd=0.21m as=0 ps=0 w=126 l=15
X1072 din0[1] bank_0.replica_bitcell_array_0.wl_0_1 bank_0.replica_bitcell_array_0.replica_column_0.replica_cell_1rw_14.q din0[1] sky130_fd_pr__nfet_01v8 ad=1.428n pd=0.152m as=3.864n ps=0.21m w=42 l=15
X1073 a_n4113_6649# control_logic_rw_0.delay_chain_0.pinv_11_24.Z a_n4166_6649# w_n5644_6180# sky130_fd_pr__pfet_01v8 ad=3.276n pd=0.246m as=3.192n ps=0.244m w=84 l=15
X1074 din0[1] bank_0.replica_bitcell_array_0.dummy_array_0_0.dummy_cell_1rw_0.q bank_0.replica_bitcell_array_0.dummy_array_0_0.dummy_cell_1rw_0.qb din0[1] sky130_fd_pr__nfet_01v8 ad=4.41n pd=0.322m as=3.864n ps=0.21m w=126 l=15
X1075 a_n5369_4821# control_logic_rw_0.delay_chain_0.pinv_11_34.Z a_n5422_4821# w_n5644_4500# sky130_fd_pr__pfet_01v8 ad=3.276n pd=0.246m as=3.192n ps=0.244m w=84 l=15
X1076 a_n3369_n919# control_logic_rw_0.dff_buf_array_0.dout_bar_0 a_n3447_n919# din0[1] sky130_fd_pr__nfet_01v8 ad=2.128n pd=0.188m as=1.764n ps=0.119m w=56 l=15
X1077 a_5461_7397# bank_0.replica_bitcell_array_0.wl_0_7 bank_0.replica_bitcell_array_0.dummy_array_3_0.dummy_cell_1rw_9.q din0[1] sky130_fd_pr__nfet_01v8 ad=1.428n pd=0.152m as=3.864n ps=0.21m w=42 l=15
X1078 a_n3369_n513# control_logic_rw_0.dff_buf_array_0.dout_bar_0 a_n3447_n513# w_n4225_n767# sky130_fd_pr__pfet_01v8 ad=4.256n pd=0.3m as=3.528n ps=0.175m w=112 l=15
X1079 row_addr_dff_0.dff_1.net5 row_addr_dff_0.dff_3.clk row_addr_dff_0.dff_1.net4 din0[1] sky130_fd_pr__pfet_01v8 ad=4.345n pd=0.268m as=2.915n ps=0.161m w=55 l=15
X1080 a_3103_8451# din0[1] a_3049_8451# din0[1] sky130_fd_pr__nfet_01v8 ad=1.596n pd=0.16m as=1.638n ps=0.162m w=42 l=15
X1081 a_3424_7901# bank_0.port_address_0.wordline_driver_array_0.in_8 a_3370_7901# w_2422_7751# sky130_fd_pr__pfet_01v8 ad=1.848n pd=0.128m as=3.276n ps=0.246m w=84 l=15
X1082 bank_0.replica_bitcell_array_0.dummy_array_3_0.dummy_cell_1rw_16.q bank_0.replica_bitcell_array_0.dummy_array_3_0.dummy_cell_1rw_16.qb din0[1] din0[1] sky130_fd_pr__nfet_01v8 ad=3.864n pd=0.21m as=4.41n ps=0.322m w=126 l=15
X1083 din0[1] bank_0.replica_bitcell_array_0.wl_0_7 bank_0.replica_bitcell_array_0.replica_column_0.replica_cell_1rw_8.q din0[1] sky130_fd_pr__nfet_01v8 ad=1.428n pd=0.152m as=3.864n ps=0.21m w=42 l=15
X1084 a_n1744_123# control_logic_rw_0.dff_buf_array_0.dout_bar_0 a_n1822_123# w_n2769_44# sky130_fd_pr__pfet_01v8 ad=3.528n pd=0.175m as=3.528n ps=0.175m w=112 l=15
X1085 a_n4113_9169# control_logic_rw_0.delay_chain_0.pinv_11_9.Z a_n4166_9169# din0[1] sky130_fd_pr__nfet_01v8 ad=1.638n pd=0.162m as=1.596n ps=0.16m w=42 l=15
X1086 din0[1] row_addr_dff_0.dout_2 row_addr_dff_0.dff_1.net5 din0[1] sky130_fd_pr__nfet_01v8 ad=1.68n pd=0.122m as=2.352n ps=0.196m w=42 l=15
X1087 a_n1352_n513# control_logic_rw_0.dff_buf_array_0.dout_bar_0 a_n1430_n513# w_n2769_n767# sky130_fd_pr__pfet_01v8 ad=3.528n pd=0.175m as=3.528n ps=0.175m w=112 l=15
X1088 bank_0.replica_bitcell_array_0.dummy_array_3_0.dummy_cell_1rw_18.qb din0[1] a_5530_2493# din0[1] sky130_fd_pr__nfet_01v8 ad=3.864n pd=0.21m as=1.428n ps=0.152m w=42 l=15
X1089 bank_0.replica_bitcell_array_0.replica_column_0.replica_cell_1rw_15.q din0[1] din0[1] din0[1] sky130_fd_pr__nfet_01v8 ad=3.864n pd=0.21m as=4.41n ps=0.322m w=126 l=15
X1090 bank_0.replica_bitcell_array_0.bitcell_array_0.cell_1rw_1.q bank_0.replica_bitcell_array_0.wl_0_14 din0[1] din0[1] sky130_fd_pr__nfet_01v8 ad=3.864n pd=0.21m as=1.428n ps=0.152m w=42 l=15
X1091 a_3483_8047# control_logic_rw_0.wl_en a_3424_8047# w_2422_7751# sky130_fd_pr__pfet_01v8 ad=3.192n pd=0.244m as=1.848n ps=0.128m w=84 l=15
X1092 bank_0.replica_bitcell_array_0.bitcell_array_0.cell_1rw_9.q bank_0.replica_bitcell_array_0.bitcell_array_0.cell_1rw_9.qb din0[1] din0[1] sky130_fd_pr__nfet_01v8 ad=3.864n pd=0.21m as=4.41n ps=0.322m w=126 l=15
X1093 a_3103_5503# din0[1] a_3049_5503# din0[1] sky130_fd_pr__nfet_01v8 ad=1.596n pd=0.16m as=1.638n ps=0.162m w=42 l=15
X1094 bank_0.replica_bitcell_array_0.bitcell_array_0.cell_1rw_14.q bank_0.replica_bitcell_array_0.bitcell_array_0.cell_1rw_14.qb din0[1] din0[1] sky130_fd_pr__nfet_01v8 ad=3.864n pd=0.21m as=4.41n ps=0.322m w=126 l=15
X1095 a_5053_1712# control_logic_rw_0.p_en_bar a_4999_1712# w_4605_1519# sky130_fd_pr__pfet_01v8 ad=3.192n pd=0.244m as=3.276n ps=0.246m w=84 l=15
X1096 a_3483_3829# control_logic_rw_0.wl_en a_3424_3829# w_2422_3679# sky130_fd_pr__pfet_01v8 ad=3.192n pd=0.244m as=1.848n ps=0.128m w=84 l=15
X1097 a_n2461_151# din0[1] a_n2515_151# w_n2769_44# sky130_fd_pr__pfet_01v8 ad=1.33n pd=0.135m as=3.276n ps=0.246m w=84 l=15
X1098 a_3797_3361# din0[1] a_3743_3361# din0[1] sky130_fd_pr__nfet_01v8 ad=1.596n pd=0.16m as=1.638n ps=0.162m w=42 l=15
X1099 bank_0.replica_bitcell_array_0.replica_column_0.dummy_cell_1rw_1.qb din0[1] a_4750_2493# din0[1] sky130_fd_pr__nfet_01v8 ad=3.864n pd=0.21m as=1.428n ps=0.152m w=42 l=15
X1100 din0[1] din0[1] din0[1] din0[1] sky130_fd_pr__pfet_01v8 ad=2.962n pd=0.175m as=0 ps=0 w=55 l=15
X1101 din0[1] bank_0.replica_bitcell_array_0.dummy_array_2_0.dummy_cell_1rw_3.q bank_0.replica_bitcell_array_0.dummy_array_2_0.dummy_cell_1rw_3.qb din0[1] sky130_fd_pr__nfet_01v8 ad=4.41n pd=0.322m as=3.864n ps=0.21m w=126 l=15
X1102 a_n4427_7383# control_logic_rw_0.delay_chain_0.pinv_11_19.Z a_n4480_7383# din0[1] sky130_fd_pr__nfet_01v8 ad=1.638n pd=0.162m as=1.596n ps=0.16m w=42 l=15
X1103 a_n4427_6501# control_logic_rw_0.delay_chain_0.pinv_11_24.Z a_n4480_6501# w_n5644_6180# sky130_fd_pr__pfet_01v8 ad=3.276n pd=0.246m as=3.192n ps=0.244m w=84 l=15
X1104 bank_0.replica_bitcell_array_0.dummy_array_2_0.dummy_cell_1rw_10.q bank_0.replica_bitcell_array_0.dummy_array_2_0.dummy_cell_1rw_10.qb din0[1] din0[1] sky130_fd_pr__nfet_01v8 ad=3.864n pd=0.21m as=4.41n ps=0.322m w=126 l=15
X1105 bank_0.replica_bitcell_array_0.dummy_array_2_0.dummy_cell_1rw_15.q bank_0.replica_bitcell_array_0.dummy_array_2_0.dummy_cell_1rw_15.qb din0[1] din0[1] sky130_fd_pr__nfet_01v8 ad=3.864n pd=0.21m as=4.41n ps=0.322m w=126 l=15
X1106 a_3797_3975# din0[1] a_3743_3975# w_2422_3679# sky130_fd_pr__pfet_01v8 ad=3.192n pd=0.244m as=3.276n ps=0.246m w=84 l=15
X1107 a_n831_n919# control_logic_rw_0.pdriver_0_0.pinv_7_0.A a_n909_n919# din0[1] sky130_fd_pr__nfet_01v8 ad=1.795n pd=0.12m as=1.795n ps=0.12m w=57 l=15
X1108 din0[1] bank_0.replica_bitcell_array_0.dummy_array_1_0.dummy_cell_1rw_0.q bank_0.replica_bitcell_array_0.dummy_array_1_0.dummy_cell_1rw_0.qb din0[1] sky130_fd_pr__pfet_01v8 ad=1.925n pd=0.18m as=1.925n ps=0.18m w=55 l=15
X1109 control_logic_rw_0.dff_buf_array_0.dff_buf_0_1.pinv_0_0.A control_logic_rw_0.dff_buf_array_0.dff_buf_0_1.dff_0.net4 din0[1] din0[1] sky130_fd_pr__pfet_01v8 ad=2.2n pd=0.19m as=2.2n ps=0.135m w=55 l=15
X1110 a_1508_7901# row_addr_dff_0.dout_3 a_1449_7901# w_1141_7751# sky130_fd_pr__pfet_01v8 ad=3.192n pd=0.244m as=1.848n ps=0.128m w=84 l=15
X1111 bank_0.replica_bitcell_array_0.dummy_array_3_0.dummy_cell_1rw_12.qb bank_0.replica_bitcell_array_0.wl_0_4 a_5530_5547# din0[1] sky130_fd_pr__nfet_01v8 ad=3.864n pd=0.21m as=1.428n ps=0.152m w=42 l=15
X1112 a_3424_4993# bank_0.port_address_0.wordline_driver_array_0.in_3 a_3370_4993# w_2422_4697# sky130_fd_pr__pfet_01v8 ad=1.848n pd=0.128m as=3.276n ps=0.246m w=84 l=15
X1113 din0[1] bank_0.replica_bitcell_array_0.bitcell_array_0.cell_1rw_13.q bank_0.replica_bitcell_array_0.bitcell_array_0.cell_1rw_13.qb din0[1] sky130_fd_pr__nfet_01v8 ad=4.41n pd=0.322m as=3.864n ps=0.21m w=126 l=15
X1114 row_addr_dff_0.dout_3 row_addr_dff_0.dff_0.net4 din0[1] din0[1] sky130_fd_pr__pfet_01v8 ad=2.2n pd=0.19m as=2.2n ps=0.135m w=55 l=15
X1115 din0[1] bank_0.replica_bitcell_array_0.dummy_array_3_0.dummy_cell_1rw_3.q bank_0.replica_bitcell_array_0.dummy_array_3_0.dummy_cell_1rw_3.qb din0[1] sky130_fd_pr__nfet_01v8 ad=4.41n pd=0.322m as=3.864n ps=0.21m w=126 l=15
X1116 bank_0.port_address_0.hierarchical_decoder_0.and2_dec_12.pnand2_0.nmos_m1_w0_840_sactive_dli_0.S bank_0.port_address_0.hierarchical_decoder_0.predecode_3 a_2676_5355# din0[1] sky130_fd_pr__nfet_01v8 ad=1.848n pd=0.128m as=3.276n ps=0.246m w=84 l=15
X1117 a_n3917_n661# control_logic_rw_0.dff_buf_array_0.dff_buf_0_1.pinv_0_0.A a_n3971_n661# w_n4225_n767# sky130_fd_pr__pfet_01v8 ad=2.646n pd=0.147m as=3.276n ps=0.246m w=84 l=15
X1118 din0[1] din0[1] din0[1] din0[1] sky130_fd_pr__nfet_01v8 ad=2.1n pd=0.184m as=0 ps=0 w=42 l=15
X1119 a_3483_9575# control_logic_rw_0.wl_en bank_0.port_address_0.wordline_driver_array_0.wordline_driver_3.pnand2_0.nmos_m1_w0_840_sactive_dli_0.S din0[1] sky130_fd_pr__nfet_01v8 ad=3.192n pd=0.244m as=1.848n ps=0.128m w=84 l=15
X1120 a_3483_6883# control_logic_rw_0.wl_en a_3424_6883# w_2422_6733# sky130_fd_pr__pfet_01v8 ad=3.192n pd=0.244m as=1.848n ps=0.128m w=84 l=15
X1121 control_logic_rw_0.dff_buf_array_0.dff_buf_0_0.dff_0.net2 din0[1] control_logic_rw_0.dff_buf_array_0.dff_buf_0_0.dff_0.net1 din0[1] sky130_fd_pr__nfet_01v8 ad=2.856n pd=0.22m as=2.226n ps=0.148m w=42 l=15
X1122 din0[1] bank_0.replica_bitcell_array_0.dummy_array_2_0.dummy_cell_1rw_18.q bank_0.replica_bitcell_array_0.dummy_array_2_0.dummy_cell_1rw_18.qb din0[1] sky130_fd_pr__pfet_01v8 ad=1.925n pd=0.18m as=1.925n ps=0.18m w=55 l=15
X1123 din0[1] bank_0.replica_bitcell_array_0.dummy_array_2_0.dummy_cell_1rw_14.q bank_0.replica_bitcell_array_0.dummy_array_2_0.dummy_cell_1rw_14.qb din0[1] sky130_fd_pr__nfet_01v8 ad=4.41n pd=0.322m as=3.864n ps=0.21m w=126 l=15
X1124 din0[1] row_addr_dff_0.dff_1.net3 row_addr_dff_0.dff_1.net2 din0[1] sky130_fd_pr__pfet_01v8 ad=2.2n pd=0.135m as=2.915n ps=0.216m w=55 l=15
X1125 bank_0.replica_bitcell_array_0.bitcell_array_0.cell_1rw_19.q bank_0.replica_bitcell_array_0.bitcell_array_0.cell_1rw_19.qb din0[1] din0[1] sky130_fd_pr__pfet_01v8 ad=1.925n pd=0.18m as=1.925n ps=0.18m w=55 l=15
X1126 din0[1] bank_0.replica_bitcell_array_0.wl_0_4 din0[1] din0[1] sky130_fd_pr__nfet_01v8 ad=3.864n pd=0.21m as=0 ps=0 w=42 l=15
X1127 bank_0.replica_bitcell_array_0.bitcell_array_0.cell_1rw_5.qb bank_0.replica_bitcell_array_0.wl_0_10 din0[1] din0[1] sky130_fd_pr__nfet_01v8 ad=3.864n pd=0.21m as=1.428n ps=0.152m w=42 l=15
X1128 bank_0.replica_bitcell_array_0.dummy_array_0.dummy_cell_1rw_1.q bank_0.replica_bitcell_array_0.dummy_array_0.dummy_cell_1rw_1.qb din0[1] din0[1] sky130_fd_pr__pfet_01v8 ad=1.925n pd=0.18m as=1.925n ps=0.18m w=55 l=15
X1129 a_2730_10955# bank_0.port_address_0.hierarchical_decoder_0.predecode_2 a_2676_10955# w_2422_10805# sky130_fd_pr__pfet_01v8 ad=1.848n pd=0.128m as=3.276n ps=0.246m w=84 l=15
X1130 control_logic_rw_0.dff_buf_array_0.dff_buf_0_1.pinv_0_0.A control_logic_rw_0.dff_buf_array_0.dff_buf_0_1.dff_0.net4 din0[1] din0[1] sky130_fd_pr__nfet_01v8 ad=1.68n pd=0.164m as=1.68n ps=0.122m w=42 l=15
X1131 a_n3447_n227# control_logic_rw_0.dff_buf_array_0.dout_bar_0 a_n3525_n227# din0[1] sky130_fd_pr__nfet_01v8 ad=1.764n pd=0.119m as=1.764n ps=0.119m w=56 l=15
X1132 bank_0.replica_bitcell_array_0.replica_column_0.dummy_cell_1rw_0.qb din0[1] a_4750_11655# din0[1] sky130_fd_pr__nfet_01v8 ad=3.864n pd=0.21m as=1.428n ps=0.152m w=42 l=15
X1133 bank_0.replica_bitcell_array_0.dummy_array_2_0.dummy_cell_1rw_6.qb bank_0.replica_bitcell_array_0.wl_0_10 a_4490_8601# din0[1] sky130_fd_pr__nfet_01v8 ad=3.864n pd=0.21m as=1.428n ps=0.152m w=42 l=15
X1134 a_n4427_5809# control_logic_rw_0.delay_chain_0.pinv_11_24.Z a_n4480_5809# din0[1] sky130_fd_pr__nfet_01v8 ad=1.638n pd=0.162m as=1.596n ps=0.16m w=42 l=15
X1135 row_addr_dff_0.dff_1.net1 row_addr_dff_0.dff_3.clk addr0[2] din0[1] sky130_fd_pr__pfet_01v8 ad=2.915n pd=0.161m as=2.53n ps=0.202m w=55 l=15
X1136 a_3797_8919# din0[1] a_3743_8919# w_2422_8769# sky130_fd_pr__pfet_01v8 ad=3.192n pd=0.244m as=3.276n ps=0.246m w=84 l=15
X1137 a_n1801_599# control_logic_rw_0.pdriver_1_0.pinv_8_0.Z a_n1855_599# din0[1] sky130_fd_pr__nfet_01v8 ad=1.323n pd=0.105m as=1.638n ps=0.162m w=42 l=15
X1138 a_3424_9937# bank_0.port_address_0.wordline_driver_array_0.in_12 a_3370_9937# w_2422_9787# sky130_fd_pr__pfet_01v8 ad=1.848n pd=0.128m as=3.276n ps=0.246m w=84 l=15
X1139 din0[1] bank_0.replica_bitcell_array_0.bitcell_array_0.cell_1rw_21.q bank_0.replica_bitcell_array_0.bitcell_array_0.cell_1rw_21.qb din0[1] sky130_fd_pr__pfet_01v8 ad=1.925n pd=0.18m as=1.925n ps=0.18m w=55 l=15
X1140 din0[1] bank_0.replica_bitcell_array_0.replica_column_0.dummy_cell_1rw_0.q bank_0.replica_bitcell_array_0.replica_column_0.dummy_cell_1rw_0.qb din0[1] sky130_fd_pr__nfet_01v8 ad=4.41n pd=0.322m as=3.864n ps=0.21m w=126 l=15
X1141 bank_0.port_address_0.wordline_driver_array_0.wordline_driver_0.pnand2_0.nmos_m1_w0_840_sactive_dli_0.S bank_0.port_address_0.wordline_driver_array_0.in_15 a_3370_11463# din0[1] sky130_fd_pr__nfet_01v8 ad=1.848n pd=0.128m as=3.276n ps=0.246m w=84 l=15
X1142 row_addr_dff_0.dff_3.net5 row_addr_dff_0.dff_3.clk row_addr_dff_0.dff_3.net4 din0[1] sky130_fd_pr__pfet_01v8 ad=4.345n pd=0.268m as=2.915n ps=0.161m w=55 l=15
X1143 row_addr_dff_0.dff_3.net3 row_addr_dff_0.dff_3.net1 din0[1] din0[1] sky130_fd_pr__nfet_01v8 ad=2.604n pd=0.208m as=1.68n ps=0.122m w=42 l=15
X1144 a_1508_4993# row_addr_dff_0.dout_1 a_1449_4993# w_1141_4697# sky130_fd_pr__pfet_01v8 ad=3.192n pd=0.244m as=1.848n ps=0.128m w=84 l=15
X1145 din0[1] bank_0.replica_bitcell_array_0.bitcell_array_0.cell_1rw_22.q bank_0.replica_bitcell_array_0.bitcell_array_0.cell_1rw_22.qb din0[1] sky130_fd_pr__nfet_01v8 ad=4.41n pd=0.322m as=3.864n ps=0.21m w=126 l=15
X1146 a_n1430_n227# control_logic_rw_0.dff_buf_array_0.dout_bar_0 a_n1508_n227# din0[1] sky130_fd_pr__nfet_01v8 ad=1.764n pd=0.119m as=1.764n ps=0.119m w=56 l=15
X1147 a_3103_10955# din0[1] a_3049_10955# w_2422_10805# sky130_fd_pr__pfet_01v8 ad=3.192n pd=0.244m as=3.276n ps=0.246m w=84 l=15
X1148 a_2789_6011# bank_0.port_address_0.hierarchical_decoder_0.predecode_5 a_2730_6011# w_2422_5715# sky130_fd_pr__pfet_01v8 ad=3.192n pd=0.244m as=1.848n ps=0.128m w=84 l=15
X1149 din0[1] bank_0.replica_bitcell_array_0.wl_0_5 bank_0.replica_bitcell_array_0.bitcell_array_0.cell_1rw_26.qb din0[1] sky130_fd_pr__nfet_01v8 ad=1.428n pd=0.152m as=3.864n ps=0.21m w=42 l=15
X1150 a_n2461_1775# control_logic_rw_0.delay_chain_0.out a_n2515_1775# w_n2769_1669# sky130_fd_pr__pfet_01v8 ad=3.192n pd=0.244m as=3.276n ps=0.246m w=84 l=15
X1151 bank_0.replica_bitcell_array_0.bitcell_array_0.cell_1rw_15.q bank_0.replica_bitcell_array_0.wl_0_0 din0[1] din0[1] sky130_fd_pr__nfet_01v8 ad=3.864n pd=0.21m as=1.428n ps=0.152m w=42 l=15
X1152 a_n3525_n689# control_logic_rw_0.dff_buf_array_0.dout_bar_0 a_n3579_n689# w_n4225_n767# sky130_fd_pr__pfet_01v8 ad=3.528n pd=0.175m as=4.368n ps=0.302m w=112 l=15
X1153 a_5372_1928# control_logic_rw_0.p_en_bar a_5313_1928# w_4605_1519# sky130_fd_pr__pfet_01v8 ad=3.192n pd=0.244m as=1.848n ps=0.128m w=84 l=15
X1154 a_5270_3325# bank_0.replica_bitcell_array_0.rbl_wl_0_0 bank_0.replica_bitcell_array_0.dummy_array_0.dummy_cell_1rw_0.qb din0[1] sky130_fd_pr__nfet_01v8 ad=1.428n pd=0.152m as=3.864n ps=0.21m w=42 l=15
X1155 a_2789_10083# bank_0.port_address_0.hierarchical_decoder_0.predecode_7 a_2730_10083# w_2422_9787# sky130_fd_pr__pfet_01v8 ad=3.192n pd=0.244m as=1.848n ps=0.128m w=84 l=15
X1156 a_3103_9065# din0[1] a_3049_9065# w_2422_8769# sky130_fd_pr__pfet_01v8 ad=3.192n pd=0.244m as=3.276n ps=0.246m w=84 l=15
X1157 a_3103_7539# din0[1] a_3049_7539# din0[1] sky130_fd_pr__nfet_01v8 ad=1.596n pd=0.16m as=1.638n ps=0.162m w=42 l=15
X1158 a_3483_3319# din0[1] bank_0.port_address_0.and2_dec_0_0.pnand2_0.nmos_m1_w0_840_sactive_dli_0.S din0[1] sky130_fd_pr__nfet_01v8 ad=3.192n pd=0.244m as=1.848n ps=0.128m w=84 l=15
X1159 bank_0.replica_bitcell_array_0.bitcell_array_0.cell_1rw_26.q bank_0.replica_bitcell_array_0.bitcell_array_0.cell_1rw_26.qb din0[1] din0[1] sky130_fd_pr__nfet_01v8 ad=3.864n pd=0.21m as=4.41n ps=0.322m w=126 l=15
X1160 a_3103_4847# din0[1] a_3049_4847# w_2422_4697# sky130_fd_pr__pfet_01v8 ad=3.192n pd=0.244m as=3.276n ps=0.246m w=84 l=15
X1161 din0[1] din0[1] din0[1] din0[1] sky130_fd_pr__pfet_01v8 ad=2.75n pd=0.21m as=0 ps=0 w=55 l=15
X1162 a_4490_3325# bank_0.replica_bitcell_array_0.rbl_wl_0_0 bank_0.replica_bitcell_array_0.dummy_array_2_0.dummy_cell_1rw_17.qb din0[1] sky130_fd_pr__nfet_01v8 ad=1.428n pd=0.152m as=3.864n ps=0.21m w=42 l=15
X1163 bank_0.replica_bitcell_array_0.dummy_array_2_0.dummy_cell_1rw_16.q bank_0.replica_bitcell_array_0.wl_0_0 a_4421_3511# din0[1] sky130_fd_pr__nfet_01v8 ad=3.864n pd=0.21m as=1.428n ps=0.152m w=42 l=15
X1164 a_3797_5397# din0[1] a_3743_5397# din0[1] sky130_fd_pr__nfet_01v8 ad=1.596n pd=0.16m as=1.638n ps=0.162m w=42 l=15
X1165 a_n1841_927# control_logic_rw_0.dff_buf_array_0.dout_bar_0 a_n1919_927# w_n2769_857# sky130_fd_pr__pfet_01v8 ad=3.78n pd=0.183m as=3.78n ps=0.183m w=120 l=15
X1166 bank_0.replica_bitcell_array_0.bitcell_array_0.cell_1rw_21.q bank_0.replica_bitcell_array_0.wl_0_10 din0[1] din0[1] sky130_fd_pr__nfet_01v8 ad=3.864n pd=0.21m as=1.428n ps=0.152m w=42 l=15
X1167 a_n5369_4129# control_logic_rw_0.delay_chain_0.pinv_11_34.Z a_n5422_4129# din0[1] sky130_fd_pr__nfet_01v8 ad=1.638n pd=0.162m as=1.596n ps=0.16m w=42 l=15
X1168 bank_0.replica_bitcell_array_0.dummy_array_3_0.dummy_cell_1rw_16.q bank_0.replica_bitcell_array_0.dummy_array_3_0.dummy_cell_1rw_16.qb din0[1] din0[1] sky130_fd_pr__pfet_01v8 ad=1.925n pd=0.18m as=1.925n ps=0.18m w=55 l=15
X1169 row_addr_dff_0.dff_0.net3 row_addr_dff_0.dff_0.net1 din0[1] din0[1] sky130_fd_pr__nfet_01v8 ad=2.604n pd=0.208m as=1.68n ps=0.122m w=42 l=15
X1170 din0[1] bank_0.replica_bitcell_array_0.bitcell_array_0.cell_1rw_6.q bank_0.replica_bitcell_array_0.bitcell_array_0.cell_1rw_6.qb din0[1] sky130_fd_pr__pfet_01v8 ad=1.925n pd=0.18m as=1.925n ps=0.18m w=55 l=15
X1171 din0[1] bank_0.replica_bitcell_array_0.bitcell_array_0.cell_1rw_13.q bank_0.replica_bitcell_array_0.bitcell_array_0.cell_1rw_13.qb din0[1] sky130_fd_pr__pfet_01v8 ad=1.925n pd=0.18m as=1.925n ps=0.18m w=55 l=15
X1172 din0[1] bank_0.replica_bitcell_array_0.replica_column_0.replica_cell_1rw_15.q din0[1] din0[1] sky130_fd_pr__nfet_01v8 ad=3.864n pd=0.21m as=0 ps=0 w=126 l=15
X1173 din0[1] bank_0.replica_bitcell_array_0.bitcell_array_0.cell_1rw_9.q bank_0.replica_bitcell_array_0.bitcell_array_0.cell_1rw_9.qb din0[1] sky130_fd_pr__nfet_01v8 ad=4.41n pd=0.322m as=3.864n ps=0.21m w=126 l=15
X1174 din0[1] bank_0.replica_bitcell_array_0.dummy_array_3_0.dummy_cell_1rw_13.q bank_0.replica_bitcell_array_0.dummy_array_3_0.dummy_cell_1rw_13.qb din0[1] sky130_fd_pr__pfet_01v8 ad=1.925n pd=0.18m as=1.925n ps=0.18m w=55 l=15
X1175 din0[1] bank_0.replica_bitcell_array_0.bitcell_array_0.cell_1rw_14.q bank_0.replica_bitcell_array_0.bitcell_array_0.cell_1rw_14.qb din0[1] sky130_fd_pr__nfet_01v8 ad=4.41n pd=0.322m as=3.864n ps=0.21m w=126 l=15
X1176 bank_0.replica_bitcell_array_0.replica_column_0.replica_cell_1rw_15.q din0[1] din0[1] din0[1] sky130_fd_pr__pfet_01v8 ad=1.925n pd=0.18m as=1.925n ps=0.18m w=55 l=15
X1177 a_n1567_n681# control_logic_rw_0.pdriver_0_0.pinv_6_0.A a_n1645_n681# w_n2769_n767# sky130_fd_pr__pfet_01v8 ad=3.307n pd=0.168m as=3.307n ps=0.168m w=105 l=15
X1178 row_addr_dff_0.dout_1 row_addr_dff_0.dff_2.net4 din0[1] din0[1] sky130_fd_pr__pfet_01v8 ad=2.2n pd=0.19m as=2.2n ps=0.135m w=55 l=15
X1179 din0[1] bank_0.replica_bitcell_array_0.dummy_array_2_0.dummy_cell_1rw_7.q bank_0.replica_bitcell_array_0.dummy_array_2_0.dummy_cell_1rw_7.qb din0[1] sky130_fd_pr__pfet_01v8 ad=1.925n pd=0.18m as=1.925n ps=0.18m w=55 l=15
X1180 a_3483_6373# control_logic_rw_0.wl_en bank_0.port_address_0.wordline_driver_array_0.wordline_driver_10.pnand2_0.nmos_m1_w0_840_sactive_dli_0.S din0[1] sky130_fd_pr__nfet_01v8 ad=3.192n pd=0.244m as=1.848n ps=0.128m w=84 l=15
X1181 din0[1] bank_0.replica_bitcell_array_0.dummy_array_2_0.dummy_cell_1rw_14.q bank_0.replica_bitcell_array_0.dummy_array_2_0.dummy_cell_1rw_14.qb din0[1] sky130_fd_pr__pfet_01v8 ad=1.925n pd=0.18m as=1.925n ps=0.18m w=55 l=15
X1182 din0[1] bank_0.replica_bitcell_array_0.replica_column_0.replica_cell_1rw_12.q din0[1] din0[1] sky130_fd_pr__pfet_01v8 ad=1.925n pd=0.18m as=0 ps=0 w=55 l=15
X1183 a_1822_3975# din0[1] a_1768_3975# w_1141_3679# sky130_fd_pr__pfet_01v8 ad=3.192n pd=0.244m as=3.276n ps=0.246m w=84 l=15
X1184 bank_0.port_address_0.wordline_driver_array_0.wordline_driver_15.pnand2_0.nmos_m1_w0_840_sactive_dli_0.S bank_0.port_address_0.wordline_driver_array_0.in_0 a_3370_3467# din0[1] sky130_fd_pr__nfet_01v8 ad=1.848n pd=0.128m as=3.276n ps=0.246m w=84 l=15
X1185 din0[1] bank_0.replica_bitcell_array_0.dummy_array_2_0.dummy_cell_1rw_10.q bank_0.replica_bitcell_array_0.dummy_array_2_0.dummy_cell_1rw_10.qb din0[1] sky130_fd_pr__nfet_01v8 ad=4.41n pd=0.322m as=3.864n ps=0.21m w=126 l=15
X1186 din0[1] bank_0.replica_bitcell_array_0.dummy_array_2_0.dummy_cell_1rw_15.q bank_0.replica_bitcell_array_0.dummy_array_2_0.dummy_cell_1rw_15.qb din0[1] sky130_fd_pr__nfet_01v8 ad=4.41n pd=0.322m as=3.864n ps=0.21m w=126 l=15
X1187 row_addr_dff_0.dff_0.clkb row_addr_dff_0.dff_3.clk din0[1] din0[1] sky130_fd_pr__pfet_01v8 ad=2.53n pd=0.202m as=2.53n ps=0.202m w=55 l=15
X1188 din0[1] row_addr_dff_0.dff_3.net3 row_addr_dff_0.dff_3.net2 din0[1] sky130_fd_pr__pfet_01v8 ad=2.2n pd=0.135m as=2.915n ps=0.216m w=55 l=15
X1189 bank_0.port_address_0.hierarchical_decoder_0.and2_dec_2.pnand2_0.nmos_m1_w0_840_sactive_dli_0.S bank_0.port_address_0.hierarchical_decoder_0.predecode_1 a_2676_10445# din0[1] sky130_fd_pr__nfet_01v8 ad=1.848n pd=0.128m as=3.276n ps=0.246m w=84 l=15
X1190 a_n1997_1923# control_logic_rw_0.dff_buf_array_0.dout_1 a_n2051_1923# w_n2769_1669# sky130_fd_pr__pfet_01v8 ad=2.646n pd=0.147m as=3.276n ps=0.246m w=84 l=15
X1191 a_n4741_3141# control_logic_rw_0.delay_chain_0.pinv_11_44.Z a_n4794_3141# w_n5644_2820# sky130_fd_pr__pfet_01v8 ad=3.276n pd=0.246m as=3.192n ps=0.244m w=84 l=15
X1192 a_n1489_n919# control_logic_rw_0.pdriver_0_0.pinv_6_0.A a_n1567_n919# din0[1] sky130_fd_pr__nfet_01v8 ad=1.976n pd=0.18m as=1.638n ps=0.115m w=52 l=15
X1193 a_4941_3325# bank_0.replica_bitcell_array_0.rbl_wl_0_0 bank_0.replica_bitcell_array_0.dummy_array_0.dummy_cell_1rw_1.q din0[1] sky130_fd_pr__nfet_01v8 ad=1.428n pd=0.152m as=3.864n ps=0.21m w=42 l=15
X1194 din0[1] bank_0.replica_bitcell_array_0.wl_0_11 bank_0.replica_bitcell_array_0.bitcell_array_0.cell_1rw_4.q din0[1] sky130_fd_pr__nfet_01v8 ad=1.428n pd=0.152m as=3.864n ps=0.21m w=42 l=15
X1195 a_2730_7901# bank_0.port_address_0.hierarchical_decoder_0.predecode_0 a_2676_7901# w_2422_7751# sky130_fd_pr__pfet_01v8 ad=1.848n pd=0.128m as=3.276n ps=0.246m w=84 l=15
X1196 a_739_7433# row_addr_dff_0.dout_3 a_685_7433# din0[1] sky130_fd_pr__nfet_01v8 ad=1.596n pd=0.16m as=1.638n ps=0.162m w=42 l=15
X1197 bank_0.replica_bitcell_array_0.dummy_array_3_0.dummy_cell_1rw_11.q bank_0.replica_bitcell_array_0.dummy_array_3_0.dummy_cell_1rw_11.qb din0[1] din0[1] sky130_fd_pr__pfet_01v8 ad=1.925n pd=0.18m as=1.925n ps=0.18m w=55 l=15
X1198 din0[1] din0[1] din0[1] din0[1] sky130_fd_pr__nfet_01v8 ad=0.56n pd=77u as=0 ps=0 w=19 l=1
X1199 a_n1377_589# control_logic_rw_0.pdriver_1_0.pinv_6_0.A a_n1431_589# din0[1] sky130_fd_pr__nfet_01v8 ad=1.638n pd=0.115m as=2.028n ps=0.182m w=52 l=15
X1200 a_n2343_1018# control_logic_rw_0.pand3_0.pnand3_0_0.nmos_m1_w0_840_sactive_dli_0.G a_n2402_963# w_n2769_857# sky130_fd_pr__pfet_01v8 ad=1.102n pd=0.134m as=1.848n ps=0.128m w=36 l=15
X1201 din0[1] din0[1] din0[1] din0[1] sky130_fd_pr__pfet_01v8 ad=2.475n pd=0.2m as=0 ps=0 w=55 l=15
X1202 row_addr_dff_0.dff_3.net1 row_addr_dff_0.dff_3.clk addr0[0] din0[1] sky130_fd_pr__pfet_01v8 ad=2.915n pd=0.161m as=2.53n ps=0.202m w=55 l=15
X1203 bank_0.replica_bitcell_array_0.bitcell_array_0.cell_1rw_3.q bank_0.replica_bitcell_array_0.bitcell_array_0.cell_1rw_3.qb din0[1] din0[1] sky130_fd_pr__pfet_01v8 ad=1.925n pd=0.18m as=1.925n ps=0.18m w=55 l=15
X1204 bank_0.port_address_0.wordline_driver_array_0.wordline_driver_4.pnand2_0.nmos_m1_w0_840_sactive_dli_0.S bank_0.port_address_0.wordline_driver_array_0.in_11 a_3370_9427# din0[1] sky130_fd_pr__nfet_01v8 ad=1.848n pd=0.128m as=3.276n ps=0.246m w=84 l=15
X1205 a_4421_9433# bank_0.replica_bitcell_array_0.wl_0_11 bank_0.replica_bitcell_array_0.dummy_array_2_0.dummy_cell_1rw_5.q din0[1] sky130_fd_pr__nfet_01v8 ad=1.428n pd=0.152m as=3.864n ps=0.21m w=42 l=15
X1206 bank_0.replica_bitcell_array_0.replica_column_0.replica_cell_1rw_10.q din0[1] din0[1] din0[1] sky130_fd_pr__pfet_01v8 ad=1.925n pd=0.18m as=1.925n ps=0.18m w=55 l=15
X1207 bank_0.replica_bitcell_array_0.dummy_array_0.dummy_cell_1rw_0.q bank_0.replica_bitcell_array_0.dummy_array_0.dummy_cell_1rw_0.qb din0[1] din0[1] sky130_fd_pr__pfet_01v8 ad=1.925n pd=0.18m as=1.925n ps=0.18m w=55 l=15
X1208 a_n4741_9861# control_logic_rw_0.delay_chain_0.out a_n4794_9861# w_n5644_9540# sky130_fd_pr__pfet_01v8 ad=3.276n pd=0.246m as=3.192n ps=0.244m w=84 l=15
X1209 bank_0.replica_bitcell_array_0.dummy_array_2_0.dummy_cell_1rw_4.q bank_0.replica_bitcell_array_0.dummy_array_2_0.dummy_cell_1rw_4.qb din0[1] din0[1] sky130_fd_pr__pfet_01v8 ad=1.925n pd=0.18m as=1.925n ps=0.18m w=55 l=15
X1210 a_n1685_705# control_logic_rw_0.dff_buf_array_0.dout_bar_0 a_n1763_705# din0[1] sky130_fd_pr__nfet_01v8 ad=1.89n pd=0.123m as=1.89n ps=0.123m w=60 l=15
X1211 a_2789_8047# bank_0.port_address_0.hierarchical_decoder_0.predecode_6 a_2730_8047# w_2422_7751# sky130_fd_pr__pfet_01v8 ad=3.192n pd=0.244m as=1.848n ps=0.128m w=84 l=15
X1212 din0[1] bank_0.replica_bitcell_array_0.wl_0_3 bank_0.replica_bitcell_array_0.bitcell_array_0.cell_1rw_12.qb din0[1] sky130_fd_pr__nfet_01v8 ad=1.428n pd=0.152m as=3.864n ps=0.21m w=42 l=15
X1213 a_n1143_n691# control_logic_rw_0.pdriver_0_0.pinv_7_0.A a_n1197_n691# w_n2769_n767# sky130_fd_pr__pfet_01v8 ad=3.622n pd=0.178m as=4.485n ps=0.308m w=115 l=15
X1214 bank_0.replica_bitcell_array_0.dummy_array_3_0.dummy_cell_1rw_18.q din0[1] a_5461_2493# din0[1] sky130_fd_pr__nfet_01v8 ad=3.864n pd=0.21m as=1.428n ps=0.152m w=42 l=15
X1215 bank_0.replica_bitcell_array_0.dummy_array_2_0.dummy_cell_1rw_17.q bank_0.replica_bitcell_array_0.dummy_array_2_0.dummy_cell_1rw_17.qb din0[1] din0[1] sky130_fd_pr__pfet_01v8 ad=1.925n pd=0.18m as=1.925n ps=0.18m w=55 l=15
X1216 bank_0.replica_bitcell_array_0.replica_column_0.dummy_cell_1rw_0.q din0[1] a_4681_11655# din0[1] sky130_fd_pr__nfet_01v8 ad=3.864n pd=0.21m as=1.428n ps=0.152m w=42 l=15
X1217 a_2789_3829# bank_0.port_address_0.hierarchical_decoder_0.predecode_4 a_2730_3829# w_2422_3679# sky130_fd_pr__pfet_01v8 ad=3.192n pd=0.244m as=1.848n ps=0.128m w=84 l=15
X1218 a_1508_3467# bank_0.port_address_0.hierarchical_decoder_0.hierarchical_predecode2x4_1.pinv_0.Z bank_0.port_address_0.hierarchical_decoder_0.hierarchical_predecode2x4_1.and2_dec_3.pnand2_0.nmos_m1_w0_840_sactive_dli_0.S din0[1] sky130_fd_pr__nfet_01v8 ad=3.192n pd=0.244m as=1.848n ps=0.128m w=84 l=15
X1219 bank_0.port_data_0.sense_amp_array_0.sense_amp_1.net1 din0[1] din0[1] din0[1] sky130_fd_pr__nfet_01v8 ad=1.68n pd=0.164m as=1.89n ps=0.174m w=42 l=15
X1220 a_n4741_2449# control_logic_rw_0.delay_chain_0.pinv_11_44.Z a_n4794_2449# din0[1] sky130_fd_pr__nfet_01v8 ad=1.638n pd=0.162m as=1.596n ps=0.16m w=42 l=15
X1221 a_n4113_5703# control_logic_rw_0.delay_chain_0.pinv_11_34.Z a_n4166_5703# din0[1] sky130_fd_pr__nfet_01v8 ad=1.638n pd=0.162m as=1.596n ps=0.16m w=42 l=15
X1222 din0[1] din0[1] din0[1] din0[1] sky130_fd_pr__pfet_01v8 ad=0.696n pd=90u as=0 ps=0 w=55 l=15
X1223 din0[1] din0[1] row_addr_dff_0.dff_3.net5 din0[1] sky130_fd_pr__nfet_01v8 ad=1.68n pd=0.122m as=2.352n ps=0.196m w=42 l=15
X1224 bank_0.replica_bitcell_array_0.dummy_array_3_0.dummy_cell_1rw_12.q bank_0.replica_bitcell_array_0.dummy_array_3_0.dummy_cell_1rw_12.qb din0[1] din0[1] sky130_fd_pr__nfet_01v8 ad=3.864n pd=0.21m as=4.41n ps=0.322m w=126 l=15
X1225 a_4490_5361# bank_0.replica_bitcell_array_0.wl_0_3 bank_0.replica_bitcell_array_0.dummy_array_2_0.dummy_cell_1rw_13.qb din0[1] sky130_fd_pr__nfet_01v8 ad=1.428n pd=0.152m as=3.864n ps=0.21m w=42 l=15
X1226 bank_0.replica_bitcell_array_0.replica_column_0.dummy_cell_1rw_1.q din0[1] a_4681_2493# din0[1] sky130_fd_pr__nfet_01v8 ad=3.864n pd=0.21m as=1.428n ps=0.152m w=42 l=15
X1227 a_n4113_3289# control_logic_rw_0.delay_chain_0.pinv_11_44.Z a_n4166_3289# w_n5644_2820# sky130_fd_pr__pfet_01v8 ad=3.276n pd=0.246m as=3.192n ps=0.244m w=84 l=15
X1228 bank_0.replica_bitcell_array_0.dummy_array_3_0.dummy_cell_1rw_17.q bank_0.replica_bitcell_array_0.dummy_array_3_0.dummy_cell_1rw_17.qb din0[1] din0[1] sky130_fd_pr__nfet_01v8 ad=3.864n pd=0.21m as=4.41n ps=0.322m w=126 l=15
X1229 a_2730_4993# bank_0.port_address_0.hierarchical_decoder_0.predecode_3 a_2676_4993# w_2422_4697# sky130_fd_pr__pfet_01v8 ad=1.848n pd=0.128m as=3.276n ps=0.246m w=84 l=15
X1230 control_logic_rw_0.dff_buf_array_0.dff_buf_0_0.dff_0.clkb din0[1] din0[1] din0[1] sky130_fd_pr__pfet_01v8 ad=2.53n pd=0.202m as=2.53n ps=0.202m w=55 l=15
X1231 a_n1666_123# control_logic_rw_0.dff_buf_array_0.dout_bar_0 a_n1744_123# w_n2769_44# sky130_fd_pr__pfet_01v8 ad=3.528n pd=0.175m as=3.528n ps=0.175m w=112 l=15
X1232 a_n5369_8329# control_logic_rw_0.delay_chain_0.pinv_11_9.Z a_n5422_8329# w_n5644_7860# sky130_fd_pr__pfet_01v8 ad=3.276n pd=0.246m as=3.192n ps=0.244m w=84 l=15
X1233 a_n2461_n661# clk0 a_n2515_n661# w_n2769_n767# sky130_fd_pr__pfet_01v8 ad=3.192n pd=0.244m as=3.276n ps=0.246m w=84 l=15
X1234 row_addr_dff_0.dff_2.net3 row_addr_dff_0.dff_2.net1 din0[1] din0[1] sky130_fd_pr__nfet_01v8 ad=2.604n pd=0.208m as=1.68n ps=0.122m w=42 l=15
X1235 a_2789_9575# bank_0.port_address_0.hierarchical_decoder_0.predecode_7 bank_0.port_address_0.hierarchical_decoder_0.and2_dec_3.pnand2_0.nmos_m1_w0_840_sactive_dli_0.S din0[1] sky130_fd_pr__nfet_01v8 ad=3.192n pd=0.244m as=1.848n ps=0.128m w=84 l=15
X1236 a_1449_8047# row_addr_dff_0.dout_2 a_1395_8047# w_1141_7751# sky130_fd_pr__pfet_01v8 ad=1.848n pd=0.128m as=3.276n ps=0.246m w=84 l=15
X1237 din0[1] bank_0.replica_bitcell_array_0.dummy_array_3_0.dummy_cell_1rw_9.q bank_0.replica_bitcell_array_0.dummy_array_3_0.dummy_cell_1rw_9.qb din0[1] sky130_fd_pr__pfet_01v8 ad=1.925n pd=0.18m as=1.925n ps=0.18m w=55 l=15
X1238 bank_0.replica_bitcell_array_0.replica_column_0.replica_cell_1rw_11.q din0[1] din0[1] din0[1] sky130_fd_pr__nfet_01v8 ad=3.864n pd=0.21m as=4.41n ps=0.322m w=126 l=15
X1239 bank_0.replica_bitcell_array_0.dummy_array_3_0.dummy_cell_1rw_12.q bank_0.replica_bitcell_array_0.wl_0_4 a_5461_5547# din0[1] sky130_fd_pr__nfet_01v8 ad=3.864n pd=0.21m as=1.428n ps=0.152m w=42 l=15
X1240 a_1822_5397# din0[1] a_1768_5397# din0[1] sky130_fd_pr__nfet_01v8 ad=1.596n pd=0.16m as=1.638n ps=0.162m w=42 l=15
X1241 din0[1] din0[1] din0[1] din0[1] sky130_fd_pr__nfet_01v8 ad=1.89n pd=0.174m as=0 ps=0 w=42 l=15
X1242 bank_0.replica_bitcell_array_0.replica_column_0.replica_cell_1rw_16.q din0[1] din0[1] din0[1] sky130_fd_pr__nfet_01v8 ad=3.864n pd=0.21m as=4.41n ps=0.322m w=126 l=15
X1243 a_2789_6883# bank_0.port_address_0.hierarchical_decoder_0.predecode_5 a_2730_6883# w_2422_6733# sky130_fd_pr__pfet_01v8 ad=3.192n pd=0.244m as=1.848n ps=0.128m w=84 l=15
X1244 bank_0.replica_bitcell_array_0.bitcell_array_0.cell_1rw_10.q bank_0.replica_bitcell_array_0.bitcell_array_0.cell_1rw_10.qb din0[1] din0[1] sky130_fd_pr__nfet_01v8 ad=3.864n pd=0.21m as=4.41n ps=0.322m w=126 l=15
X1245 a_1449_3829# bank_0.port_address_0.hierarchical_decoder_0.hierarchical_predecode2x4_1.pinv_1.Z a_1395_3829# w_1141_3679# sky130_fd_pr__pfet_01v8 ad=1.848n pd=0.128m as=3.276n ps=0.246m w=84 l=15
X1246 row_addr_dff_0.dff_0.net4 row_addr_dff_0.dff_0.clkb row_addr_dff_0.dff_0.net3 din0[1] sky130_fd_pr__pfet_01v8 ad=2.915n pd=0.161m as=3.52n ps=0.238m w=55 l=15
X1247 din0[1] bank_0.replica_bitcell_array_0.replica_column_0.replica_cell_1rw_8.q din0[1] din0[1] sky130_fd_pr__pfet_01v8 ad=1.925n pd=0.18m as=0 ps=0 w=55 l=15
X1248 bank_0.replica_bitcell_array_0.replica_column_0.replica_cell_1rw_11.q bank_0.replica_bitcell_array_0.wl_0_4 din0[1] din0[1] sky130_fd_pr__nfet_01v8 ad=3.864n pd=0.21m as=1.428n ps=0.152m w=42 l=15
X1249 a_n519_n691# control_logic_rw_0.pdriver_0_0.pinv_7_0.A a_n597_n691# w_n2769_n767# sky130_fd_pr__pfet_01v8 ad=3.622n pd=0.178m as=3.622n ps=0.178m w=115 l=15
X1250 row_addr_dff_0.dff_2.clkb row_addr_dff_0.dff_3.clk din0[1] din0[1] sky130_fd_pr__pfet_01v8 ad=2.53n pd=0.202m as=2.53n ps=0.202m w=55 l=15
X1251 bank_0.replica_bitcell_array_0.dummy_array_2_0.dummy_cell_1rw_11.q bank_0.replica_bitcell_array_0.dummy_array_2_0.dummy_cell_1rw_11.qb din0[1] din0[1] sky130_fd_pr__nfet_01v8 ad=3.864n pd=0.21m as=4.41n ps=0.322m w=126 l=15
X1252 a_5053_1928# control_logic_rw_0.p_en_bar a_4999_1928# w_4605_1519# sky130_fd_pr__pfet_01v8 ad=1.848n pd=0.128m as=3.276n ps=0.246m w=84 l=15
X1253 din0[1] bank_0.replica_bitcell_array_0.bitcell_array_0.cell_1rw_31.q bank_0.replica_bitcell_array_0.bitcell_array_0.cell_1rw_31.qb din0[1] sky130_fd_pr__nfet_01v8 ad=4.41n pd=0.322m as=3.864n ps=0.21m w=126 l=15
X1254 din0[1] row_addr_dff_0.dout_3 row_addr_dff_0.dff_0.net5 din0[1] sky130_fd_pr__nfet_01v8 ad=1.68n pd=0.122m as=2.352n ps=0.196m w=42 l=15
X1255 din0[1] bank_0.replica_bitcell_array_0.dummy_array_3_0.dummy_cell_1rw_10.q bank_0.replica_bitcell_array_0.dummy_array_3_0.dummy_cell_1rw_10.qb din0[1] sky130_fd_pr__pfet_01v8 ad=1.925n pd=0.18m as=1.925n ps=0.18m w=55 l=15
X1256 a_n5055_4023# control_logic_rw_0.delay_chain_0.pinv_11_39.Z a_n5108_4023# din0[1] sky130_fd_pr__nfet_01v8 ad=1.638n pd=0.162m as=1.596n ps=0.16m w=42 l=15
X1257 a_2730_9937# bank_0.port_address_0.hierarchical_decoder_0.predecode_0 a_2676_9937# w_2422_9787# sky130_fd_pr__pfet_01v8 ad=1.848n pd=0.128m as=3.276n ps=0.246m w=84 l=15
X1258 din0[1] bank_0.replica_bitcell_array_0.dummy_array_3_0.dummy_cell_1rw_6.q bank_0.replica_bitcell_array_0.dummy_array_3_0.dummy_cell_1rw_6.qb din0[1] sky130_fd_pr__nfet_01v8 ad=4.41n pd=0.322m as=3.864n ps=0.21m w=126 l=15
X1259 a_1449_6883# bank_0.port_address_0.hierarchical_decoder_0.hierarchical_predecode2x4_0.pinv_1.Z a_1395_6883# w_1141_6733# sky130_fd_pr__pfet_01v8 ad=1.848n pd=0.128m as=3.276n ps=0.246m w=84 l=15
X1260 din0[1] bank_0.replica_bitcell_array_0.wl_0_3 bank_0.replica_bitcell_array_0.bitcell_array_0.cell_1rw_28.q din0[1] sky130_fd_pr__nfet_01v8 ad=1.428n pd=0.152m as=3.864n ps=0.21m w=42 l=15
X1261 a_n4427_3141# control_logic_rw_0.delay_chain_0.pinv_11_44.Z a_n4480_3141# w_n5644_2820# sky130_fd_pr__pfet_01v8 ad=3.276n pd=0.246m as=3.192n ps=0.244m w=84 l=15
X1262 din0[1] bank_0.replica_bitcell_array_0.replica_column_0.replica_cell_1rw_9.q din0[1] din0[1] sky130_fd_pr__pfet_01v8 ad=1.925n pd=0.18m as=0 ps=0 w=55 l=15
X1263 a_3797_11505# din0[1] a_3743_11505# din0[1] sky130_fd_pr__nfet_01v8 ad=1.596n pd=0.16m as=1.638n ps=0.162m w=42 l=15
X1264 din0[1] control_logic_rw_0.dff_buf_array_0.dff_buf_0_0.pinv_0_0.A control_logic_rw_0.dff_buf_array_0.dff_buf_0_0.dff_0.net5 din0[1] sky130_fd_pr__pfet_01v8 ad=2.2n pd=0.135m as=3.08n ps=0.222m w=55 l=15
X1265 a_3483_2957# din0[1] a_3424_2957# w_3116_2703# sky130_fd_pr__pfet_01v8 ad=3.192n pd=0.244m as=1.848n ps=0.128m w=84 l=15
X1266 a_n1274_n513# control_logic_rw_0.dff_buf_array_0.dout_bar_0 a_n1352_n513# w_n2769_n767# sky130_fd_pr__pfet_01v8 ad=3.528n pd=0.175m as=3.528n ps=0.175m w=112 l=15
C0 control_logic_rw_0.pand3_0.B control_logic_rw_0.delay_chain_0.out 2.48633f
C1 bank_0.port_address_0.hierarchical_decoder_0.predecode_2 bank_0.port_address_0.hierarchical_decoder_0.predecode_3 5.37298f
C2 bank_0.port_address_0.hierarchical_decoder_0.predecode_5 bank_0.port_address_0.hierarchical_decoder_0.predecode_4 5.22918f
C3 row_addr_dff_0.dout_2 row_addr_dff_0.dout_1 4.60186f
C4 row_addr_dff_0.dout_3 row_addr_dff_0.dout_2 8.55516f
C5 w_n2769_n767# control_logic_rw_0.dff_buf_array_0.dout_bar_0 2.5923f
C6 bank_0.port_address_0.hierarchical_decoder_0.predecode_1 bank_0.port_address_0.hierarchical_decoder_0.predecode_0 5.43708f
C7 bank_0.port_address_0.hierarchical_decoder_0.predecode_5 bank_0.port_address_0.hierarchical_decoder_0.predecode_6 5.31855f
C8 control_logic_rw_0.dff_buf_array_0.dout_bar_0 control_logic_rw_0.pand2_0.Z 5.64107f
C9 bank_0.port_address_0.hierarchical_decoder_0.predecode_3 bank_0.port_address_0.hierarchical_decoder_0.predecode_4 5.50661f
C10 control_logic_rw_0.dff_buf_array_0.dout_bar_0 control_logic_rw_0.dff_buf_array_0.dout_1 2.97961f
C11 control_logic_rw_0.dff_buf_array_0.dout_bar_0 control_logic_rw_0.delay_chain_0.out 3.43684f
C12 bank_0.port_address_0.hierarchical_decoder_0.predecode_7 bank_0.port_address_0.hierarchical_decoder_0.predecode_6 5.35956f
C13 bank_0.port_address_0.hierarchical_decoder_0.predecode_2 bank_0.port_address_0.hierarchical_decoder_0.predecode_1 5.71068f
C14 control_logic_rw_0.pdriver_0_0.gnd din0[1] 2.38411f ; **FLOATING
C15 data_dff_0.dff_0.net5 din0[1] 2.30867f
C16 data_dff_0.dff_0.net2 din0[1] 6.64566f
C17 data_dff_0.dff_1.net5 din0[1] 2.51497f
C18 data_dff_0.dff_1.net2 din0[1] 4.70123f
C19 data_dff_0.dff_1.net3 din0[1] 4.30278f
C20 control_logic_rw_0.dff_buf_array_0.dff_buf_0_1.dff_0.net2 din0[1] 4.32999f
C21 a_n2461_n513# din0[1] 2.36763f
C22 a_n2515_n513# din0[1] 2.36947f
C23 a_n3369_n227# din0[1] 5.94459f
C24 a_n3447_n227# din0[1] 5.94859f
C25 control_logic_rw_0.dff_buf_array_0.dff_buf_0_0.dff_0.net5 din0[1] 3.0395f
C26 control_logic_rw_0.dff_buf_array_0.dff_buf_0_0.dff_0.net2 din0[1] 2.35144f
C27 web0 din0[1] 2.54842f
C28 a_4793_1712# din0[1] 4.44492f
C29 a_4739_1712# din0[1] 4.44659f
C30 a_n4427_2449# din0[1] 2.52107f
C31 a_n4480_2449# din0[1] 2.51485f
C32 a_5010_3325# din0[1] 2.40088f
C33 bank_0.port_address_0.hierarchical_decoder_0.and2_dec_15.pnand2_0.nmos_m1_w0_840_sactive_dli_0.S din0[1] 3.61854f
C34 a_2676_3467# din0[1] 3.61164f
C35 a_n4741_3289# din0[1] 2.4536f
C36 a_n4794_3289# din0[1] 2.44853f
C37 bank_0.port_address_0.hierarchical_decoder_0.hierarchical_predecode2x4_1.and2_dec_2.pnand2_0.nmos_m1_w0_840_sactive_dli_0.S din0[1] 2.13884f
C38 a_2789_4485# din0[1] 2.04143f
C39 bank_0.port_address_0.hierarchical_decoder_0.and2_dec_13.pnand2_0.nmos_m1_w0_840_sactive_dli_0.S din0[1] 2.04219f
C40 a_1822_4485# din0[1] 2.43026f
C41 a_1768_4485# din0[1] 2.43663f
C42 a_2730_4847# din0[1] 2.28322f
C43 a_2676_4847# din0[1] 2.27274f
C44 a_n4741_4821# din0[1] 2.29598f
C45 a_n4794_4821# din0[1] 2.29132f
C46 a_1449_4993# din0[1] 2.24956f
C47 a_1395_4993# din0[1] 2.2384f
C48 a_n5369_4969# din0[1] 2.45203f
C49 a_n5422_4969# din0[1] 2.4466f
C50 a_3797_6011# din0[1] 5.90906f
C51 a_3743_6011# din0[1] 5.91438f
C52 a_5530_6379# din0[1] 2.47571f
C53 a_1822_6883# din0[1] 2.89701f
C54 a_n5055_6501# din0[1] 2.30641f
C55 a_n5108_6501# din0[1] 2.30117f
C56 a_1768_6883# din0[1] 2.90272f
C57 a_739_6883# din0[1] 2.83447f
C58 a_685_6883# din0[1] 2.83921f
C59 a_n4741_6649# din0[1] 2.46902f
C60 a_n4794_6649# din0[1] 2.46391f
C61 a_1822_7433# din0[1] 5.33555f
C62 a_1768_7433# din0[1] 5.34191f
C63 a_1508_7539# din0[1] 4.28364f
C64 bank_0.port_address_0.hierarchical_decoder_0.hierarchical_predecode2x4_0.and2_dec_1.pnand2_0.nmos_m1_w0_840_sactive_dli_0.S din0[1] 4.28536f
C65 a_n5369_8181# din0[1] 2.30159f
C66 a_n5422_8181# din0[1] 2.29606f
C67 a_n4741_9063# din0[1] 2.52522f
C68 a_n4794_9063# din0[1] 2.51904f
C69 a_3103_9469# din0[1] 2.65787f
C70 a_3049_9469# din0[1] 2.66413f
C71 bank_0.port_address_0.hierarchical_decoder_0.and2_dec_4.pnand2_0.nmos_m1_w0_840_sactive_dli_0.S din0[1] 2.28773f
C72 a_2676_9427# din0[1] 2.28207f
C73 a_5530_9619# din0[1] 2.49338f
C74 a_3103_9575# din0[1] 2.36001f
C75 a_3049_9575# din0[1] 2.36632f
C76 a_n4427_9861# din0[1] 7.15671f
C77 a_n4480_9861# din0[1] 7.15189f
C78 a_2730_10083# din0[1] 2.35083f
C79 a_2676_10083# din0[1] 2.34035f
C80 a_2789_10593# din0[1] 2.38995f
C81 bank_0.port_address_0.hierarchical_decoder_0.and2_dec_1.pnand2_0.nmos_m1_w0_840_sactive_dli_0.S din0[1] 2.3905f
C82 a_3483_10955# din0[1] 9.58981f
C83 a_3424_10955# din0[1] 10.05703f
C84 row_addr_dff_0.dff_2.net5 din0[1] 7.06166f
C85 a_4490_11469# din0[1] 2.55972f
C86 row_addr_dff_0.dff_1.net2 din0[1] 5.52658f
C87 w_n2769_n767# din0[1] 17.4507f
C88 w_n4225_n767# din0[1] 7.31929f
C89 w_n2769_44# din0[1] 11.6162f
C90 w_n2769_857# din0[1] 9.66068f
C91 w_n2769_1669# din0[1] 6.66748f
C92 w_4605_1519# din0[1] 11.8821f
C93 w_3116_2703# din0[1] 6.84936f
C94 w_2422_3679# din0[1] 13.3356f
C95 w_1141_3679# din0[1] 7.57496f
C96 w_431_3679# din0[1] 4.6745f
C97 w_n5644_2820# din0[1] 21.9701f
C98 w_2422_4697# din0[1] 13.2272f
C99 w_1141_4697# din0[1] 7.49573f
C100 w_n5644_4500# din0[1] 21.8977f
C101 w_2422_5715# din0[1] 13.2225f
C102 w_2422_6733# din0[1] 13.3934f
C103 w_1141_6733# din0[1] 7.51109f
C104 w_431_6733# din0[1] 4.57378f
C105 w_n5644_6180# din0[1] 21.9986f
C106 w_2422_7751# din0[1] 13.214f
C107 w_1141_7751# din0[1] 7.40295f
C108 w_n5644_7860# din0[1] 21.9463f
C109 w_2422_8769# din0[1] 13.1057f
C110 w_2422_9787# din0[1] 13.1419f
C111 w_n5644_9540# din0[1] 16.7195f
C112 w_2422_10805# din0[1] 13.141f
.ends
