* NGSPICE file created from sram_2_16_sky130A.ext - technology: sky130A

.option scale=10m

X0 vdd data_dff_0/dff_0/net3 data_dff_0/dff_0/net2 vdd sky130_fd_pr__pfet_01v8 ad=2.2n pd=0.135m as=2.915n ps=0.216m w=55 l=15
X1 data_dff_0/dff_0/net4 vdd data_dff_0/dff_0/net3 vdd sky130_fd_pr__pfet_01v8 ad=2.915n pd=0.161m as=3.52n ps=0.238m w=55 l=15
X2 vdd vdd vdd vdd sky130_fd_pr__nfet_01v8 ad=1.932n pd=0.176m as=1.932n ps=0.176m w=42 l=15
X3 data_dff_0/dff_0/net1 vdd vdd vdd sky130_fd_pr__nfet_01v8 ad=2.226n pd=0.148m as=1.932n ps=0.176m w=42 l=15
X4 vdd data_dff_0/dff_0/net3 data_dff_0/dff_0/net2 vdd sky130_fd_pr__nfet_01v8 ad=1.68n pd=0.122m as=2.226n ps=0.19m w=42 l=15
X5 data_dff_0/dff_0/net2 vdd data_dff_0/dff_0/net1 vdd sky130_fd_pr__nfet_01v8 ad=2.856n pd=0.22m as=2.226n ps=0.148m w=42 l=15
X6 data_dff_0/dff_0/net1 vdd vdd vdd sky130_fd_pr__pfet_01v8 ad=2.915n pd=0.161m as=2.53n ps=0.202m w=55 l=15
X7 data_dff_0/dff_0/net4 vdd data_dff_0/dff_0/net3 vdd sky130_fd_pr__nfet_01v8 ad=2.226n pd=0.148m as=2.73n ps=0.214m w=42 l=15
X8 vdd data_dff_0/dff_0/net4 vdd vdd sky130_fd_pr__nfet_01v8 ad=1.68n pd=0.164m as=1.68n ps=0.122m w=42 l=15
X9 data_dff_0/dff_0/net5 vdd data_dff_0/dff_0/net4 vdd sky130_fd_pr__pfet_01v8 ad=4.345n pd=0.268m as=2.915n ps=0.161m w=55 l=15
X10 data_dff_0/dff_0/net5 vdd data_dff_0/dff_0/net4 vdd sky130_fd_pr__nfet_01v8 ad=3.318n pd=0.242m as=2.226n ps=0.148m w=42 l=15
X11 vdd vdd vdd vdd sky130_fd_pr__pfet_01v8 ad=2.53n pd=0.202m as=2.53n ps=0.202m w=55 l=15
X12 vdd vdd data_dff_0/dff_0/net5 vdd sky130_fd_pr__nfet_01v8 ad=1.68n pd=0.122m as=2.352n ps=0.196m w=42 l=15
X13 vdd data_dff_0/dff_0/net4 vdd vdd sky130_fd_pr__pfet_01v8 ad=2.2n pd=0.19m as=2.2n ps=0.135m w=55 l=15
X14 data_dff_0/dff_0/net3 data_dff_0/dff_0/net1 vdd vdd sky130_fd_pr__pfet_01v8 ad=3.465n pd=0.236m as=2.2n ps=0.135m w=55 l=15
X15 data_dff_0/dff_0/net3 data_dff_0/dff_0/net1 vdd vdd sky130_fd_pr__nfet_01v8 ad=2.604n pd=0.208m as=1.68n ps=0.122m w=42 l=15
X16 data_dff_0/dff_0/net2 vdd data_dff_0/dff_0/net1 vdd sky130_fd_pr__pfet_01v8 ad=3.74n pd=0.246m as=2.915n ps=0.161m w=55 l=15
X17 vdd vdd data_dff_0/dff_0/net5 vdd sky130_fd_pr__pfet_01v8 ad=2.2n pd=0.135m as=3.08n ps=0.222m w=55 l=15
X18 vdd data_dff_0/dff_1/net3 data_dff_0/dff_1/net2 vdd sky130_fd_pr__pfet_01v8 ad=0.92835u pd=0.08837 as=6.655n ps=0.462m w=55 l=15
X19 vdd data_dff_0/dff_1/clkb data_dff_0/dff_1/net3 vdd sky130_fd_pr__pfet_01v8 ad=0 pd=0 as=6.985n ps=0.474m w=55 l=15
X20 data_dff_0/dff_1/clkb vdd vdd vdd sky130_fd_pr__nfet_01v8 ad=1.932n pd=0.176m as=1.57961u ps=0.11872 w=42 l=15
X21 data_dff_0/dff_1/net1 data_dff_0/dff_1/clkb din0[0] vdd sky130_fd_pr__nfet_01v8 ad=4.452n pd=0.296m as=1.932n ps=0.176m w=42 l=15
X22 vdd data_dff_0/dff_1/net3 data_dff_0/dff_1/net2 vdd sky130_fd_pr__nfet_01v8 ad=0 pd=0 as=5.082n ps=0.41m w=42 l=15
X23 data_dff_0/dff_1/net2 vdd data_dff_0/dff_1/net1 vdd sky130_fd_pr__nfet_01v8 ad=0 pd=0 as=0 ps=0 w=42 l=15
X24 data_dff_0/dff_1/net1 vdd din0[0] vdd sky130_fd_pr__pfet_01v8 ad=5.83n pd=0.322m as=2.53n ps=0.202m w=55 l=15
X25 vdd vdd data_dff_0/dff_1/net3 vdd sky130_fd_pr__nfet_01v8 ad=0 pd=0 as=5.334n ps=0.422m w=42 l=15
X26 vdd vdd vdd vdd sky130_fd_pr__nfet_01v8 ad=0 pd=0 as=0 ps=0 w=42 l=15
X27 data_dff_0/dff_1/net5 vdd vdd vdd sky130_fd_pr__pfet_01v8 ad=7.425n pd=0.49m as=0 ps=0 w=55 l=15
X28 data_dff_0/dff_1/net5 data_dff_0/dff_1/clkb vdd vdd sky130_fd_pr__nfet_01v8 ad=5.67n pd=0.438m as=0 ps=0 w=42 l=15
X29 data_dff_0/dff_1/clkb vdd vdd vdd sky130_fd_pr__pfet_01v8 ad=2.53n pd=0.202m as=0 ps=0 w=55 l=15
X30 vdd vdd data_dff_0/dff_1/net5 vdd sky130_fd_pr__nfet_01v8 ad=0 pd=0 as=0 ps=0 w=42 l=15
X31 vdd vdd vdd vdd sky130_fd_pr__pfet_01v8 ad=0 pd=0 as=0 ps=0 w=55 l=15
X32 data_dff_0/dff_1/net3 data_dff_0/dff_1/net1 vdd vdd sky130_fd_pr__pfet_01v8 ad=0 pd=0 as=0 ps=0 w=55 l=15
X33 data_dff_0/dff_1/net3 data_dff_0/dff_1/net1 vdd vdd sky130_fd_pr__nfet_01v8 ad=0 pd=0 as=0 ps=0 w=42 l=15
X34 data_dff_0/dff_1/net2 data_dff_0/dff_1/clkb data_dff_0/dff_1/net1 vdd sky130_fd_pr__pfet_01v8 ad=0 pd=0 as=0 ps=0 w=55 l=15
X35 vdd vdd data_dff_0/dff_1/net5 vdd sky130_fd_pr__pfet_01v8 ad=0 pd=0 as=0 ps=0 w=55 l=15
X36 control_logic_rw_0/pand3_0_0/pnand3_0_0/pmos_m1_w0_840_sli_dli_0/a_54_0# control_logic_rw_0/pand3_0_0/C control_logic_rw_0/pand3_0_0/pnand3_0_0/pmos_m1_w0_840_sli_dli_0/a_0_0# control_logic_rw_0/pinv_3_0/w_n127_195# sky130_fd_pr__pfet_01v8 ad=3.192n pd=0.244m as=3.276n ps=0.246m w=84 l=15
X37 control_logic_rw_0/pand3_0_0/pnand3_0_0/pmos_m1_w0_840_sli_dli_0/a_0_0# control_logic_rw_0/pand3_0/C control_logic_rw_0/pand3_0_0/pnand3_0_0/pmos_m1_w0_840_sli_dli_1/a_0_0# control_logic_rw_0/pinv_3_0/w_n127_195# sky130_fd_pr__pfet_01v8 ad=3.699n pd=0.259m as=3.699n ps=0.259m w=84 l=15
X38 control_logic_rw_0/pand3_0_0/pnand3_0_0/pmos_m1_w0_840_sli_dli_1/a_0_0# control_logic_rw_0/pinv_3_0/A control_logic_rw_0/pand3_0_0/pnand3_0_0/pmos_m1_w0_840_sli_dli_2/a_0_0# control_logic_rw_0/pinv_3_0/w_n127_195# sky130_fd_pr__pfet_01v8 ad=0 pd=0 as=3.277n ps=0.247m w=84 l=15
X39 control_logic_rw_0/pand3_0_0/pnand3_0_0/nmos_m1_w0_840_sli_dactive_0/D control_logic_rw_0/pinv_3_0/A control_logic_rw_0/pand3_0_0/pnand3_0_0/nmos_m1_w0_840_sli_dactive_0/a_0_0# vdd sky130_fd_pr__nfet_01v8 ad=3.192n pd=0.244m as=3.276n ps=0.246m w=84 l=15
X40 control_logic_rw_0/pand3_0_0/pnand3_0_0/nmos_m1_w0_840_sactive_dli_0/a_54_0# control_logic_rw_0/pand3_0_0/C control_logic_rw_0/pand3_0_0/pnand3_0_0/nmos_m1_w0_840_sactive_dli_0/S vdd sky130_fd_pr__nfet_01v8 ad=3.192n pd=0.244m as=3.276n ps=0.246m w=84 l=15
X41 control_logic_rw_0/pand3_0_0/pnand3_0_0/nmos_m1_w0_840_sactive_dli_0/S control_logic_rw_0/pand3_0/C control_logic_rw_0/pand3_0_0/pnand3_0_0/nmos_m1_w0_840_sli_dactive_0/D vdd sky130_fd_pr__nfet_01v8 ad=3.192n pd=0.244m as=3.276n ps=0.246m w=84 l=15
X42 control_logic_rw_0/pand3_0_0/pdriver_3_0/pinv_10_0/nmos_m2_w0_420_sli_dli_da_p_0/a_132_0# control_logic_rw_0/pand3_0_0/C control_logic_rw_0/pand3_0_0/pdriver_3_0/pinv_10_0/nmos_m2_w0_420_sli_dli_da_p_0/a_54_0# vdd sky130_fd_pr__nfet_01v8 ad=1.596n pd=0.16m as=1.323n ps=0.105m w=42 l=15
X43 control_logic_rw_0/pand3_0_0/pdriver_3_0/pinv_10_0/nmos_m2_w0_420_sli_dli_da_p_0/a_54_0# control_logic_rw_0/pand3_0_0/C control_logic_rw_0/pand3_0_0/pdriver_3_0/pinv_10_0/nmos_m2_w0_420_sli_dli_da_p_0/a_0_0# vdd sky130_fd_pr__nfet_01v8 ad=1.323n pd=0.105m as=1.638n ps=0.162m w=42 l=15
X44 control_logic_rw_0/pand3_0_0/pdriver_3_0/pinv_10_0/pmos_m2_w0_840_sli_dli_da_p_0/a_54_0# control_logic_rw_0/pand3_0_0/C control_logic_rw_0/pand3_0_0/pdriver_3_0/pinv_10_0/pmos_m2_w0_840_sli_dli_da_p_0/a_0_0# control_logic_rw_0/pinv_3_0/w_n127_195# sky130_fd_pr__pfet_01v8 ad=2.646n pd=0.147m as=3.276n ps=0.246m w=84 l=15
X45 control_logic_rw_0/pand3_0_0/pdriver_3_0/pinv_10_0/pmos_m2_w0_840_sli_dli_da_p_0/a_132_0# control_logic_rw_0/pand3_0_0/C control_logic_rw_0/pand3_0_0/pdriver_3_0/pinv_10_0/pmos_m2_w0_840_sli_dli_da_p_0/a_54_0# control_logic_rw_0/pinv_3_0/w_n127_195# sky130_fd_pr__pfet_01v8 ad=3.192n pd=0.244m as=2.646n ps=0.147m w=84 l=15
X46 vdd control_logic_rw_0/dff_buf_array_0/dff_buf_0_1/dff_0/net3 control_logic_rw_0/dff_buf_array_0/dff_buf_0_1/dff_0/net2 vdd sky130_fd_pr__pfet_01v8 ad=0 pd=0 as=6.655n ps=0.462m w=55 l=15
X47 control_logic_rw_0/dff_buf_array_0/dff_buf_0_1/dff_0/net4 control_logic_rw_0/dff_buf_array_0/dff_buf_0_1/dff_0/clkb control_logic_rw_0/dff_buf_array_0/dff_buf_0_1/dff_0/net3 vdd sky130_fd_pr__pfet_01v8 ad=5.83n pd=0.322m as=6.985n ps=0.474m w=55 l=15
X48 control_logic_rw_0/dff_buf_array_0/dff_buf_0_1/dff_0/clkb vdd vdd vdd sky130_fd_pr__nfet_01v8 ad=1.932n pd=0.176m as=0 ps=0 w=42 l=15
X49 control_logic_rw_0/dff_buf_array_0/dff_buf_0_1/dff_0/net1 control_logic_rw_0/dff_buf_array_0/dff_buf_0_1/dff_0/clkb csb0 vdd sky130_fd_pr__nfet_01v8 ad=4.452n pd=0.296m as=1.932n ps=0.176m w=42 l=15
X50 vdd control_logic_rw_0/dff_buf_array_0/dff_buf_0_1/dff_0/net3 control_logic_rw_0/dff_buf_array_0/dff_buf_0_1/dff_0/net2 vdd sky130_fd_pr__nfet_01v8 ad=0 pd=0 as=5.082n ps=0.41m w=42 l=15
X51 control_logic_rw_0/dff_buf_array_0/dff_buf_0_1/dff_0/net2 vdd control_logic_rw_0/dff_buf_array_0/dff_buf_0_1/dff_0/net1 vdd sky130_fd_pr__nfet_01v8 ad=0 pd=0 as=0 ps=0 w=42 l=15
X52 control_logic_rw_0/dff_buf_array_0/dff_buf_0_1/dff_0/net1 vdd csb0 vdd sky130_fd_pr__pfet_01v8 ad=5.83n pd=0.322m as=2.53n ps=0.202m w=55 l=15
X53 control_logic_rw_0/dff_buf_array_0/dff_buf_0_1/dff_0/net4 vdd control_logic_rw_0/dff_buf_array_0/dff_buf_0_1/dff_0/net3 vdd sky130_fd_pr__nfet_01v8 ad=4.452n pd=0.296m as=5.334n ps=0.422m w=42 l=15
X54 control_logic_rw_0/dff_buf_array_0/dff_buf_0_1/dff_0/Q control_logic_rw_0/dff_buf_array_0/dff_buf_0_1/dff_0/net4 vdd vdd sky130_fd_pr__nfet_01v8 ad=1.68n pd=0.164m as=0 ps=0 w=42 l=15
X55 control_logic_rw_0/dff_buf_array_0/dff_buf_0_1/dff_0/net5 vdd control_logic_rw_0/dff_buf_array_0/dff_buf_0_1/dff_0/net4 vdd sky130_fd_pr__pfet_01v8 ad=7.425n pd=0.49m as=0 ps=0 w=55 l=15
X56 control_logic_rw_0/dff_buf_array_0/dff_buf_0_1/dff_0/net5 control_logic_rw_0/dff_buf_array_0/dff_buf_0_1/dff_0/clkb control_logic_rw_0/dff_buf_array_0/dff_buf_0_1/dff_0/net4 vdd sky130_fd_pr__nfet_01v8 ad=5.67n pd=0.438m as=0 ps=0 w=42 l=15
X57 control_logic_rw_0/dff_buf_array_0/dff_buf_0_1/dff_0/clkb vdd vdd vdd sky130_fd_pr__pfet_01v8 ad=2.53n pd=0.202m as=0 ps=0 w=55 l=15
X58 vdd control_logic_rw_0/dff_buf_array_0/dff_buf_0_1/dff_0/Q control_logic_rw_0/dff_buf_array_0/dff_buf_0_1/dff_0/net5 vdd sky130_fd_pr__nfet_01v8 ad=0 pd=0 as=0 ps=0 w=42 l=15
X59 control_logic_rw_0/dff_buf_array_0/dff_buf_0_1/dff_0/Q control_logic_rw_0/dff_buf_array_0/dff_buf_0_1/dff_0/net4 vdd vdd sky130_fd_pr__pfet_01v8 ad=2.2n pd=0.19m as=0 ps=0 w=55 l=15
X60 control_logic_rw_0/dff_buf_array_0/dff_buf_0_1/dff_0/net3 control_logic_rw_0/dff_buf_array_0/dff_buf_0_1/dff_0/net1 vdd vdd sky130_fd_pr__pfet_01v8 ad=0 pd=0 as=0 ps=0 w=55 l=15
X61 control_logic_rw_0/dff_buf_array_0/dff_buf_0_1/dff_0/net3 control_logic_rw_0/dff_buf_array_0/dff_buf_0_1/dff_0/net1 vdd vdd sky130_fd_pr__nfet_01v8 ad=0 pd=0 as=0 ps=0 w=42 l=15
X62 control_logic_rw_0/dff_buf_array_0/dff_buf_0_1/dff_0/net2 control_logic_rw_0/dff_buf_array_0/dff_buf_0_1/dff_0/clkb control_logic_rw_0/dff_buf_array_0/dff_buf_0_1/dff_0/net1 vdd sky130_fd_pr__pfet_01v8 ad=0 pd=0 as=0 ps=0 w=55 l=15
X63 vdd control_logic_rw_0/dff_buf_array_0/dff_buf_0_1/dff_0/Q control_logic_rw_0/dff_buf_array_0/dff_buf_0_1/dff_0/net5 vdd sky130_fd_pr__pfet_01v8 ad=0 pd=0 as=0 ps=0 w=55 l=15
X64 control_logic_rw_0/dff_buf_array_0/dff_buf_0_1/pinv_1_0/pmos_m3_w1_120_sli_dli_da_p_0/a_210_0# control_logic_rw_0/pand3_0/C control_logic_rw_0/dff_buf_array_0/dff_buf_0_1/pinv_1_0/pmos_m3_w1_120_sli_dli_da_p_0/a_132_0# control_logic_rw_0/dff_buf_array_0/dff_buf_0_1/pinv_1_0/w_n127_195# sky130_fd_pr__pfet_01v8 ad=4.256n pd=0.3m as=3.528n ps=0.175m w=112 l=15
X65 control_logic_rw_0/dff_buf_array_0/dff_buf_0_1/pinv_1_0/pmos_m3_w1_120_sli_dli_da_p_0/a_54_0# control_logic_rw_0/pand3_0/C control_logic_rw_0/dff_buf_array_0/dff_buf_0_1/pinv_1_0/pmos_m3_w1_120_sli_dli_da_p_0/a_0_0# control_logic_rw_0/dff_buf_array_0/dff_buf_0_1/pinv_1_0/w_n127_195# sky130_fd_pr__pfet_01v8 ad=3.528n pd=0.175m as=4.368n ps=0.302m w=112 l=15
X66 control_logic_rw_0/dff_buf_array_0/dff_buf_0_1/pinv_1_0/pmos_m3_w1_120_sli_dli_da_p_0/a_132_0# control_logic_rw_0/pand3_0/C control_logic_rw_0/dff_buf_array_0/dff_buf_0_1/pinv_1_0/pmos_m3_w1_120_sli_dli_da_p_0/a_54_0# control_logic_rw_0/dff_buf_array_0/dff_buf_0_1/pinv_1_0/w_n127_195# sky130_fd_pr__pfet_01v8 ad=3.528n pd=0.175m as=3.528n ps=0.175m w=112 l=15
X67 control_logic_rw_0/dff_buf_array_0/dff_buf_0_1/pinv_1_0/nmos_m3_w0_560_sli_dli_da_p_0/a_132_0# control_logic_rw_0/pand3_0/C control_logic_rw_0/dff_buf_array_0/dff_buf_0_1/pinv_1_0/nmos_m3_w0_560_sli_dli_da_p_0/a_54_0# vdd sky130_fd_pr__nfet_01v8 ad=1.764n pd=0.119m as=1.764n ps=0.119m w=56 l=15
X68 control_logic_rw_0/dff_buf_array_0/dff_buf_0_1/pinv_1_0/nmos_m3_w0_560_sli_dli_da_p_0/a_210_0# control_logic_rw_0/pand3_0/C control_logic_rw_0/dff_buf_array_0/dff_buf_0_1/pinv_1_0/nmos_m3_w0_560_sli_dli_da_p_0/a_132_0# vdd sky130_fd_pr__nfet_01v8 ad=2.128n pd=0.188m as=1.764n ps=0.119m w=56 l=15
X69 control_logic_rw_0/dff_buf_array_0/dff_buf_0_1/pinv_1_0/nmos_m3_w0_560_sli_dli_da_p_0/a_54_0# control_logic_rw_0/pand3_0/C control_logic_rw_0/dff_buf_array_0/dff_buf_0_1/pinv_1_0/nmos_m3_w0_560_sli_dli_da_p_0/a_0_0# vdd sky130_fd_pr__nfet_01v8 ad=1.764n pd=0.119m as=2.184n ps=0.19m w=56 l=15
X70 control_logic_rw_0/dff_buf_array_0/dff_buf_0_1/pinv_0_0/nmos_m2_w0_420_sli_dli_da_p_0/a_132_0# control_logic_rw_0/dff_buf_array_0/dff_buf_0_1/dff_0/Q control_logic_rw_0/dff_buf_array_0/dff_buf_0_1/pinv_0_0/nmos_m2_w0_420_sli_dli_da_p_0/a_54_0# vdd sky130_fd_pr__nfet_01v8 ad=1.597n pd=0.161m as=2.647n ps=0.211m w=42 l=15
X71 control_logic_rw_0/dff_buf_array_0/dff_buf_0_1/pinv_0_0/nmos_m2_w0_420_sli_dli_da_p_0/a_54_0# control_logic_rw_0/dff_buf_array_0/dff_buf_0_1/dff_0/Q control_logic_rw_0/dff_buf_array_0/dff_buf_0_1/pinv_0_0/nmos_m2_w0_420_sli_dli_da_p_0/a_0_0# vdd sky130_fd_pr__nfet_01v8 ad=0 pd=0 as=1.639n ps=0.163m w=42 l=15
X72 control_logic_rw_0/dff_buf_array_0/dff_buf_0_1/pinv_0_0/pmos_m2_w0_840_sli_dli_da_p_0/a_54_0# control_logic_rw_0/dff_buf_array_0/dff_buf_0_1/dff_0/Q control_logic_rw_0/dff_buf_array_0/dff_buf_0_1/pinv_0_0/pmos_m2_w0_840_sli_dli_da_p_0/a_0_0# control_logic_rw_0/dff_buf_array_0/dff_buf_0_1/pinv_1_0/w_n127_195# sky130_fd_pr__pfet_01v8 ad=5.293n pd=0.295m as=3.277n ps=0.247m w=84 l=15
X73 control_logic_rw_0/dff_buf_array_0/dff_buf_0_1/pinv_0_0/pmos_m2_w0_840_sli_dli_da_p_0/a_132_0# control_logic_rw_0/dff_buf_array_0/dff_buf_0_1/dff_0/Q control_logic_rw_0/dff_buf_array_0/dff_buf_0_1/pinv_0_0/pmos_m2_w0_840_sli_dli_da_p_0/a_54_0# control_logic_rw_0/dff_buf_array_0/dff_buf_0_1/pinv_1_0/w_n127_195# sky130_fd_pr__pfet_01v8 ad=3.193n pd=0.245m as=0 ps=0 w=84 l=15
X74 vdd control_logic_rw_0/dff_buf_array_0/dff_buf_0_0/dff_0/net3 control_logic_rw_0/dff_buf_array_0/dff_buf_0_0/dff_0/net2 vdd sky130_fd_pr__pfet_01v8 ad=0 pd=0 as=6.655n ps=0.462m w=55 l=15
X75 control_logic_rw_0/dff_buf_array_0/dff_buf_0_0/dff_0/net4 control_logic_rw_0/dff_buf_array_0/dff_buf_0_0/dff_0/clkb control_logic_rw_0/dff_buf_array_0/dff_buf_0_0/dff_0/net3 vdd sky130_fd_pr__pfet_01v8 ad=5.83n pd=0.322m as=6.985n ps=0.474m w=55 l=15
X76 control_logic_rw_0/dff_buf_array_0/dff_buf_0_0/dff_0/clkb vdd vdd vdd sky130_fd_pr__nfet_01v8 ad=1.932n pd=0.176m as=0 ps=0 w=42 l=15
X77 control_logic_rw_0/dff_buf_array_0/dff_buf_0_0/dff_0/net1 control_logic_rw_0/dff_buf_array_0/dff_buf_0_0/dff_0/clkb web0 vdd sky130_fd_pr__nfet_01v8 ad=4.452n pd=0.296m as=1.932n ps=0.176m w=42 l=15
X78 vdd control_logic_rw_0/dff_buf_array_0/dff_buf_0_0/dff_0/net3 control_logic_rw_0/dff_buf_array_0/dff_buf_0_0/dff_0/net2 vdd sky130_fd_pr__nfet_01v8 ad=0 pd=0 as=5.082n ps=0.41m w=42 l=15
X79 control_logic_rw_0/dff_buf_array_0/dff_buf_0_0/dff_0/net2 vdd control_logic_rw_0/dff_buf_array_0/dff_buf_0_0/dff_0/net1 vdd sky130_fd_pr__nfet_01v8 ad=0 pd=0 as=0 ps=0 w=42 l=15
X80 control_logic_rw_0/dff_buf_array_0/dff_buf_0_0/dff_0/net1 vdd web0 vdd sky130_fd_pr__pfet_01v8 ad=5.83n pd=0.322m as=2.53n ps=0.202m w=55 l=15
X81 control_logic_rw_0/dff_buf_array_0/dff_buf_0_0/dff_0/net4 vdd control_logic_rw_0/dff_buf_array_0/dff_buf_0_0/dff_0/net3 vdd sky130_fd_pr__nfet_01v8 ad=4.452n pd=0.296m as=5.334n ps=0.422m w=42 l=15
X82 control_logic_rw_0/dff_buf_array_0/dff_buf_0_0/dff_0/Q control_logic_rw_0/dff_buf_array_0/dff_buf_0_0/dff_0/net4 vdd vdd sky130_fd_pr__nfet_01v8 ad=1.68n pd=0.164m as=0 ps=0 w=42 l=15
X83 control_logic_rw_0/dff_buf_array_0/dff_buf_0_0/dff_0/net5 vdd control_logic_rw_0/dff_buf_array_0/dff_buf_0_0/dff_0/net4 vdd sky130_fd_pr__pfet_01v8 ad=7.425n pd=0.49m as=0 ps=0 w=55 l=15
X84 control_logic_rw_0/dff_buf_array_0/dff_buf_0_0/dff_0/net5 control_logic_rw_0/dff_buf_array_0/dff_buf_0_0/dff_0/clkb control_logic_rw_0/dff_buf_array_0/dff_buf_0_0/dff_0/net4 vdd sky130_fd_pr__nfet_01v8 ad=5.67n pd=0.438m as=0 ps=0 w=42 l=15
X85 control_logic_rw_0/dff_buf_array_0/dff_buf_0_0/dff_0/clkb vdd vdd vdd sky130_fd_pr__pfet_01v8 ad=2.53n pd=0.202m as=0 ps=0 w=55 l=15
X86 vdd control_logic_rw_0/dff_buf_array_0/dff_buf_0_0/dff_0/Q control_logic_rw_0/dff_buf_array_0/dff_buf_0_0/dff_0/net5 vdd sky130_fd_pr__nfet_01v8 ad=0 pd=0 as=0 ps=0 w=42 l=15
X87 control_logic_rw_0/dff_buf_array_0/dff_buf_0_0/dff_0/Q control_logic_rw_0/dff_buf_array_0/dff_buf_0_0/dff_0/net4 vdd vdd sky130_fd_pr__pfet_01v8 ad=2.2n pd=0.19m as=0 ps=0 w=55 l=15
X88 control_logic_rw_0/dff_buf_array_0/dff_buf_0_0/dff_0/net3 control_logic_rw_0/dff_buf_array_0/dff_buf_0_0/dff_0/net1 vdd vdd sky130_fd_pr__pfet_01v8 ad=0 pd=0 as=0 ps=0 w=55 l=15
X89 control_logic_rw_0/dff_buf_array_0/dff_buf_0_0/dff_0/net3 control_logic_rw_0/dff_buf_array_0/dff_buf_0_0/dff_0/net1 vdd vdd sky130_fd_pr__nfet_01v8 ad=0 pd=0 as=0 ps=0 w=42 l=15
X90 control_logic_rw_0/dff_buf_array_0/dff_buf_0_0/dff_0/net2 control_logic_rw_0/dff_buf_array_0/dff_buf_0_0/dff_0/clkb control_logic_rw_0/dff_buf_array_0/dff_buf_0_0/dff_0/net1 vdd sky130_fd_pr__pfet_01v8 ad=0 pd=0 as=0 ps=0 w=55 l=15
X91 vdd control_logic_rw_0/dff_buf_array_0/dff_buf_0_0/dff_0/Q control_logic_rw_0/dff_buf_array_0/dff_buf_0_0/dff_0/net5 vdd sky130_fd_pr__pfet_01v8 ad=0 pd=0 as=0 ps=0 w=55 l=15
X92 control_logic_rw_0/dff_buf_array_0/dff_buf_0_0/pinv_1_0/pmos_m3_w1_120_sli_dli_da_p_0/a_210_0# control_logic_rw_0/pand3_0/C control_logic_rw_0/dff_buf_array_0/dff_buf_0_0/pinv_1_0/pmos_m3_w1_120_sli_dli_da_p_0/a_132_0# control_logic_rw_0/dff_buf_array_0/dff_buf_0_1/pinv_1_0/w_n127_195# sky130_fd_pr__pfet_01v8 ad=4.257n pd=0.301m as=7.057n ps=0.351m w=112 l=15
X93 control_logic_rw_0/dff_buf_array_0/dff_buf_0_0/pinv_1_0/pmos_m3_w1_120_sli_dli_da_p_0/a_54_0# control_logic_rw_0/pand3_0/C control_logic_rw_0/dff_buf_array_0/dff_buf_0_0/pinv_1_0/pmos_m3_w1_120_sli_dli_da_p_0/a_0_0# control_logic_rw_0/dff_buf_array_0/dff_buf_0_1/pinv_1_0/w_n127_195# sky130_fd_pr__pfet_01v8 ad=7.057n pd=0.351m as=4.369n ps=0.303m w=112 l=15
X94 control_logic_rw_0/dff_buf_array_0/dff_buf_0_0/pinv_1_0/pmos_m3_w1_120_sli_dli_da_p_0/a_132_0# control_logic_rw_0/pand3_0/C control_logic_rw_0/dff_buf_array_0/dff_buf_0_0/pinv_1_0/pmos_m3_w1_120_sli_dli_da_p_0/a_54_0# control_logic_rw_0/dff_buf_array_0/dff_buf_0_1/pinv_1_0/w_n127_195# sky130_fd_pr__pfet_01v8 ad=0 pd=0 as=0 ps=0 w=112 l=15
X95 control_logic_rw_0/dff_buf_array_0/dff_buf_0_0/pinv_1_0/nmos_m3_w0_560_sli_dli_da_p_0/a_132_0# control_logic_rw_0/pand3_0/C control_logic_rw_0/dff_buf_array_0/dff_buf_0_0/pinv_1_0/nmos_m3_w0_560_sli_dli_da_p_0/a_54_0# vdd sky130_fd_pr__nfet_01v8 ad=3.529n pd=0.239m as=3.529n ps=0.239m w=56 l=15
X96 control_logic_rw_0/dff_buf_array_0/dff_buf_0_0/pinv_1_0/nmos_m3_w0_560_sli_dli_da_p_0/a_210_0# control_logic_rw_0/pand3_0/C control_logic_rw_0/dff_buf_array_0/dff_buf_0_0/pinv_1_0/nmos_m3_w0_560_sli_dli_da_p_0/a_132_0# vdd sky130_fd_pr__nfet_01v8 ad=2.129n pd=0.189m as=0 ps=0 w=56 l=15
X97 control_logic_rw_0/dff_buf_array_0/dff_buf_0_0/pinv_1_0/nmos_m3_w0_560_sli_dli_da_p_0/a_54_0# control_logic_rw_0/pand3_0/C control_logic_rw_0/dff_buf_array_0/dff_buf_0_0/pinv_1_0/nmos_m3_w0_560_sli_dli_da_p_0/a_0_0# vdd sky130_fd_pr__nfet_01v8 ad=0 pd=0 as=2.185n ps=0.191m w=56 l=15
X98 control_logic_rw_0/dff_buf_array_0/dff_buf_0_0/pinv_0_0/nmos_m2_w0_420_sli_dli_da_p_0/a_132_0# control_logic_rw_0/dff_buf_array_0/dff_buf_0_0/dff_0/Q control_logic_rw_0/dff_buf_array_0/dff_buf_0_0/pinv_0_0/nmos_m2_w0_420_sli_dli_da_p_0/a_54_0# vdd sky130_fd_pr__nfet_01v8 ad=1.597n pd=0.161m as=2.647n ps=0.211m w=42 l=15
X99 control_logic_rw_0/dff_buf_array_0/dff_buf_0_0/pinv_0_0/nmos_m2_w0_420_sli_dli_da_p_0/a_54_0# control_logic_rw_0/dff_buf_array_0/dff_buf_0_0/dff_0/Q control_logic_rw_0/dff_buf_array_0/dff_buf_0_0/pinv_0_0/nmos_m2_w0_420_sli_dli_da_p_0/a_0_0# vdd sky130_fd_pr__nfet_01v8 ad=0 pd=0 as=1.639n ps=0.163m w=42 l=15
X100 control_logic_rw_0/dff_buf_array_0/dff_buf_0_0/pinv_0_0/pmos_m2_w0_840_sli_dli_da_p_0/a_54_0# control_logic_rw_0/dff_buf_array_0/dff_buf_0_0/dff_0/Q control_logic_rw_0/dff_buf_array_0/dff_buf_0_0/pinv_0_0/pmos_m2_w0_840_sli_dli_da_p_0/a_0_0# control_logic_rw_0/dff_buf_array_0/dff_buf_0_1/pinv_1_0/w_n127_195# sky130_fd_pr__pfet_01v8 ad=5.293n pd=0.295m as=3.277n ps=0.247m w=84 l=15
X101 control_logic_rw_0/dff_buf_array_0/dff_buf_0_0/pinv_0_0/pmos_m2_w0_840_sli_dli_da_p_0/a_132_0# control_logic_rw_0/dff_buf_array_0/dff_buf_0_0/dff_0/Q control_logic_rw_0/dff_buf_array_0/dff_buf_0_0/pinv_0_0/pmos_m2_w0_840_sli_dli_da_p_0/a_54_0# control_logic_rw_0/dff_buf_array_0/dff_buf_0_1/pinv_1_0/w_n127_195# sky130_fd_pr__pfet_01v8 ad=3.193n pd=0.245m as=0 ps=0 w=84 l=15
X102 control_logic_rw_0/pand3_0/pnand3_0_0/pmos_m1_w0_840_sli_dli_0/a_54_0# control_logic_rw_0/pand3_0/C control_logic_rw_0/pand3_0/pnand3_0_0/pmos_m1_w0_840_sli_dli_0/a_0_0# control_logic_rw_0/pnand2_1_0/w_n127_195# sky130_fd_pr__pfet_01v8 ad=3.193n pd=0.245m as=3.699n ps=0.259m w=84 l=15
X103 control_logic_rw_0/pand3_0/pnand3_0_0/pmos_m1_w0_840_sli_dli_0/a_0_0# control_logic_rw_0/pand3_0/B control_logic_rw_0/pand3_0/pnand3_0_0/pmos_m1_w0_840_sli_dli_1/a_0_0# control_logic_rw_0/pnand2_1_0/w_n127_195# sky130_fd_pr__pfet_01v8 ad=0 pd=0 as=3.699n ps=0.259m w=84 l=15
X104 control_logic_rw_0/pand3_0/pnand3_0_0/pmos_m1_w0_840_sli_dli_1/a_0_0# control_logic_rw_0/pand3_0/C control_logic_rw_0/pand3_0/pnand3_0_0/pmos_m1_w0_840_sli_dli_2/a_0_0# control_logic_rw_0/pnand2_1_0/w_n127_195# sky130_fd_pr__pfet_01v8 ad=0 pd=0 as=3.277n ps=0.247m w=84 l=15
X105 control_logic_rw_0/pand3_0/pnand3_0_0/nmos_m1_w0_840_sli_dactive_0/D control_logic_rw_0/pand3_0/C control_logic_rw_0/pand3_0/pnand3_0_0/nmos_m1_w0_840_sli_dactive_0/a_0_0# vdd sky130_fd_pr__nfet_01v8 ad=3.697n pd=0.257m as=3.277n ps=0.247m w=84 l=15
X106 control_logic_rw_0/pand3_0/pnand3_0_0/nmos_m1_w0_840_sactive_dli_0/a_54_0# control_logic_rw_0/pand3_0/C control_logic_rw_0/pand3_0/pnand3_0_0/nmos_m1_w0_840_sactive_dli_0/S vdd sky130_fd_pr__nfet_01v8 ad=3.193n pd=0.245m as=3.697n ps=0.257m w=84 l=15
X107 control_logic_rw_0/pand3_0/pnand3_0_0/nmos_m1_w0_840_sactive_dli_0/S control_logic_rw_0/pand3_0/B control_logic_rw_0/pand3_0/pnand3_0_0/nmos_m1_w0_840_sli_dactive_0/D vdd sky130_fd_pr__nfet_01v8 ad=0 pd=0 as=0 ps=0 w=84 l=15
X108 control_logic_rw_0/pand3_0/pdriver_2_0/pinv_9_0/nmos_m7_w0_600_sli_dli_da_p_0/a_132_0# control_logic_rw_0/pand3_0/C control_logic_rw_0/pand3_0/pdriver_2_0/pinv_9_0/nmos_m7_w0_600_sli_dli_da_p_0/a_54_0# vdd sky130_fd_pr__nfet_01v8 ad=1.89n pd=0.123m as=1.89n ps=0.123m w=60 l=15
X109 control_logic_rw_0/pand3_0/pdriver_2_0/pinv_9_0/nmos_m7_w0_600_sli_dli_da_p_0/a_366_0# control_logic_rw_0/pand3_0/C control_logic_rw_0/pand3_0/pdriver_2_0/pinv_9_0/nmos_m7_w0_600_sli_dli_da_p_0/a_288_0# vdd sky130_fd_pr__nfet_01v8 ad=1.89n pd=0.123m as=1.89n ps=0.123m w=60 l=15
X110 control_logic_rw_0/pand3_0/pdriver_2_0/pinv_9_0/nmos_m7_w0_600_sli_dli_da_p_0/a_288_0# control_logic_rw_0/pand3_0/C control_logic_rw_0/pand3_0/pdriver_2_0/pinv_9_0/nmos_m7_w0_600_sli_dli_da_p_0/a_210_0# vdd sky130_fd_pr__nfet_01v8 ad=1.89n pd=0.123m as=1.89n ps=0.123m w=60 l=15
X111 control_logic_rw_0/pand3_0/pdriver_2_0/pinv_9_0/nmos_m7_w0_600_sli_dli_da_p_0/a_210_0# control_logic_rw_0/pand3_0/C control_logic_rw_0/pand3_0/pdriver_2_0/pinv_9_0/nmos_m7_w0_600_sli_dli_da_p_0/a_132_0# vdd sky130_fd_pr__nfet_01v8 ad=1.89n pd=0.123m as=1.89n ps=0.123m w=60 l=15
X112 control_logic_rw_0/pand3_0/pdriver_2_0/pinv_9_0/nmos_m7_w0_600_sli_dli_da_p_0/a_54_0# control_logic_rw_0/pand3_0/C control_logic_rw_0/pand3_0/pdriver_2_0/pinv_9_0/nmos_m7_w0_600_sli_dli_da_p_0/a_0_0# vdd sky130_fd_pr__nfet_01v8 ad=1.89n pd=0.123m as=2.34n ps=0.198m w=60 l=15
X113 control_logic_rw_0/pand3_0/pdriver_2_0/pinv_9_0/nmos_m7_w0_600_sli_dli_da_p_0/a_522_0# control_logic_rw_0/pand3_0/C control_logic_rw_0/pand3_0/pdriver_2_0/pinv_9_0/nmos_m7_w0_600_sli_dli_da_p_0/a_444_0# vdd sky130_fd_pr__nfet_01v8 ad=2.28n pd=0.196m as=1.89n ps=0.123m w=60 l=15
X114 control_logic_rw_0/pand3_0/pdriver_2_0/pinv_9_0/nmos_m7_w0_600_sli_dli_da_p_0/a_444_0# control_logic_rw_0/pand3_0/C control_logic_rw_0/pand3_0/pdriver_2_0/pinv_9_0/nmos_m7_w0_600_sli_dli_da_p_0/a_366_0# vdd sky130_fd_pr__nfet_01v8 ad=1.89n pd=0.123m as=1.89n ps=0.123m w=60 l=15
X115 control_logic_rw_0/pand3_0/pdriver_2_0/pinv_9_0/pmos_m7_w1_200_sli_dli_da_p_0/a_288_0# control_logic_rw_0/pand3_0/C control_logic_rw_0/pand3_0/pdriver_2_0/pinv_9_0/pmos_m7_w1_200_sli_dli_da_p_0/a_210_0# control_logic_rw_0/pnand2_1_0/w_n127_195# sky130_fd_pr__pfet_01v8 ad=3.78n pd=0.183m as=3.78n ps=0.183m w=120 l=15
X116 control_logic_rw_0/pand3_0/pdriver_2_0/pinv_9_0/pmos_m7_w1_200_sli_dli_da_p_0/a_210_0# control_logic_rw_0/pand3_0/C control_logic_rw_0/pand3_0/pdriver_2_0/pinv_9_0/pmos_m7_w1_200_sli_dli_da_p_0/a_132_0# control_logic_rw_0/pnand2_1_0/w_n127_195# sky130_fd_pr__pfet_01v8 ad=3.78n pd=0.183m as=3.78n ps=0.183m w=120 l=15
X117 control_logic_rw_0/pand3_0/pdriver_2_0/pinv_9_0/pmos_m7_w1_200_sli_dli_da_p_0/a_54_0# control_logic_rw_0/pand3_0/C control_logic_rw_0/pand3_0/pdriver_2_0/pinv_9_0/pmos_m7_w1_200_sli_dli_da_p_0/a_0_0# control_logic_rw_0/pnand2_1_0/w_n127_195# sky130_fd_pr__pfet_01v8 ad=3.78n pd=0.183m as=4.68n ps=0.318m w=120 l=15
X118 control_logic_rw_0/pand3_0/pdriver_2_0/pinv_9_0/pmos_m7_w1_200_sli_dli_da_p_0/a_522_0# control_logic_rw_0/pand3_0/C control_logic_rw_0/pand3_0/pdriver_2_0/pinv_9_0/pmos_m7_w1_200_sli_dli_da_p_0/a_444_0# control_logic_rw_0/pnand2_1_0/w_n127_195# sky130_fd_pr__pfet_01v8 ad=4.56n pd=0.316m as=3.78n ps=0.183m w=120 l=15
X119 control_logic_rw_0/pand3_0/pdriver_2_0/pinv_9_0/pmos_m7_w1_200_sli_dli_da_p_0/a_444_0# control_logic_rw_0/pand3_0/C control_logic_rw_0/pand3_0/pdriver_2_0/pinv_9_0/pmos_m7_w1_200_sli_dli_da_p_0/a_366_0# control_logic_rw_0/pnand2_1_0/w_n127_195# sky130_fd_pr__pfet_01v8 ad=3.78n pd=0.183m as=3.78n ps=0.183m w=120 l=15
X120 control_logic_rw_0/pand3_0/pdriver_2_0/pinv_9_0/pmos_m7_w1_200_sli_dli_da_p_0/a_132_0# control_logic_rw_0/pand3_0/C control_logic_rw_0/pand3_0/pdriver_2_0/pinv_9_0/pmos_m7_w1_200_sli_dli_da_p_0/a_54_0# control_logic_rw_0/pnand2_1_0/w_n127_195# sky130_fd_pr__pfet_01v8 ad=3.78n pd=0.183m as=3.78n ps=0.183m w=120 l=15
X121 control_logic_rw_0/pand3_0/pdriver_2_0/pinv_9_0/pmos_m7_w1_200_sli_dli_da_p_0/a_366_0# control_logic_rw_0/pand3_0/C control_logic_rw_0/pand3_0/pdriver_2_0/pinv_9_0/pmos_m7_w1_200_sli_dli_da_p_0/a_288_0# control_logic_rw_0/pnand2_1_0/w_n127_195# sky130_fd_pr__pfet_01v8 ad=3.78n pd=0.183m as=3.78n ps=0.183m w=120 l=15
X122 control_logic_rw_0/pinv_3_0/pmos_m1_w0_840_sli_dli_da_p_0/a_54_0# control_logic_rw_0/pinv_3_0/A control_logic_rw_0/pinv_3_0/pmos_m1_w0_840_sli_dli_da_p_0/a_0_0# control_logic_rw_0/pinv_3_0/w_n127_195# sky130_fd_pr__pfet_01v8 ad=3.192n pd=0.244m as=3.276n ps=0.246m w=84 l=15
X123 control_logic_rw_0/pinv_3_0/nmos_m1_w0_420_sli_dli_da_p_0/a_54_0# control_logic_rw_0/pinv_3_0/A control_logic_rw_0/pinv_3_0/nmos_m1_w0_420_sli_dli_da_p_0/a_0_0# vdd sky130_fd_pr__nfet_01v8 ad=1.596n pd=0.16m as=1.638n ps=0.162m w=42 l=15
X124 control_logic_rw_0/pinv_3_1/pmos_m1_w0_840_sli_dli_da_p_0/a_54_0# vdd control_logic_rw_0/pinv_3_1/pmos_m1_w0_840_sli_dli_da_p_0/a_0_0# control_logic_rw_0/pinv_3_1/w_n127_195# sky130_fd_pr__pfet_01v8 ad=3.193n pd=0.245m as=3.277n ps=0.247m w=84 l=15
X125 control_logic_rw_0/pinv_3_1/nmos_m1_w0_420_sli_dli_da_p_0/a_54_0# vdd control_logic_rw_0/pinv_3_1/nmos_m1_w0_420_sli_dli_da_p_0/a_0_0# vdd sky130_fd_pr__nfet_01v8 ad=1.597n pd=0.161m as=1.639n ps=0.163m w=42 l=15
X126 control_logic_rw_0/pdriver_1_0/pinv_5_0/pmos_m1_w0_840_sli_dli_da_p_0/a_54_0# control_logic_rw_0/pand3_0/C control_logic_rw_0/pdriver_1_0/pinv_5_0/pmos_m1_w0_840_sli_dli_da_p_0/a_0_0# control_logic_rw_0/pdriver_1_0/w_n127_195# sky130_fd_pr__pfet_01v8 ad=3.193n pd=0.245m as=3.277n ps=0.247m w=84 l=15
X127 control_logic_rw_0/pdriver_1_0/pinv_5_0/nmos_m1_w0_420_sli_dli_da_p_0/a_54_0# control_logic_rw_0/pand3_0/C control_logic_rw_0/pdriver_1_0/pinv_5_0/nmos_m1_w0_420_sli_dli_da_p_0/a_0_0# vdd sky130_fd_pr__nfet_01v8 ad=1.597n pd=0.161m as=1.639n ps=0.163m w=42 l=15
X128 control_logic_rw_0/pdriver_1_0/pinv_8_0/pmos_m1_w0_840_sli_dli_da_p_0/a_54_0# control_logic_rw_0/pdriver_1_0/pinv_8_0/A control_logic_rw_0/pdriver_1_0/pinv_8_0/pmos_m1_w0_840_sli_dli_da_p_0/a_0_0# control_logic_rw_0/pdriver_1_0/w_n127_195# sky130_fd_pr__pfet_01v8 ad=3.193n pd=0.245m as=3.277n ps=0.247m w=84 l=15
X129 control_logic_rw_0/pdriver_1_0/pinv_8_0/nmos_m1_w0_420_sli_dli_da_p_0/a_54_0# control_logic_rw_0/pdriver_1_0/pinv_8_0/A control_logic_rw_0/pdriver_1_0/pinv_8_0/nmos_m1_w0_420_sli_dli_da_p_0/a_0_0# vdd sky130_fd_pr__nfet_01v8 ad=1.597n pd=0.161m as=1.639n ps=0.163m w=42 l=15
X130 control_logic_rw_0/pdriver_1_0/pinv_6_0/pmos_m4_w1_050_sli_dli_da_p_0/a_288_0# control_logic_rw_0/pdriver_1_0/pinv_6_0/A control_logic_rw_0/pdriver_1_0/pinv_6_0/pmos_m4_w1_050_sli_dli_da_p_0/a_210_0# control_logic_rw_0/pdriver_1_0/w_n127_195# sky130_fd_pr__pfet_01v8 ad=3.99n pd=0.286m as=3.307n ps=0.168m w=105 l=15
X131 control_logic_rw_0/pdriver_1_0/pinv_6_0/pmos_m4_w1_050_sli_dli_da_p_0/a_210_0# control_logic_rw_0/pdriver_1_0/pinv_6_0/A control_logic_rw_0/pdriver_1_0/pinv_6_0/pmos_m4_w1_050_sli_dli_da_p_0/a_132_0# control_logic_rw_0/pdriver_1_0/w_n127_195# sky130_fd_pr__pfet_01v8 ad=3.307n pd=0.168m as=3.307n ps=0.168m w=105 l=15
X132 control_logic_rw_0/pdriver_1_0/pinv_6_0/pmos_m4_w1_050_sli_dli_da_p_0/a_54_0# control_logic_rw_0/pdriver_1_0/pinv_6_0/A control_logic_rw_0/pdriver_1_0/pinv_6_0/pmos_m4_w1_050_sli_dli_da_p_0/a_0_0# control_logic_rw_0/pdriver_1_0/w_n127_195# sky130_fd_pr__pfet_01v8 ad=3.307n pd=0.168m as=4.095n ps=0.288m w=105 l=15
X133 control_logic_rw_0/pdriver_1_0/pinv_6_0/pmos_m4_w1_050_sli_dli_da_p_0/a_132_0# control_logic_rw_0/pdriver_1_0/pinv_6_0/A control_logic_rw_0/pdriver_1_0/pinv_6_0/pmos_m4_w1_050_sli_dli_da_p_0/a_54_0# control_logic_rw_0/pdriver_1_0/w_n127_195# sky130_fd_pr__pfet_01v8 ad=3.307n pd=0.168m as=3.307n ps=0.168m w=105 l=15
X134 control_logic_rw_0/pdriver_1_0/pinv_6_0/nmos_m4_w0_520_sli_dli_da_p_0/a_132_0# control_logic_rw_0/pdriver_1_0/pinv_6_0/A control_logic_rw_0/pdriver_1_0/pinv_6_0/nmos_m4_w0_520_sli_dli_da_p_0/a_54_0# vdd sky130_fd_pr__nfet_01v8 ad=1.638n pd=0.115m as=1.638n ps=0.115m w=52 l=15
X135 control_logic_rw_0/pdriver_1_0/pinv_6_0/nmos_m4_w0_520_sli_dli_da_p_0/a_288_0# control_logic_rw_0/pdriver_1_0/pinv_6_0/A control_logic_rw_0/pdriver_1_0/pinv_6_0/nmos_m4_w0_520_sli_dli_da_p_0/a_210_0# vdd sky130_fd_pr__nfet_01v8 ad=1.976n pd=0.18m as=1.638n ps=0.115m w=52 l=15
X136 control_logic_rw_0/pdriver_1_0/pinv_6_0/nmos_m4_w0_520_sli_dli_da_p_0/a_210_0# control_logic_rw_0/pdriver_1_0/pinv_6_0/A control_logic_rw_0/pdriver_1_0/pinv_6_0/nmos_m4_w0_520_sli_dli_da_p_0/a_132_0# vdd sky130_fd_pr__nfet_01v8 ad=1.638n pd=0.115m as=1.638n ps=0.115m w=52 l=15
X137 control_logic_rw_0/pdriver_1_0/pinv_6_0/nmos_m4_w0_520_sli_dli_da_p_0/a_54_0# control_logic_rw_0/pdriver_1_0/pinv_6_0/A control_logic_rw_0/pdriver_1_0/pinv_6_0/nmos_m4_w0_520_sli_dli_da_p_0/a_0_0# vdd sky130_fd_pr__nfet_01v8 ad=1.638n pd=0.115m as=2.028n ps=0.182m w=52 l=15
X138 control_logic_rw_0/pdriver_1_0/pinv_4_0/nmos_m2_w0_420_sli_dli_da_p_0/a_132_0# control_logic_rw_0/pdriver_1_0/pinv_8_0/Z control_logic_rw_0/pdriver_1_0/pinv_4_0/nmos_m2_w0_420_sli_dli_da_p_0/a_54_0# vdd sky130_fd_pr__nfet_01v8 ad=1.597n pd=0.161m as=2.647n ps=0.211m w=42 l=15
X139 control_logic_rw_0/pdriver_1_0/pinv_4_0/nmos_m2_w0_420_sli_dli_da_p_0/a_54_0# control_logic_rw_0/pdriver_1_0/pinv_8_0/Z control_logic_rw_0/pdriver_1_0/pinv_4_0/nmos_m2_w0_420_sli_dli_da_p_0/a_0_0# vdd sky130_fd_pr__nfet_01v8 ad=0 pd=0 as=1.639n ps=0.163m w=42 l=15
X140 control_logic_rw_0/pdriver_1_0/pinv_4_0/pmos_m2_w0_840_sli_dli_da_p_0/a_54_0# control_logic_rw_0/pdriver_1_0/pinv_8_0/Z control_logic_rw_0/pdriver_1_0/pinv_4_0/pmos_m2_w0_840_sli_dli_da_p_0/a_0_0# control_logic_rw_0/pdriver_1_0/w_n127_195# sky130_fd_pr__pfet_01v8 ad=5.293n pd=0.295m as=3.277n ps=0.247m w=84 l=15
X141 control_logic_rw_0/pdriver_1_0/pinv_4_0/pmos_m2_w0_840_sli_dli_da_p_0/a_132_0# control_logic_rw_0/pdriver_1_0/pinv_8_0/Z control_logic_rw_0/pdriver_1_0/pinv_4_0/pmos_m2_w0_840_sli_dli_da_p_0/a_54_0# control_logic_rw_0/pdriver_1_0/w_n127_195# sky130_fd_pr__pfet_01v8 ad=3.193n pd=0.245m as=0 ps=0 w=84 l=15
X142 control_logic_rw_0/delay_chain_0/pinv_11_0/pmos_m1_w0_840_sli_dli_da_p_0/a_54_0# control_logic_rw_0/pinv_3_0/A control_logic_rw_0/delay_chain_0/pinv_11_0/pmos_m1_w0_840_sli_dli_da_p_0/a_0_0# control_logic_rw_0/delay_chain_0/pinv_11_4/w_n127_403# sky130_fd_pr__pfet_01v8 ad=3.193n pd=0.245m as=3.277n ps=0.247m w=84 l=15
X143 control_logic_rw_0/delay_chain_0/pinv_11_0/nmos_m1_w0_420_sli_dli_da_p_0/a_54_0# control_logic_rw_0/pinv_3_0/A control_logic_rw_0/delay_chain_0/pinv_11_0/nmos_m1_w0_420_sli_dli_da_p_0/a_0_0# vdd sky130_fd_pr__nfet_01v8 ad=1.597n pd=0.161m as=1.639n ps=0.163m w=42 l=15
X144 control_logic_rw_0/delay_chain_0/pinv_11_1/pmos_m1_w0_840_sli_dli_da_p_0/a_54_0# control_logic_rw_0/pinv_3_0/A control_logic_rw_0/delay_chain_0/pinv_11_1/pmos_m1_w0_840_sli_dli_da_p_0/a_0_0# control_logic_rw_0/delay_chain_0/pinv_11_4/w_n127_403# sky130_fd_pr__pfet_01v8 ad=3.193n pd=0.245m as=3.277n ps=0.247m w=84 l=15
X145 control_logic_rw_0/delay_chain_0/pinv_11_1/nmos_m1_w0_420_sli_dli_da_p_0/a_54_0# control_logic_rw_0/pinv_3_0/A control_logic_rw_0/delay_chain_0/pinv_11_1/nmos_m1_w0_420_sli_dli_da_p_0/a_0_0# vdd sky130_fd_pr__nfet_01v8 ad=1.597n pd=0.161m as=1.639n ps=0.163m w=42 l=15
X146 control_logic_rw_0/delay_chain_0/pinv_11_2/pmos_m1_w0_840_sli_dli_da_p_0/a_54_0# control_logic_rw_0/pinv_3_0/A control_logic_rw_0/delay_chain_0/pinv_11_2/pmos_m1_w0_840_sli_dli_da_p_0/a_0_0# control_logic_rw_0/delay_chain_0/pinv_11_4/w_n127_403# sky130_fd_pr__pfet_01v8 ad=3.193n pd=0.245m as=3.277n ps=0.247m w=84 l=15
X147 control_logic_rw_0/delay_chain_0/pinv_11_2/nmos_m1_w0_420_sli_dli_da_p_0/a_54_0# control_logic_rw_0/pinv_3_0/A control_logic_rw_0/delay_chain_0/pinv_11_2/nmos_m1_w0_420_sli_dli_da_p_0/a_0_0# vdd sky130_fd_pr__nfet_01v8 ad=1.597n pd=0.161m as=1.639n ps=0.163m w=42 l=15
X148 control_logic_rw_0/delay_chain_0/pinv_11_3/pmos_m1_w0_840_sli_dli_da_p_0/a_54_0# control_logic_rw_0/pinv_3_0/A control_logic_rw_0/delay_chain_0/pinv_11_3/pmos_m1_w0_840_sli_dli_da_p_0/a_0_0# control_logic_rw_0/delay_chain_0/pinv_11_4/w_n127_403# sky130_fd_pr__pfet_01v8 ad=3.193n pd=0.245m as=3.277n ps=0.247m w=84 l=15
X149 control_logic_rw_0/delay_chain_0/pinv_11_3/nmos_m1_w0_420_sli_dli_da_p_0/a_54_0# control_logic_rw_0/pinv_3_0/A control_logic_rw_0/delay_chain_0/pinv_11_3/nmos_m1_w0_420_sli_dli_da_p_0/a_0_0# vdd sky130_fd_pr__nfet_01v8 ad=1.597n pd=0.161m as=1.639n ps=0.163m w=42 l=15
X150 control_logic_rw_0/delay_chain_0/pinv_11_4/pmos_m1_w0_840_sli_dli_da_p_0/a_54_0# control_logic_rw_0/delay_chain_0/pinv_11_9/Z control_logic_rw_0/delay_chain_0/pinv_11_4/pmos_m1_w0_840_sli_dli_da_p_0/a_0_0# control_logic_rw_0/delay_chain_0/pinv_11_4/w_n127_403# sky130_fd_pr__pfet_01v8 ad=3.193n pd=0.245m as=3.277n ps=0.247m w=84 l=15
X151 control_logic_rw_0/delay_chain_0/pinv_11_4/nmos_m1_w0_420_sli_dli_da_p_0/a_54_0# control_logic_rw_0/delay_chain_0/pinv_11_9/Z control_logic_rw_0/delay_chain_0/pinv_11_4/nmos_m1_w0_420_sli_dli_da_p_0/a_0_0# vdd sky130_fd_pr__nfet_01v8 ad=1.597n pd=0.161m as=1.639n ps=0.163m w=42 l=15
X152 control_logic_rw_0/delay_chain_0/pinv_11_5/pmos_m1_w0_840_sli_dli_da_p_0/a_54_0# control_logic_rw_0/delay_chain_0/pinv_11_9/Z control_logic_rw_0/delay_chain_0/pinv_11_5/pmos_m1_w0_840_sli_dli_da_p_0/a_0_0# control_logic_rw_0/delay_chain_0/pinv_11_9/w_n127_403# sky130_fd_pr__pfet_01v8 ad=3.193n pd=0.245m as=3.277n ps=0.247m w=84 l=15
X153 control_logic_rw_0/delay_chain_0/pinv_11_5/nmos_m1_w0_420_sli_dli_da_p_0/a_54_0# control_logic_rw_0/delay_chain_0/pinv_11_9/Z control_logic_rw_0/delay_chain_0/pinv_11_5/nmos_m1_w0_420_sli_dli_da_p_0/a_0_0# vdd sky130_fd_pr__nfet_01v8 ad=1.597n pd=0.161m as=1.639n ps=0.163m w=42 l=15
X154 control_logic_rw_0/delay_chain_0/pinv_11_6/pmos_m1_w0_840_sli_dli_da_p_0/a_54_0# control_logic_rw_0/delay_chain_0/pinv_11_9/Z control_logic_rw_0/delay_chain_0/pinv_11_6/pmos_m1_w0_840_sli_dli_da_p_0/a_0_0# control_logic_rw_0/delay_chain_0/pinv_11_9/w_n127_403# sky130_fd_pr__pfet_01v8 ad=3.193n pd=0.245m as=3.277n ps=0.247m w=84 l=15
X155 control_logic_rw_0/delay_chain_0/pinv_11_6/nmos_m1_w0_420_sli_dli_da_p_0/a_54_0# control_logic_rw_0/delay_chain_0/pinv_11_9/Z control_logic_rw_0/delay_chain_0/pinv_11_6/nmos_m1_w0_420_sli_dli_da_p_0/a_0_0# vdd sky130_fd_pr__nfet_01v8 ad=1.597n pd=0.161m as=1.639n ps=0.163m w=42 l=15
X156 control_logic_rw_0/delay_chain_0/pinv_11_7/pmos_m1_w0_840_sli_dli_da_p_0/a_54_0# control_logic_rw_0/delay_chain_0/pinv_11_9/Z control_logic_rw_0/delay_chain_0/pinv_11_7/pmos_m1_w0_840_sli_dli_da_p_0/a_0_0# control_logic_rw_0/delay_chain_0/pinv_11_9/w_n127_403# sky130_fd_pr__pfet_01v8 ad=3.193n pd=0.245m as=3.277n ps=0.247m w=84 l=15
X157 control_logic_rw_0/delay_chain_0/pinv_11_7/nmos_m1_w0_420_sli_dli_da_p_0/a_54_0# control_logic_rw_0/delay_chain_0/pinv_11_9/Z control_logic_rw_0/delay_chain_0/pinv_11_7/nmos_m1_w0_420_sli_dli_da_p_0/a_0_0# vdd sky130_fd_pr__nfet_01v8 ad=1.597n pd=0.161m as=1.639n ps=0.163m w=42 l=15
X158 control_logic_rw_0/delay_chain_0/pinv_11_8/pmos_m1_w0_840_sli_dli_da_p_0/a_54_0# control_logic_rw_0/delay_chain_0/pinv_11_9/Z control_logic_rw_0/delay_chain_0/pinv_11_8/pmos_m1_w0_840_sli_dli_da_p_0/a_0_0# control_logic_rw_0/delay_chain_0/pinv_11_9/w_n127_403# sky130_fd_pr__pfet_01v8 ad=3.193n pd=0.245m as=3.277n ps=0.247m w=84 l=15
X159 control_logic_rw_0/delay_chain_0/pinv_11_8/nmos_m1_w0_420_sli_dli_da_p_0/a_54_0# control_logic_rw_0/delay_chain_0/pinv_11_9/Z control_logic_rw_0/delay_chain_0/pinv_11_8/nmos_m1_w0_420_sli_dli_da_p_0/a_0_0# vdd sky130_fd_pr__nfet_01v8 ad=1.597n pd=0.161m as=1.639n ps=0.163m w=42 l=15
X160 control_logic_rw_0/delay_chain_0/pinv_11_9/pmos_m1_w0_840_sli_dli_da_p_0/a_54_0# control_logic_rw_0/delay_chain_0/pinv_11_9/A control_logic_rw_0/delay_chain_0/pinv_11_9/pmos_m1_w0_840_sli_dli_da_p_0/a_0_0# control_logic_rw_0/delay_chain_0/pinv_11_9/w_n127_403# sky130_fd_pr__pfet_01v8 ad=3.193n pd=0.245m as=3.277n ps=0.247m w=84 l=15
X161 control_logic_rw_0/delay_chain_0/pinv_11_9/nmos_m1_w0_420_sli_dli_da_p_0/a_54_0# control_logic_rw_0/delay_chain_0/pinv_11_9/A control_logic_rw_0/delay_chain_0/pinv_11_9/nmos_m1_w0_420_sli_dli_da_p_0/a_0_0# vdd sky130_fd_pr__nfet_01v8 ad=1.597n pd=0.161m as=1.639n ps=0.163m w=42 l=15
X162 control_logic_rw_0/delay_chain_0/pinv_11_40/pmos_m1_w0_840_sli_dli_da_p_0/a_54_0# control_logic_rw_0/delay_chain_0/pinv_11_44/Z control_logic_rw_0/delay_chain_0/pinv_11_40/pmos_m1_w0_840_sli_dli_da_p_0/a_0_0# control_logic_rw_0/delay_chain_0/pinv_11_44/w_n127_403# sky130_fd_pr__pfet_01v8 ad=3.193n pd=0.245m as=3.277n ps=0.247m w=84 l=15
X163 control_logic_rw_0/delay_chain_0/pinv_11_40/nmos_m1_w0_420_sli_dli_da_p_0/a_54_0# control_logic_rw_0/delay_chain_0/pinv_11_44/Z control_logic_rw_0/delay_chain_0/pinv_11_40/nmos_m1_w0_420_sli_dli_da_p_0/a_0_0# vdd sky130_fd_pr__nfet_01v8 ad=1.597n pd=0.161m as=1.639n ps=0.163m w=42 l=15
X164 control_logic_rw_0/delay_chain_0/pinv_11_41/pmos_m1_w0_840_sli_dli_da_p_0/a_54_0# control_logic_rw_0/delay_chain_0/pinv_11_44/Z control_logic_rw_0/delay_chain_0/pinv_11_41/pmos_m1_w0_840_sli_dli_da_p_0/a_0_0# control_logic_rw_0/delay_chain_0/pinv_11_44/w_n127_403# sky130_fd_pr__pfet_01v8 ad=3.193n pd=0.245m as=3.277n ps=0.247m w=84 l=15
X165 control_logic_rw_0/delay_chain_0/pinv_11_41/nmos_m1_w0_420_sli_dli_da_p_0/a_54_0# control_logic_rw_0/delay_chain_0/pinv_11_44/Z control_logic_rw_0/delay_chain_0/pinv_11_41/nmos_m1_w0_420_sli_dli_da_p_0/a_0_0# vdd sky130_fd_pr__nfet_01v8 ad=1.597n pd=0.161m as=1.639n ps=0.163m w=42 l=15
X166 control_logic_rw_0/delay_chain_0/pinv_11_30/pmos_m1_w0_840_sli_dli_da_p_0/a_54_0# control_logic_rw_0/delay_chain_0/pinv_11_34/Z control_logic_rw_0/delay_chain_0/pinv_11_30/pmos_m1_w0_840_sli_dli_da_p_0/a_0_0# control_logic_rw_0/delay_chain_0/pinv_11_34/w_n127_403# sky130_fd_pr__pfet_01v8 ad=3.193n pd=0.245m as=3.277n ps=0.247m w=84 l=15
X167 control_logic_rw_0/delay_chain_0/pinv_11_30/nmos_m1_w0_420_sli_dli_da_p_0/a_54_0# control_logic_rw_0/delay_chain_0/pinv_11_34/Z control_logic_rw_0/delay_chain_0/pinv_11_30/nmos_m1_w0_420_sli_dli_da_p_0/a_0_0# vdd sky130_fd_pr__nfet_01v8 ad=1.597n pd=0.161m as=1.639n ps=0.163m w=42 l=15
X168 control_logic_rw_0/delay_chain_0/pinv_11_20/pmos_m1_w0_840_sli_dli_da_p_0/a_54_0# control_logic_rw_0/delay_chain_0/pinv_11_24/Z control_logic_rw_0/delay_chain_0/pinv_11_20/pmos_m1_w0_840_sli_dli_da_p_0/a_0_0# control_logic_rw_0/delay_chain_0/pinv_11_24/w_n127_403# sky130_fd_pr__pfet_01v8 ad=3.193n pd=0.245m as=3.277n ps=0.247m w=84 l=15
X169 control_logic_rw_0/delay_chain_0/pinv_11_20/nmos_m1_w0_420_sli_dli_da_p_0/a_54_0# control_logic_rw_0/delay_chain_0/pinv_11_24/Z control_logic_rw_0/delay_chain_0/pinv_11_20/nmos_m1_w0_420_sli_dli_da_p_0/a_0_0# vdd sky130_fd_pr__nfet_01v8 ad=1.597n pd=0.161m as=1.639n ps=0.163m w=42 l=15
X170 control_logic_rw_0/delay_chain_0/pinv_11_42/pmos_m1_w0_840_sli_dli_da_p_0/a_54_0# control_logic_rw_0/delay_chain_0/pinv_11_44/Z control_logic_rw_0/delay_chain_0/pinv_11_42/pmos_m1_w0_840_sli_dli_da_p_0/a_0_0# control_logic_rw_0/delay_chain_0/pinv_11_44/w_n127_403# sky130_fd_pr__pfet_01v8 ad=3.193n pd=0.245m as=3.277n ps=0.247m w=84 l=15
X171 control_logic_rw_0/delay_chain_0/pinv_11_42/nmos_m1_w0_420_sli_dli_da_p_0/a_54_0# control_logic_rw_0/delay_chain_0/pinv_11_44/Z control_logic_rw_0/delay_chain_0/pinv_11_42/nmos_m1_w0_420_sli_dli_da_p_0/a_0_0# vdd sky130_fd_pr__nfet_01v8 ad=1.597n pd=0.161m as=1.639n ps=0.163m w=42 l=15
X172 control_logic_rw_0/delay_chain_0/pinv_11_31/pmos_m1_w0_840_sli_dli_da_p_0/a_54_0# control_logic_rw_0/delay_chain_0/pinv_11_34/Z control_logic_rw_0/delay_chain_0/pinv_11_31/pmos_m1_w0_840_sli_dli_da_p_0/a_0_0# control_logic_rw_0/delay_chain_0/pinv_11_34/w_n127_403# sky130_fd_pr__pfet_01v8 ad=3.193n pd=0.245m as=3.277n ps=0.247m w=84 l=15
X173 control_logic_rw_0/delay_chain_0/pinv_11_31/nmos_m1_w0_420_sli_dli_da_p_0/a_54_0# control_logic_rw_0/delay_chain_0/pinv_11_34/Z control_logic_rw_0/delay_chain_0/pinv_11_31/nmos_m1_w0_420_sli_dli_da_p_0/a_0_0# vdd sky130_fd_pr__nfet_01v8 ad=1.597n pd=0.161m as=1.639n ps=0.163m w=42 l=15
X174 control_logic_rw_0/delay_chain_0/pinv_11_10/pmos_m1_w0_840_sli_dli_da_p_0/a_54_0# control_logic_rw_0/delay_chain_0/pinv_11_9/A control_logic_rw_0/delay_chain_0/pinv_11_10/pmos_m1_w0_840_sli_dli_da_p_0/a_0_0# control_logic_rw_0/delay_chain_0/pinv_11_9/w_n127_403# sky130_fd_pr__pfet_01v8 ad=3.193n pd=0.245m as=3.277n ps=0.247m w=84 l=15
X175 control_logic_rw_0/delay_chain_0/pinv_11_10/nmos_m1_w0_420_sli_dli_da_p_0/a_54_0# control_logic_rw_0/delay_chain_0/pinv_11_9/A control_logic_rw_0/delay_chain_0/pinv_11_10/nmos_m1_w0_420_sli_dli_da_p_0/a_0_0# vdd sky130_fd_pr__nfet_01v8 ad=1.597n pd=0.161m as=1.639n ps=0.163m w=42 l=15
X176 control_logic_rw_0/delay_chain_0/pinv_11_21/pmos_m1_w0_840_sli_dli_da_p_0/a_54_0# control_logic_rw_0/delay_chain_0/pinv_11_24/Z control_logic_rw_0/delay_chain_0/pinv_11_21/pmos_m1_w0_840_sli_dli_da_p_0/a_0_0# control_logic_rw_0/delay_chain_0/pinv_11_24/w_n127_403# sky130_fd_pr__pfet_01v8 ad=3.193n pd=0.245m as=3.277n ps=0.247m w=84 l=15
X177 control_logic_rw_0/delay_chain_0/pinv_11_21/nmos_m1_w0_420_sli_dli_da_p_0/a_54_0# control_logic_rw_0/delay_chain_0/pinv_11_24/Z control_logic_rw_0/delay_chain_0/pinv_11_21/nmos_m1_w0_420_sli_dli_da_p_0/a_0_0# vdd sky130_fd_pr__nfet_01v8 ad=1.597n pd=0.161m as=1.639n ps=0.163m w=42 l=15
X178 control_logic_rw_0/delay_chain_0/pinv_11_43/pmos_m1_w0_840_sli_dli_da_p_0/a_54_0# control_logic_rw_0/delay_chain_0/pinv_11_44/Z control_logic_rw_0/delay_chain_0/pinv_11_43/pmos_m1_w0_840_sli_dli_da_p_0/a_0_0# control_logic_rw_0/delay_chain_0/pinv_11_44/w_n127_403# sky130_fd_pr__pfet_01v8 ad=3.193n pd=0.245m as=3.277n ps=0.247m w=84 l=15
X179 control_logic_rw_0/delay_chain_0/pinv_11_43/nmos_m1_w0_420_sli_dli_da_p_0/a_54_0# control_logic_rw_0/delay_chain_0/pinv_11_44/Z control_logic_rw_0/delay_chain_0/pinv_11_43/nmos_m1_w0_420_sli_dli_da_p_0/a_0_0# vdd sky130_fd_pr__nfet_01v8 ad=1.597n pd=0.161m as=1.639n ps=0.163m w=42 l=15
X180 control_logic_rw_0/delay_chain_0/pinv_11_32/pmos_m1_w0_840_sli_dli_da_p_0/a_54_0# control_logic_rw_0/delay_chain_0/pinv_11_34/Z control_logic_rw_0/delay_chain_0/pinv_11_32/pmos_m1_w0_840_sli_dli_da_p_0/a_0_0# control_logic_rw_0/delay_chain_0/pinv_11_34/w_n127_403# sky130_fd_pr__pfet_01v8 ad=3.193n pd=0.245m as=3.277n ps=0.247m w=84 l=15
X181 control_logic_rw_0/delay_chain_0/pinv_11_32/nmos_m1_w0_420_sli_dli_da_p_0/a_54_0# control_logic_rw_0/delay_chain_0/pinv_11_34/Z control_logic_rw_0/delay_chain_0/pinv_11_32/nmos_m1_w0_420_sli_dli_da_p_0/a_0_0# vdd sky130_fd_pr__nfet_01v8 ad=1.597n pd=0.161m as=1.639n ps=0.163m w=42 l=15
X182 control_logic_rw_0/delay_chain_0/pinv_11_11/pmos_m1_w0_840_sli_dli_da_p_0/a_54_0# control_logic_rw_0/delay_chain_0/pinv_11_9/A control_logic_rw_0/delay_chain_0/pinv_11_11/pmos_m1_w0_840_sli_dli_da_p_0/a_0_0# control_logic_rw_0/delay_chain_0/pinv_11_9/w_n127_403# sky130_fd_pr__pfet_01v8 ad=3.193n pd=0.245m as=3.277n ps=0.247m w=84 l=15
X183 control_logic_rw_0/delay_chain_0/pinv_11_11/nmos_m1_w0_420_sli_dli_da_p_0/a_54_0# control_logic_rw_0/delay_chain_0/pinv_11_9/A control_logic_rw_0/delay_chain_0/pinv_11_11/nmos_m1_w0_420_sli_dli_da_p_0/a_0_0# vdd sky130_fd_pr__nfet_01v8 ad=1.597n pd=0.161m as=1.639n ps=0.163m w=42 l=15
X184 control_logic_rw_0/delay_chain_0/pinv_11_22/pmos_m1_w0_840_sli_dli_da_p_0/a_54_0# control_logic_rw_0/delay_chain_0/pinv_11_24/Z control_logic_rw_0/delay_chain_0/pinv_11_22/pmos_m1_w0_840_sli_dli_da_p_0/a_0_0# control_logic_rw_0/delay_chain_0/pinv_11_24/w_n127_403# sky130_fd_pr__pfet_01v8 ad=3.193n pd=0.245m as=3.277n ps=0.247m w=84 l=15
X185 control_logic_rw_0/delay_chain_0/pinv_11_22/nmos_m1_w0_420_sli_dli_da_p_0/a_54_0# control_logic_rw_0/delay_chain_0/pinv_11_24/Z control_logic_rw_0/delay_chain_0/pinv_11_22/nmos_m1_w0_420_sli_dli_da_p_0/a_0_0# vdd sky130_fd_pr__nfet_01v8 ad=1.597n pd=0.161m as=1.639n ps=0.163m w=42 l=15
X186 control_logic_rw_0/delay_chain_0/pinv_11_44/pmos_m1_w0_840_sli_dli_da_p_0/a_54_0# vdd control_logic_rw_0/delay_chain_0/pinv_11_44/pmos_m1_w0_840_sli_dli_da_p_0/a_0_0# control_logic_rw_0/delay_chain_0/pinv_11_44/w_n127_403# sky130_fd_pr__pfet_01v8 ad=3.193n pd=0.245m as=3.277n ps=0.247m w=84 l=15
X187 control_logic_rw_0/delay_chain_0/pinv_11_44/nmos_m1_w0_420_sli_dli_da_p_0/a_54_0# vdd control_logic_rw_0/delay_chain_0/pinv_11_44/nmos_m1_w0_420_sli_dli_da_p_0/a_0_0# vdd sky130_fd_pr__nfet_01v8 ad=1.597n pd=0.161m as=1.639n ps=0.163m w=42 l=15
X188 control_logic_rw_0/delay_chain_0/pinv_11_33/pmos_m1_w0_840_sli_dli_da_p_0/a_54_0# control_logic_rw_0/delay_chain_0/pinv_11_34/Z control_logic_rw_0/delay_chain_0/pinv_11_33/pmos_m1_w0_840_sli_dli_da_p_0/a_0_0# control_logic_rw_0/delay_chain_0/pinv_11_34/w_n127_403# sky130_fd_pr__pfet_01v8 ad=3.193n pd=0.245m as=3.277n ps=0.247m w=84 l=15
X189 control_logic_rw_0/delay_chain_0/pinv_11_33/nmos_m1_w0_420_sli_dli_da_p_0/a_54_0# control_logic_rw_0/delay_chain_0/pinv_11_34/Z control_logic_rw_0/delay_chain_0/pinv_11_33/nmos_m1_w0_420_sli_dli_da_p_0/a_0_0# vdd sky130_fd_pr__nfet_01v8 ad=1.597n pd=0.161m as=1.639n ps=0.163m w=42 l=15
X190 control_logic_rw_0/delay_chain_0/pinv_11_12/pmos_m1_w0_840_sli_dli_da_p_0/a_54_0# control_logic_rw_0/delay_chain_0/pinv_11_9/A control_logic_rw_0/delay_chain_0/pinv_11_12/pmos_m1_w0_840_sli_dli_da_p_0/a_0_0# control_logic_rw_0/delay_chain_0/pinv_11_9/w_n127_403# sky130_fd_pr__pfet_01v8 ad=3.193n pd=0.245m as=3.277n ps=0.247m w=84 l=15
X191 control_logic_rw_0/delay_chain_0/pinv_11_12/nmos_m1_w0_420_sli_dli_da_p_0/a_54_0# control_logic_rw_0/delay_chain_0/pinv_11_9/A control_logic_rw_0/delay_chain_0/pinv_11_12/nmos_m1_w0_420_sli_dli_da_p_0/a_0_0# vdd sky130_fd_pr__nfet_01v8 ad=1.597n pd=0.161m as=1.639n ps=0.163m w=42 l=15
X192 control_logic_rw_0/delay_chain_0/pinv_11_23/pmos_m1_w0_840_sli_dli_da_p_0/a_54_0# control_logic_rw_0/delay_chain_0/pinv_11_24/Z control_logic_rw_0/delay_chain_0/pinv_11_23/pmos_m1_w0_840_sli_dli_da_p_0/a_0_0# control_logic_rw_0/delay_chain_0/pinv_11_24/w_n127_403# sky130_fd_pr__pfet_01v8 ad=3.193n pd=0.245m as=3.277n ps=0.247m w=84 l=15
X193 control_logic_rw_0/delay_chain_0/pinv_11_23/nmos_m1_w0_420_sli_dli_da_p_0/a_54_0# control_logic_rw_0/delay_chain_0/pinv_11_24/Z control_logic_rw_0/delay_chain_0/pinv_11_23/nmos_m1_w0_420_sli_dli_da_p_0/a_0_0# vdd sky130_fd_pr__nfet_01v8 ad=1.597n pd=0.161m as=1.639n ps=0.163m w=42 l=15
X194 control_logic_rw_0/delay_chain_0/pinv_11_34/pmos_m1_w0_840_sli_dli_da_p_0/a_54_0# control_logic_rw_0/delay_chain_0/pinv_11_39/Z control_logic_rw_0/delay_chain_0/pinv_11_34/pmos_m1_w0_840_sli_dli_da_p_0/a_0_0# control_logic_rw_0/delay_chain_0/pinv_11_34/w_n127_403# sky130_fd_pr__pfet_01v8 ad=3.193n pd=0.245m as=3.277n ps=0.247m w=84 l=15
X195 control_logic_rw_0/delay_chain_0/pinv_11_34/nmos_m1_w0_420_sli_dli_da_p_0/a_54_0# control_logic_rw_0/delay_chain_0/pinv_11_39/Z control_logic_rw_0/delay_chain_0/pinv_11_34/nmos_m1_w0_420_sli_dli_da_p_0/a_0_0# vdd sky130_fd_pr__nfet_01v8 ad=1.597n pd=0.161m as=1.639n ps=0.163m w=42 l=15
X196 control_logic_rw_0/delay_chain_0/pinv_11_13/pmos_m1_w0_840_sli_dli_da_p_0/a_54_0# control_logic_rw_0/delay_chain_0/pinv_11_9/A control_logic_rw_0/delay_chain_0/pinv_11_13/pmos_m1_w0_840_sli_dli_da_p_0/a_0_0# control_logic_rw_0/delay_chain_0/pinv_11_9/w_n127_403# sky130_fd_pr__pfet_01v8 ad=3.193n pd=0.245m as=3.277n ps=0.247m w=84 l=15
X197 control_logic_rw_0/delay_chain_0/pinv_11_13/nmos_m1_w0_420_sli_dli_da_p_0/a_54_0# control_logic_rw_0/delay_chain_0/pinv_11_9/A control_logic_rw_0/delay_chain_0/pinv_11_13/nmos_m1_w0_420_sli_dli_da_p_0/a_0_0# vdd sky130_fd_pr__nfet_01v8 ad=1.597n pd=0.161m as=1.639n ps=0.163m w=42 l=15
X198 control_logic_rw_0/delay_chain_0/pinv_11_24/pmos_m1_w0_840_sli_dli_da_p_0/a_54_0# control_logic_rw_0/delay_chain_0/pinv_11_29/Z control_logic_rw_0/delay_chain_0/pinv_11_24/pmos_m1_w0_840_sli_dli_da_p_0/a_0_0# control_logic_rw_0/delay_chain_0/pinv_11_24/w_n127_403# sky130_fd_pr__pfet_01v8 ad=3.193n pd=0.245m as=3.277n ps=0.247m w=84 l=15
X199 control_logic_rw_0/delay_chain_0/pinv_11_24/nmos_m1_w0_420_sli_dli_da_p_0/a_54_0# control_logic_rw_0/delay_chain_0/pinv_11_29/Z control_logic_rw_0/delay_chain_0/pinv_11_24/nmos_m1_w0_420_sli_dli_da_p_0/a_0_0# vdd sky130_fd_pr__nfet_01v8 ad=1.597n pd=0.161m as=1.639n ps=0.163m w=42 l=15
X200 control_logic_rw_0/delay_chain_0/pinv_11_35/pmos_m1_w0_840_sli_dli_da_p_0/a_54_0# control_logic_rw_0/delay_chain_0/pinv_11_39/Z control_logic_rw_0/delay_chain_0/pinv_11_35/pmos_m1_w0_840_sli_dli_da_p_0/a_0_0# control_logic_rw_0/delay_chain_0/pinv_11_44/w_n127_403# sky130_fd_pr__pfet_01v8 ad=3.193n pd=0.245m as=3.277n ps=0.247m w=84 l=15
X201 control_logic_rw_0/delay_chain_0/pinv_11_35/nmos_m1_w0_420_sli_dli_da_p_0/a_54_0# control_logic_rw_0/delay_chain_0/pinv_11_39/Z control_logic_rw_0/delay_chain_0/pinv_11_35/nmos_m1_w0_420_sli_dli_da_p_0/a_0_0# vdd sky130_fd_pr__nfet_01v8 ad=1.597n pd=0.161m as=1.639n ps=0.163m w=42 l=15
X202 control_logic_rw_0/delay_chain_0/pinv_11_14/pmos_m1_w0_840_sli_dli_da_p_0/a_54_0# control_logic_rw_0/delay_chain_0/pinv_11_19/Z control_logic_rw_0/delay_chain_0/pinv_11_14/pmos_m1_w0_840_sli_dli_da_p_0/a_0_0# control_logic_rw_0/delay_chain_0/pinv_11_9/w_n127_403# sky130_fd_pr__pfet_01v8 ad=3.193n pd=0.245m as=3.277n ps=0.247m w=84 l=15
X203 control_logic_rw_0/delay_chain_0/pinv_11_14/nmos_m1_w0_420_sli_dli_da_p_0/a_54_0# control_logic_rw_0/delay_chain_0/pinv_11_19/Z control_logic_rw_0/delay_chain_0/pinv_11_14/nmos_m1_w0_420_sli_dli_da_p_0/a_0_0# vdd sky130_fd_pr__nfet_01v8 ad=1.597n pd=0.161m as=1.639n ps=0.163m w=42 l=15
X204 control_logic_rw_0/delay_chain_0/pinv_11_25/pmos_m1_w0_840_sli_dli_da_p_0/a_54_0# control_logic_rw_0/delay_chain_0/pinv_11_29/Z control_logic_rw_0/delay_chain_0/pinv_11_25/pmos_m1_w0_840_sli_dli_da_p_0/a_0_0# control_logic_rw_0/delay_chain_0/pinv_11_34/w_n127_403# sky130_fd_pr__pfet_01v8 ad=3.193n pd=0.245m as=3.277n ps=0.247m w=84 l=15
X205 control_logic_rw_0/delay_chain_0/pinv_11_25/nmos_m1_w0_420_sli_dli_da_p_0/a_54_0# control_logic_rw_0/delay_chain_0/pinv_11_29/Z control_logic_rw_0/delay_chain_0/pinv_11_25/nmos_m1_w0_420_sli_dli_da_p_0/a_0_0# vdd sky130_fd_pr__nfet_01v8 ad=1.597n pd=0.161m as=1.639n ps=0.163m w=42 l=15
X206 control_logic_rw_0/delay_chain_0/pinv_11_36/pmos_m1_w0_840_sli_dli_da_p_0/a_54_0# control_logic_rw_0/delay_chain_0/pinv_11_39/Z control_logic_rw_0/delay_chain_0/pinv_11_36/pmos_m1_w0_840_sli_dli_da_p_0/a_0_0# control_logic_rw_0/delay_chain_0/pinv_11_44/w_n127_403# sky130_fd_pr__pfet_01v8 ad=3.193n pd=0.245m as=3.277n ps=0.247m w=84 l=15
X207 control_logic_rw_0/delay_chain_0/pinv_11_36/nmos_m1_w0_420_sli_dli_da_p_0/a_54_0# control_logic_rw_0/delay_chain_0/pinv_11_39/Z control_logic_rw_0/delay_chain_0/pinv_11_36/nmos_m1_w0_420_sli_dli_da_p_0/a_0_0# vdd sky130_fd_pr__nfet_01v8 ad=1.597n pd=0.161m as=1.639n ps=0.163m w=42 l=15
X208 control_logic_rw_0/delay_chain_0/pinv_11_15/pmos_m1_w0_840_sli_dli_da_p_0/a_54_0# control_logic_rw_0/delay_chain_0/pinv_11_19/Z control_logic_rw_0/delay_chain_0/pinv_11_15/pmos_m1_w0_840_sli_dli_da_p_0/a_0_0# control_logic_rw_0/delay_chain_0/pinv_11_24/w_n127_403# sky130_fd_pr__pfet_01v8 ad=3.193n pd=0.245m as=3.277n ps=0.247m w=84 l=15
X209 control_logic_rw_0/delay_chain_0/pinv_11_15/nmos_m1_w0_420_sli_dli_da_p_0/a_54_0# control_logic_rw_0/delay_chain_0/pinv_11_19/Z control_logic_rw_0/delay_chain_0/pinv_11_15/nmos_m1_w0_420_sli_dli_da_p_0/a_0_0# vdd sky130_fd_pr__nfet_01v8 ad=1.597n pd=0.161m as=1.639n ps=0.163m w=42 l=15
X210 control_logic_rw_0/delay_chain_0/pinv_11_26/pmos_m1_w0_840_sli_dli_da_p_0/a_54_0# control_logic_rw_0/delay_chain_0/pinv_11_29/Z control_logic_rw_0/delay_chain_0/pinv_11_26/pmos_m1_w0_840_sli_dli_da_p_0/a_0_0# control_logic_rw_0/delay_chain_0/pinv_11_34/w_n127_403# sky130_fd_pr__pfet_01v8 ad=3.193n pd=0.245m as=3.277n ps=0.247m w=84 l=15
X211 control_logic_rw_0/delay_chain_0/pinv_11_26/nmos_m1_w0_420_sli_dli_da_p_0/a_54_0# control_logic_rw_0/delay_chain_0/pinv_11_29/Z control_logic_rw_0/delay_chain_0/pinv_11_26/nmos_m1_w0_420_sli_dli_da_p_0/a_0_0# vdd sky130_fd_pr__nfet_01v8 ad=1.597n pd=0.161m as=1.639n ps=0.163m w=42 l=15
X212 control_logic_rw_0/delay_chain_0/pinv_11_37/pmos_m1_w0_840_sli_dli_da_p_0/a_54_0# control_logic_rw_0/delay_chain_0/pinv_11_39/Z control_logic_rw_0/delay_chain_0/pinv_11_37/pmos_m1_w0_840_sli_dli_da_p_0/a_0_0# control_logic_rw_0/delay_chain_0/pinv_11_44/w_n127_403# sky130_fd_pr__pfet_01v8 ad=3.193n pd=0.245m as=3.277n ps=0.247m w=84 l=15
X213 control_logic_rw_0/delay_chain_0/pinv_11_37/nmos_m1_w0_420_sli_dli_da_p_0/a_54_0# control_logic_rw_0/delay_chain_0/pinv_11_39/Z control_logic_rw_0/delay_chain_0/pinv_11_37/nmos_m1_w0_420_sli_dli_da_p_0/a_0_0# vdd sky130_fd_pr__nfet_01v8 ad=1.597n pd=0.161m as=1.639n ps=0.163m w=42 l=15
X214 control_logic_rw_0/delay_chain_0/pinv_11_16/pmos_m1_w0_840_sli_dli_da_p_0/a_54_0# control_logic_rw_0/delay_chain_0/pinv_11_19/Z control_logic_rw_0/delay_chain_0/pinv_11_16/pmos_m1_w0_840_sli_dli_da_p_0/a_0_0# control_logic_rw_0/delay_chain_0/pinv_11_24/w_n127_403# sky130_fd_pr__pfet_01v8 ad=3.193n pd=0.245m as=3.277n ps=0.247m w=84 l=15
X215 control_logic_rw_0/delay_chain_0/pinv_11_16/nmos_m1_w0_420_sli_dli_da_p_0/a_54_0# control_logic_rw_0/delay_chain_0/pinv_11_19/Z control_logic_rw_0/delay_chain_0/pinv_11_16/nmos_m1_w0_420_sli_dli_da_p_0/a_0_0# vdd sky130_fd_pr__nfet_01v8 ad=1.597n pd=0.161m as=1.639n ps=0.163m w=42 l=15
X216 control_logic_rw_0/delay_chain_0/pinv_11_27/pmos_m1_w0_840_sli_dli_da_p_0/a_54_0# control_logic_rw_0/delay_chain_0/pinv_11_29/Z control_logic_rw_0/delay_chain_0/pinv_11_27/pmos_m1_w0_840_sli_dli_da_p_0/a_0_0# control_logic_rw_0/delay_chain_0/pinv_11_34/w_n127_403# sky130_fd_pr__pfet_01v8 ad=3.193n pd=0.245m as=3.277n ps=0.247m w=84 l=15
X217 control_logic_rw_0/delay_chain_0/pinv_11_27/nmos_m1_w0_420_sli_dli_da_p_0/a_54_0# control_logic_rw_0/delay_chain_0/pinv_11_29/Z control_logic_rw_0/delay_chain_0/pinv_11_27/nmos_m1_w0_420_sli_dli_da_p_0/a_0_0# vdd sky130_fd_pr__nfet_01v8 ad=1.597n pd=0.161m as=1.639n ps=0.163m w=42 l=15
X218 control_logic_rw_0/delay_chain_0/pinv_11_38/pmos_m1_w0_840_sli_dli_da_p_0/a_54_0# control_logic_rw_0/delay_chain_0/pinv_11_39/Z control_logic_rw_0/delay_chain_0/pinv_11_38/pmos_m1_w0_840_sli_dli_da_p_0/a_0_0# control_logic_rw_0/delay_chain_0/pinv_11_44/w_n127_403# sky130_fd_pr__pfet_01v8 ad=3.193n pd=0.245m as=3.277n ps=0.247m w=84 l=15
X219 control_logic_rw_0/delay_chain_0/pinv_11_38/nmos_m1_w0_420_sli_dli_da_p_0/a_54_0# control_logic_rw_0/delay_chain_0/pinv_11_39/Z control_logic_rw_0/delay_chain_0/pinv_11_38/nmos_m1_w0_420_sli_dli_da_p_0/a_0_0# vdd sky130_fd_pr__nfet_01v8 ad=1.597n pd=0.161m as=1.639n ps=0.163m w=42 l=15
X220 control_logic_rw_0/delay_chain_0/pinv_11_17/pmos_m1_w0_840_sli_dli_da_p_0/a_54_0# control_logic_rw_0/delay_chain_0/pinv_11_19/Z control_logic_rw_0/delay_chain_0/pinv_11_17/pmos_m1_w0_840_sli_dli_da_p_0/a_0_0# control_logic_rw_0/delay_chain_0/pinv_11_24/w_n127_403# sky130_fd_pr__pfet_01v8 ad=3.193n pd=0.245m as=3.277n ps=0.247m w=84 l=15
X221 control_logic_rw_0/delay_chain_0/pinv_11_17/nmos_m1_w0_420_sli_dli_da_p_0/a_54_0# control_logic_rw_0/delay_chain_0/pinv_11_19/Z control_logic_rw_0/delay_chain_0/pinv_11_17/nmos_m1_w0_420_sli_dli_da_p_0/a_0_0# vdd sky130_fd_pr__nfet_01v8 ad=1.597n pd=0.161m as=1.639n ps=0.163m w=42 l=15
X222 control_logic_rw_0/delay_chain_0/pinv_11_39/pmos_m1_w0_840_sli_dli_da_p_0/a_54_0# control_logic_rw_0/delay_chain_0/pinv_11_44/Z control_logic_rw_0/delay_chain_0/pinv_11_39/pmos_m1_w0_840_sli_dli_da_p_0/a_0_0# control_logic_rw_0/delay_chain_0/pinv_11_44/w_n127_403# sky130_fd_pr__pfet_01v8 ad=3.193n pd=0.245m as=3.277n ps=0.247m w=84 l=15
X223 control_logic_rw_0/delay_chain_0/pinv_11_39/nmos_m1_w0_420_sli_dli_da_p_0/a_54_0# control_logic_rw_0/delay_chain_0/pinv_11_44/Z control_logic_rw_0/delay_chain_0/pinv_11_39/nmos_m1_w0_420_sli_dli_da_p_0/a_0_0# vdd sky130_fd_pr__nfet_01v8 ad=1.597n pd=0.161m as=1.639n ps=0.163m w=42 l=15
X224 control_logic_rw_0/delay_chain_0/pinv_11_28/pmos_m1_w0_840_sli_dli_da_p_0/a_54_0# control_logic_rw_0/delay_chain_0/pinv_11_29/Z control_logic_rw_0/delay_chain_0/pinv_11_28/pmos_m1_w0_840_sli_dli_da_p_0/a_0_0# control_logic_rw_0/delay_chain_0/pinv_11_34/w_n127_403# sky130_fd_pr__pfet_01v8 ad=3.193n pd=0.245m as=3.277n ps=0.247m w=84 l=15
X225 control_logic_rw_0/delay_chain_0/pinv_11_28/nmos_m1_w0_420_sli_dli_da_p_0/a_54_0# control_logic_rw_0/delay_chain_0/pinv_11_29/Z control_logic_rw_0/delay_chain_0/pinv_11_28/nmos_m1_w0_420_sli_dli_da_p_0/a_0_0# vdd sky130_fd_pr__nfet_01v8 ad=1.597n pd=0.161m as=1.639n ps=0.163m w=42 l=15
X226 control_logic_rw_0/delay_chain_0/pinv_11_18/pmos_m1_w0_840_sli_dli_da_p_0/a_54_0# control_logic_rw_0/delay_chain_0/pinv_11_19/Z control_logic_rw_0/delay_chain_0/pinv_11_18/pmos_m1_w0_840_sli_dli_da_p_0/a_0_0# control_logic_rw_0/delay_chain_0/pinv_11_24/w_n127_403# sky130_fd_pr__pfet_01v8 ad=3.193n pd=0.245m as=3.277n ps=0.247m w=84 l=15
X227 control_logic_rw_0/delay_chain_0/pinv_11_18/nmos_m1_w0_420_sli_dli_da_p_0/a_54_0# control_logic_rw_0/delay_chain_0/pinv_11_19/Z control_logic_rw_0/delay_chain_0/pinv_11_18/nmos_m1_w0_420_sli_dli_da_p_0/a_0_0# vdd sky130_fd_pr__nfet_01v8 ad=1.597n pd=0.161m as=1.639n ps=0.163m w=42 l=15
X228 control_logic_rw_0/delay_chain_0/pinv_11_29/pmos_m1_w0_840_sli_dli_da_p_0/a_54_0# control_logic_rw_0/delay_chain_0/pinv_11_34/Z control_logic_rw_0/delay_chain_0/pinv_11_29/pmos_m1_w0_840_sli_dli_da_p_0/a_0_0# control_logic_rw_0/delay_chain_0/pinv_11_34/w_n127_403# sky130_fd_pr__pfet_01v8 ad=3.193n pd=0.245m as=3.277n ps=0.247m w=84 l=15
X229 control_logic_rw_0/delay_chain_0/pinv_11_29/nmos_m1_w0_420_sli_dli_da_p_0/a_54_0# control_logic_rw_0/delay_chain_0/pinv_11_34/Z control_logic_rw_0/delay_chain_0/pinv_11_29/nmos_m1_w0_420_sli_dli_da_p_0/a_0_0# vdd sky130_fd_pr__nfet_01v8 ad=1.597n pd=0.161m as=1.639n ps=0.163m w=42 l=15
X230 control_logic_rw_0/delay_chain_0/pinv_11_19/pmos_m1_w0_840_sli_dli_da_p_0/a_54_0# control_logic_rw_0/delay_chain_0/pinv_11_24/Z control_logic_rw_0/delay_chain_0/pinv_11_19/pmos_m1_w0_840_sli_dli_da_p_0/a_0_0# control_logic_rw_0/delay_chain_0/pinv_11_24/w_n127_403# sky130_fd_pr__pfet_01v8 ad=3.193n pd=0.245m as=3.277n ps=0.247m w=84 l=15
X231 control_logic_rw_0/delay_chain_0/pinv_11_19/nmos_m1_w0_420_sli_dli_da_p_0/a_54_0# control_logic_rw_0/delay_chain_0/pinv_11_24/Z control_logic_rw_0/delay_chain_0/pinv_11_19/nmos_m1_w0_420_sli_dli_da_p_0/a_0_0# vdd sky130_fd_pr__nfet_01v8 ad=1.597n pd=0.161m as=1.639n ps=0.163m w=42 l=15
X232 control_logic_rw_0/pdriver_4_0/pinv_5_0/pmos_m1_w0_840_sli_dli_da_p_0/a_54_0# control_logic_rw_0/pinv_3_0/A control_logic_rw_0/pdriver_4_0/pinv_5_0/pmos_m1_w0_840_sli_dli_da_p_0/a_0_0# control_logic_rw_0/pnand2_1_0/w_n127_195# sky130_fd_pr__pfet_01v8 ad=3.193n pd=0.245m as=3.277n ps=0.247m w=84 l=15
X233 control_logic_rw_0/pdriver_4_0/pinv_5_0/nmos_m1_w0_420_sli_dli_da_p_0/a_54_0# control_logic_rw_0/pinv_3_0/A control_logic_rw_0/pdriver_4_0/pinv_5_0/nmos_m1_w0_420_sli_dli_da_p_0/a_0_0# vdd sky130_fd_pr__nfet_01v8 ad=1.597n pd=0.161m as=1.639n ps=0.163m w=42 l=15
X234 control_logic_rw_0/pdriver_4_0/pinv_8_0/pmos_m1_w0_840_sli_dli_da_p_0/a_54_0# control_logic_rw_0/pdriver_4_0/pinv_8_0/A control_logic_rw_0/pdriver_4_0/pinv_8_0/pmos_m1_w0_840_sli_dli_da_p_0/a_0_0# control_logic_rw_0/pnand2_1_0/w_n127_195# sky130_fd_pr__pfet_01v8 ad=3.193n pd=0.245m as=3.277n ps=0.247m w=84 l=15
X235 control_logic_rw_0/pdriver_4_0/pinv_8_0/nmos_m1_w0_420_sli_dli_da_p_0/a_54_0# control_logic_rw_0/pdriver_4_0/pinv_8_0/A control_logic_rw_0/pdriver_4_0/pinv_8_0/nmos_m1_w0_420_sli_dli_da_p_0/a_0_0# vdd sky130_fd_pr__nfet_01v8 ad=1.597n pd=0.161m as=1.639n ps=0.163m w=42 l=15
X236 control_logic_rw_0/pand2_0/pnand2_0_0/pmos_m1_w0_840_sli_dli_0/a_54_0# control_logic_rw_0/pand3_0/C control_logic_rw_0/pand2_0/pnand2_0_0/pmos_m1_w0_840_sli_dli_0/a_0_0# control_logic_rw_0/pdriver_1_0/w_n127_195# sky130_fd_pr__pfet_01v8 ad=3.193n pd=0.245m as=2.663n ps=0.273m w=84 l=15
X237 control_logic_rw_0/pand2_0/pnand2_0_0/pmos_m1_w0_840_sli_dli_0/a_0_0# vdd control_logic_rw_0/pand2_0/pnand2_0_0/pmos_m1_w0_840_sli_dli_1/a_0_0# control_logic_rw_0/pdriver_1_0/w_n127_195# sky130_fd_pr__pfet_01v8 ad=0 pd=0 as=3.277n ps=0.247m w=84 l=15
X238 control_logic_rw_0/pand2_0/pnand2_0_0/nmos_m1_w0_840_sli_dactive_0/D vdd control_logic_rw_0/pand2_0/pnand2_0_0/nmos_m1_w0_840_sli_dactive_0/a_0_0# vdd sky130_fd_pr__nfet_01v8 ad=3.697n pd=0.257m as=3.277n ps=0.247m w=84 l=15
X239 control_logic_rw_0/pand2_0/pnand2_0_0/nmos_m1_w0_840_sactive_dli_0/a_54_0# control_logic_rw_0/pand3_0/C control_logic_rw_0/pand2_0/pnand2_0_0/nmos_m1_w0_840_sli_dactive_0/D vdd sky130_fd_pr__nfet_01v8 ad=3.193n pd=0.245m as=0 ps=0 w=84 l=15
X240 control_logic_rw_0/pand2_0/pdriver_0/pinv_2_0/pmos_m9_w1_120_sli_dli_da_p_0/a_288_0# control_logic_rw_0/pand3_0/C control_logic_rw_0/pand2_0/pdriver_0/pinv_2_0/pmos_m9_w1_120_sli_dli_da_p_0/a_210_0# control_logic_rw_0/pdriver_1_0/w_n127_195# sky130_fd_pr__pfet_01v8 ad=3.528n pd=0.175m as=3.528n ps=0.175m w=112 l=15
X241 control_logic_rw_0/pand2_0/pdriver_0/pinv_2_0/pmos_m9_w1_120_sli_dli_da_p_0/a_210_0# control_logic_rw_0/pand3_0/C control_logic_rw_0/pand2_0/pdriver_0/pinv_2_0/pmos_m9_w1_120_sli_dli_da_p_0/a_132_0# control_logic_rw_0/pdriver_1_0/w_n127_195# sky130_fd_pr__pfet_01v8 ad=3.528n pd=0.175m as=3.528n ps=0.175m w=112 l=15
X242 control_logic_rw_0/pand2_0/pdriver_0/pinv_2_0/pmos_m9_w1_120_sli_dli_da_p_0/a_54_0# control_logic_rw_0/pand3_0/C control_logic_rw_0/pand2_0/pdriver_0/pinv_2_0/pmos_m9_w1_120_sli_dli_da_p_0/a_0_0# control_logic_rw_0/pdriver_1_0/w_n127_195# sky130_fd_pr__pfet_01v8 ad=3.528n pd=0.175m as=4.368n ps=0.302m w=112 l=15
X243 control_logic_rw_0/pand2_0/pdriver_0/pinv_2_0/pmos_m9_w1_120_sli_dli_da_p_0/a_522_0# control_logic_rw_0/pand3_0/C control_logic_rw_0/pand2_0/pdriver_0/pinv_2_0/pmos_m9_w1_120_sli_dli_da_p_0/a_444_0# control_logic_rw_0/pdriver_1_0/w_n127_195# sky130_fd_pr__pfet_01v8 ad=3.528n pd=0.175m as=3.528n ps=0.175m w=112 l=15
X244 control_logic_rw_0/pand2_0/pdriver_0/pinv_2_0/pmos_m9_w1_120_sli_dli_da_p_0/a_444_0# control_logic_rw_0/pand3_0/C control_logic_rw_0/pand2_0/pdriver_0/pinv_2_0/pmos_m9_w1_120_sli_dli_da_p_0/a_366_0# control_logic_rw_0/pdriver_1_0/w_n127_195# sky130_fd_pr__pfet_01v8 ad=3.528n pd=0.175m as=3.528n ps=0.175m w=112 l=15
X245 control_logic_rw_0/pand2_0/pdriver_0/pinv_2_0/pmos_m9_w1_120_sli_dli_da_p_0/a_678_0# control_logic_rw_0/pand3_0/C control_logic_rw_0/pand2_0/pdriver_0/pinv_2_0/pmos_m9_w1_120_sli_dli_da_p_0/a_600_0# control_logic_rw_0/pdriver_1_0/w_n127_195# sky130_fd_pr__pfet_01v8 ad=4.256n pd=0.3m as=3.528n ps=0.175m w=112 l=15
X246 control_logic_rw_0/pand2_0/pdriver_0/pinv_2_0/pmos_m9_w1_120_sli_dli_da_p_0/a_132_0# control_logic_rw_0/pand3_0/C control_logic_rw_0/pand2_0/pdriver_0/pinv_2_0/pmos_m9_w1_120_sli_dli_da_p_0/a_54_0# control_logic_rw_0/pdriver_1_0/w_n127_195# sky130_fd_pr__pfet_01v8 ad=3.528n pd=0.175m as=3.528n ps=0.175m w=112 l=15
X247 control_logic_rw_0/pand2_0/pdriver_0/pinv_2_0/pmos_m9_w1_120_sli_dli_da_p_0/a_366_0# control_logic_rw_0/pand3_0/C control_logic_rw_0/pand2_0/pdriver_0/pinv_2_0/pmos_m9_w1_120_sli_dli_da_p_0/a_288_0# control_logic_rw_0/pdriver_1_0/w_n127_195# sky130_fd_pr__pfet_01v8 ad=3.528n pd=0.175m as=3.528n ps=0.175m w=112 l=15
X248 control_logic_rw_0/pand2_0/pdriver_0/pinv_2_0/pmos_m9_w1_120_sli_dli_da_p_0/a_600_0# control_logic_rw_0/pand3_0/C control_logic_rw_0/pand2_0/pdriver_0/pinv_2_0/pmos_m9_w1_120_sli_dli_da_p_0/a_522_0# control_logic_rw_0/pdriver_1_0/w_n127_195# sky130_fd_pr__pfet_01v8 ad=3.528n pd=0.175m as=3.528n ps=0.175m w=112 l=15
X249 control_logic_rw_0/pand2_0/pdriver_0/pinv_2_0/nmos_m9_w0_560_sli_dli_da_p_0/a_132_0# control_logic_rw_0/pand3_0/C control_logic_rw_0/pand2_0/pdriver_0/pinv_2_0/nmos_m9_w0_560_sli_dli_da_p_0/a_54_0# vdd sky130_fd_pr__nfet_01v8 ad=1.764n pd=0.119m as=1.764n ps=0.119m w=56 l=15
X250 control_logic_rw_0/pand2_0/pdriver_0/pinv_2_0/nmos_m9_w0_560_sli_dli_da_p_0/a_366_0# control_logic_rw_0/pand3_0/C control_logic_rw_0/pand2_0/pdriver_0/pinv_2_0/nmos_m9_w0_560_sli_dli_da_p_0/a_288_0# vdd sky130_fd_pr__nfet_01v8 ad=1.764n pd=0.119m as=1.764n ps=0.119m w=56 l=15
X251 control_logic_rw_0/pand2_0/pdriver_0/pinv_2_0/nmos_m9_w0_560_sli_dli_da_p_0/a_600_0# control_logic_rw_0/pand3_0/C control_logic_rw_0/pand2_0/pdriver_0/pinv_2_0/nmos_m9_w0_560_sli_dli_da_p_0/a_522_0# vdd sky130_fd_pr__nfet_01v8 ad=1.764n pd=0.119m as=1.764n ps=0.119m w=56 l=15
X252 control_logic_rw_0/pand2_0/pdriver_0/pinv_2_0/nmos_m9_w0_560_sli_dli_da_p_0/a_288_0# control_logic_rw_0/pand3_0/C control_logic_rw_0/pand2_0/pdriver_0/pinv_2_0/nmos_m9_w0_560_sli_dli_da_p_0/a_210_0# vdd sky130_fd_pr__nfet_01v8 ad=1.764n pd=0.119m as=1.764n ps=0.119m w=56 l=15
X253 control_logic_rw_0/pand2_0/pdriver_0/pinv_2_0/nmos_m9_w0_560_sli_dli_da_p_0/a_210_0# control_logic_rw_0/pand3_0/C control_logic_rw_0/pand2_0/pdriver_0/pinv_2_0/nmos_m9_w0_560_sli_dli_da_p_0/a_132_0# vdd sky130_fd_pr__nfet_01v8 ad=1.764n pd=0.119m as=1.764n ps=0.119m w=56 l=15
X254 control_logic_rw_0/pand2_0/pdriver_0/pinv_2_0/nmos_m9_w0_560_sli_dli_da_p_0/a_54_0# control_logic_rw_0/pand3_0/C control_logic_rw_0/pand2_0/pdriver_0/pinv_2_0/nmos_m9_w0_560_sli_dli_da_p_0/a_0_0# vdd sky130_fd_pr__nfet_01v8 ad=1.764n pd=0.119m as=2.184n ps=0.19m w=56 l=15
X255 control_logic_rw_0/pand2_0/pdriver_0/pinv_2_0/nmos_m9_w0_560_sli_dli_da_p_0/a_522_0# control_logic_rw_0/pand3_0/C control_logic_rw_0/pand2_0/pdriver_0/pinv_2_0/nmos_m9_w0_560_sli_dli_da_p_0/a_444_0# vdd sky130_fd_pr__nfet_01v8 ad=1.764n pd=0.119m as=1.764n ps=0.119m w=56 l=15
X256 control_logic_rw_0/pand2_0/pdriver_0/pinv_2_0/nmos_m9_w0_560_sli_dli_da_p_0/a_444_0# control_logic_rw_0/pand3_0/C control_logic_rw_0/pand2_0/pdriver_0/pinv_2_0/nmos_m9_w0_560_sli_dli_da_p_0/a_366_0# vdd sky130_fd_pr__nfet_01v8 ad=1.764n pd=0.119m as=1.764n ps=0.119m w=56 l=15
X257 control_logic_rw_0/pand2_0/pdriver_0/pinv_2_0/nmos_m9_w0_560_sli_dli_da_p_0/a_678_0# control_logic_rw_0/pand3_0/C control_logic_rw_0/pand2_0/pdriver_0/pinv_2_0/nmos_m9_w0_560_sli_dli_da_p_0/a_600_0# vdd sky130_fd_pr__nfet_01v8 ad=2.128n pd=0.188m as=1.764n ps=0.119m w=56 l=15
X258 control_logic_rw_0/pand2_1/pnand2_0_0/pmos_m1_w0_840_sli_dli_0/a_54_0# control_logic_rw_0/pand3_0/C control_logic_rw_0/pand2_1/pnand2_0_0/pmos_m1_w0_840_sli_dli_0/a_0_0# control_logic_rw_0/pinv_3_1/w_n127_195# sky130_fd_pr__pfet_01v8 ad=3.193n pd=0.245m as=2.663n ps=0.273m w=84 l=15
X259 control_logic_rw_0/pand2_1/pnand2_0_0/pmos_m1_w0_840_sli_dli_0/a_0_0# control_logic_rw_0/pand2_1/A control_logic_rw_0/pand2_1/pnand2_0_0/pmos_m1_w0_840_sli_dli_1/a_0_0# control_logic_rw_0/pinv_3_1/w_n127_195# sky130_fd_pr__pfet_01v8 ad=0 pd=0 as=3.277n ps=0.247m w=84 l=15
X260 control_logic_rw_0/pand2_1/pnand2_0_0/nmos_m1_w0_840_sli_dactive_0/D control_logic_rw_0/pand2_1/A control_logic_rw_0/pand2_1/pnand2_0_0/nmos_m1_w0_840_sli_dactive_0/a_0_0# vdd sky130_fd_pr__nfet_01v8 ad=3.697n pd=0.257m as=3.277n ps=0.247m w=84 l=15
X261 control_logic_rw_0/pand2_1/pnand2_0_0/nmos_m1_w0_840_sactive_dli_0/a_54_0# control_logic_rw_0/pand3_0/C control_logic_rw_0/pand2_1/pnand2_0_0/nmos_m1_w0_840_sli_dactive_0/D vdd sky130_fd_pr__nfet_01v8 ad=3.193n pd=0.245m as=0 ps=0 w=84 l=15
X262 control_logic_rw_0/pand2_1/pdriver_0/pinv_2_0/pmos_m9_w1_120_sli_dli_da_p_0/a_288_0# control_logic_rw_0/pand3_0/C control_logic_rw_0/pand2_1/pdriver_0/pinv_2_0/pmos_m9_w1_120_sli_dli_da_p_0/a_210_0# control_logic_rw_0/pinv_3_1/w_n127_195# sky130_fd_pr__pfet_01v8 ad=7.057n pd=0.351m as=7.057n ps=0.351m w=112 l=15
X263 control_logic_rw_0/pand2_1/pdriver_0/pinv_2_0/pmos_m9_w1_120_sli_dli_da_p_0/a_210_0# control_logic_rw_0/pand3_0/C control_logic_rw_0/pand2_1/pdriver_0/pinv_2_0/pmos_m9_w1_120_sli_dli_da_p_0/a_132_0# control_logic_rw_0/pinv_3_1/w_n127_195# sky130_fd_pr__pfet_01v8 ad=0 pd=0 as=7.057n ps=0.351m w=112 l=15
X264 control_logic_rw_0/pand2_1/pdriver_0/pinv_2_0/pmos_m9_w1_120_sli_dli_da_p_0/a_54_0# control_logic_rw_0/pand3_0/C control_logic_rw_0/pand2_1/pdriver_0/pinv_2_0/pmos_m9_w1_120_sli_dli_da_p_0/a_0_0# control_logic_rw_0/pinv_3_1/w_n127_195# sky130_fd_pr__pfet_01v8 ad=7.057n pd=0.351m as=4.369n ps=0.303m w=112 l=15
X265 control_logic_rw_0/pand2_1/pdriver_0/pinv_2_0/pmos_m9_w1_120_sli_dli_da_p_0/a_522_0# control_logic_rw_0/pand3_0/C control_logic_rw_0/pand2_1/pdriver_0/pinv_2_0/pmos_m9_w1_120_sli_dli_da_p_0/a_444_0# control_logic_rw_0/pinv_3_1/w_n127_195# sky130_fd_pr__pfet_01v8 ad=7.057n pd=0.351m as=7.057n ps=0.351m w=112 l=15
X266 control_logic_rw_0/pand2_1/pdriver_0/pinv_2_0/pmos_m9_w1_120_sli_dli_da_p_0/a_444_0# control_logic_rw_0/pand3_0/C control_logic_rw_0/pand2_1/pdriver_0/pinv_2_0/pmos_m9_w1_120_sli_dli_da_p_0/a_366_0# control_logic_rw_0/pinv_3_1/w_n127_195# sky130_fd_pr__pfet_01v8 ad=0 pd=0 as=7.057n ps=0.351m w=112 l=15
X267 control_logic_rw_0/pand2_1/pdriver_0/pinv_2_0/pmos_m9_w1_120_sli_dli_da_p_0/a_678_0# control_logic_rw_0/pand3_0/C control_logic_rw_0/pand2_1/pdriver_0/pinv_2_0/pmos_m9_w1_120_sli_dli_da_p_0/a_600_0# control_logic_rw_0/pinv_3_1/w_n127_195# sky130_fd_pr__pfet_01v8 ad=4.257n pd=0.301m as=7.057n ps=0.351m w=112 l=15
X268 control_logic_rw_0/pand2_1/pdriver_0/pinv_2_0/pmos_m9_w1_120_sli_dli_da_p_0/a_132_0# control_logic_rw_0/pand3_0/C control_logic_rw_0/pand2_1/pdriver_0/pinv_2_0/pmos_m9_w1_120_sli_dli_da_p_0/a_54_0# control_logic_rw_0/pinv_3_1/w_n127_195# sky130_fd_pr__pfet_01v8 ad=0 pd=0 as=0 ps=0 w=112 l=15
X269 control_logic_rw_0/pand2_1/pdriver_0/pinv_2_0/pmos_m9_w1_120_sli_dli_da_p_0/a_366_0# control_logic_rw_0/pand3_0/C control_logic_rw_0/pand2_1/pdriver_0/pinv_2_0/pmos_m9_w1_120_sli_dli_da_p_0/a_288_0# control_logic_rw_0/pinv_3_1/w_n127_195# sky130_fd_pr__pfet_01v8 ad=0 pd=0 as=0 ps=0 w=112 l=15
X270 control_logic_rw_0/pand2_1/pdriver_0/pinv_2_0/pmos_m9_w1_120_sli_dli_da_p_0/a_600_0# control_logic_rw_0/pand3_0/C control_logic_rw_0/pand2_1/pdriver_0/pinv_2_0/pmos_m9_w1_120_sli_dli_da_p_0/a_522_0# control_logic_rw_0/pinv_3_1/w_n127_195# sky130_fd_pr__pfet_01v8 ad=0 pd=0 as=0 ps=0 w=112 l=15
X271 control_logic_rw_0/pand2_1/pdriver_0/pinv_2_0/nmos_m9_w0_560_sli_dli_da_p_0/a_132_0# control_logic_rw_0/pand3_0/C control_logic_rw_0/pand2_1/pdriver_0/pinv_2_0/nmos_m9_w0_560_sli_dli_da_p_0/a_54_0# vdd sky130_fd_pr__nfet_01v8 ad=3.529n pd=0.239m as=3.529n ps=0.239m w=56 l=15
X272 control_logic_rw_0/pand2_1/pdriver_0/pinv_2_0/nmos_m9_w0_560_sli_dli_da_p_0/a_366_0# control_logic_rw_0/pand3_0/C control_logic_rw_0/pand2_1/pdriver_0/pinv_2_0/nmos_m9_w0_560_sli_dli_da_p_0/a_288_0# vdd sky130_fd_pr__nfet_01v8 ad=3.529n pd=0.239m as=3.529n ps=0.239m w=56 l=15
X273 control_logic_rw_0/pand2_1/pdriver_0/pinv_2_0/nmos_m9_w0_560_sli_dli_da_p_0/a_600_0# control_logic_rw_0/pand3_0/C control_logic_rw_0/pand2_1/pdriver_0/pinv_2_0/nmos_m9_w0_560_sli_dli_da_p_0/a_522_0# vdd sky130_fd_pr__nfet_01v8 ad=3.529n pd=0.239m as=3.529n ps=0.239m w=56 l=15
X274 control_logic_rw_0/pand2_1/pdriver_0/pinv_2_0/nmos_m9_w0_560_sli_dli_da_p_0/a_288_0# control_logic_rw_0/pand3_0/C control_logic_rw_0/pand2_1/pdriver_0/pinv_2_0/nmos_m9_w0_560_sli_dli_da_p_0/a_210_0# vdd sky130_fd_pr__nfet_01v8 ad=0 pd=0 as=3.529n ps=0.239m w=56 l=15
X275 control_logic_rw_0/pand2_1/pdriver_0/pinv_2_0/nmos_m9_w0_560_sli_dli_da_p_0/a_210_0# control_logic_rw_0/pand3_0/C control_logic_rw_0/pand2_1/pdriver_0/pinv_2_0/nmos_m9_w0_560_sli_dli_da_p_0/a_132_0# vdd sky130_fd_pr__nfet_01v8 ad=0 pd=0 as=0 ps=0 w=56 l=15
X276 control_logic_rw_0/pand2_1/pdriver_0/pinv_2_0/nmos_m9_w0_560_sli_dli_da_p_0/a_54_0# control_logic_rw_0/pand3_0/C control_logic_rw_0/pand2_1/pdriver_0/pinv_2_0/nmos_m9_w0_560_sli_dli_da_p_0/a_0_0# vdd sky130_fd_pr__nfet_01v8 ad=0 pd=0 as=2.185n ps=0.191m w=56 l=15
X277 control_logic_rw_0/pand2_1/pdriver_0/pinv_2_0/nmos_m9_w0_560_sli_dli_da_p_0/a_522_0# control_logic_rw_0/pand3_0/C control_logic_rw_0/pand2_1/pdriver_0/pinv_2_0/nmos_m9_w0_560_sli_dli_da_p_0/a_444_0# vdd sky130_fd_pr__nfet_01v8 ad=0 pd=0 as=3.529n ps=0.239m w=56 l=15
X278 control_logic_rw_0/pand2_1/pdriver_0/pinv_2_0/nmos_m9_w0_560_sli_dli_da_p_0/a_444_0# control_logic_rw_0/pand3_0/C control_logic_rw_0/pand2_1/pdriver_0/pinv_2_0/nmos_m9_w0_560_sli_dli_da_p_0/a_366_0# vdd sky130_fd_pr__nfet_01v8 ad=0 pd=0 as=0 ps=0 w=56 l=15
X279 control_logic_rw_0/pand2_1/pdriver_0/pinv_2_0/nmos_m9_w0_560_sli_dli_da_p_0/a_678_0# control_logic_rw_0/pand3_0/C control_logic_rw_0/pand2_1/pdriver_0/pinv_2_0/nmos_m9_w0_560_sli_dli_da_p_0/a_600_0# vdd sky130_fd_pr__nfet_01v8 ad=2.129n pd=0.189m as=0 ps=0 w=56 l=15
X280 control_logic_rw_0/pnand2_1_0/pmos_m1_w0_840_sli_dli_0/a_54_0# control_logic_rw_0/pinv_3_0/A control_logic_rw_0/pnand2_1_0/pmos_m1_w0_840_sli_dli_0/a_0_0# control_logic_rw_0/pnand2_1_0/w_n127_195# sky130_fd_pr__pfet_01v8 ad=3.193n pd=0.245m as=2.663n ps=0.273m w=84 l=15
X281 control_logic_rw_0/pnand2_1_0/pmos_m1_w0_840_sli_dli_0/a_0_0# control_logic_rw_0/pand2_0/Z control_logic_rw_0/pnand2_1_0/pmos_m1_w0_840_sli_dli_1/a_0_0# control_logic_rw_0/pnand2_1_0/w_n127_195# sky130_fd_pr__pfet_01v8 ad=0 pd=0 as=3.277n ps=0.247m w=84 l=15
X282 control_logic_rw_0/pnand2_1_0/nmos_m1_w0_840_sli_dactive_0/D control_logic_rw_0/pand2_0/Z control_logic_rw_0/pnand2_1_0/nmos_m1_w0_840_sli_dactive_0/a_0_0# vdd sky130_fd_pr__nfet_01v8 ad=3.697n pd=0.257m as=3.277n ps=0.247m w=84 l=15
X283 control_logic_rw_0/pnand2_1_0/nmos_m1_w0_840_sactive_dli_0/a_54_0# control_logic_rw_0/pinv_3_0/A control_logic_rw_0/pnand2_1_0/nmos_m1_w0_840_sli_dactive_0/D vdd sky130_fd_pr__nfet_01v8 ad=3.193n pd=0.245m as=0 ps=0 w=84 l=15
X284 control_logic_rw_0/pdriver_0_0/pinv_7_0/nmos_m11_w0_570_sli_dli_da_p_0/a_132_0# control_logic_rw_0/pdriver_0_0/pinv_7_0/A control_logic_rw_0/pdriver_0_0/pinv_7_0/nmos_m11_w0_570_sli_dli_da_p_0/a_54_0# vdd sky130_fd_pr__nfet_01v8 ad=1.795n pd=0.12m as=1.795n ps=0.12m w=57 l=15
X285 control_logic_rw_0/pdriver_0_0/pinv_7_0/nmos_m11_w0_570_sli_dli_da_p_0/a_366_0# control_logic_rw_0/pdriver_0_0/pinv_7_0/A control_logic_rw_0/pdriver_0_0/pinv_7_0/nmos_m11_w0_570_sli_dli_da_p_0/a_288_0# vdd sky130_fd_pr__nfet_01v8 ad=1.795n pd=0.12m as=1.795n ps=0.12m w=57 l=15
X286 control_logic_rw_0/pdriver_0_0/pinv_7_0/nmos_m11_w0_570_sli_dli_da_p_0/a_600_0# control_logic_rw_0/pdriver_0_0/pinv_7_0/A control_logic_rw_0/pdriver_0_0/pinv_7_0/nmos_m11_w0_570_sli_dli_da_p_0/a_522_0# vdd sky130_fd_pr__nfet_01v8 ad=1.795n pd=0.12m as=1.795n ps=0.12m w=57 l=15
X287 control_logic_rw_0/pdriver_0_0/pinv_7_0/nmos_m11_w0_570_sli_dli_da_p_0/a_288_0# control_logic_rw_0/pdriver_0_0/pinv_7_0/A control_logic_rw_0/pdriver_0_0/pinv_7_0/nmos_m11_w0_570_sli_dli_da_p_0/a_210_0# vdd sky130_fd_pr__nfet_01v8 ad=1.795n pd=0.12m as=1.795n ps=0.12m w=57 l=15
X288 control_logic_rw_0/pdriver_0_0/pinv_7_0/nmos_m11_w0_570_sli_dli_da_p_0/a_210_0# control_logic_rw_0/pdriver_0_0/pinv_7_0/A control_logic_rw_0/pdriver_0_0/pinv_7_0/nmos_m11_w0_570_sli_dli_da_p_0/a_132_0# vdd sky130_fd_pr__nfet_01v8 ad=1.795n pd=0.12m as=1.795n ps=0.12m w=57 l=15
X289 control_logic_rw_0/pdriver_0_0/pinv_7_0/nmos_m11_w0_570_sli_dli_da_p_0/a_54_0# control_logic_rw_0/pdriver_0_0/pinv_7_0/A control_logic_rw_0/pdriver_0_0/pinv_7_0/nmos_m11_w0_570_sli_dli_da_p_0/a_0_0# vdd sky130_fd_pr__nfet_01v8 ad=1.795n pd=0.12m as=2.223n ps=0.192m w=57 l=15
X290 control_logic_rw_0/pdriver_0_0/pinv_7_0/nmos_m11_w0_570_sli_dli_da_p_0/a_834_0# control_logic_rw_0/pdriver_0_0/pinv_7_0/A control_logic_rw_0/pdriver_0_0/pinv_7_0/nmos_m11_w0_570_sli_dli_da_p_0/a_756_0# vdd sky130_fd_pr__nfet_01v8 ad=2.166n pd=0.19m as=1.795n ps=0.12m w=57 l=15
X291 control_logic_rw_0/pdriver_0_0/pinv_7_0/nmos_m11_w0_570_sli_dli_da_p_0/a_522_0# control_logic_rw_0/pdriver_0_0/pinv_7_0/A control_logic_rw_0/pdriver_0_0/pinv_7_0/nmos_m11_w0_570_sli_dli_da_p_0/a_444_0# vdd sky130_fd_pr__nfet_01v8 ad=1.795n pd=0.12m as=1.795n ps=0.12m w=57 l=15
X292 control_logic_rw_0/pdriver_0_0/pinv_7_0/nmos_m11_w0_570_sli_dli_da_p_0/a_756_0# control_logic_rw_0/pdriver_0_0/pinv_7_0/A control_logic_rw_0/pdriver_0_0/pinv_7_0/nmos_m11_w0_570_sli_dli_da_p_0/a_678_0# vdd sky130_fd_pr__nfet_01v8 ad=1.795n pd=0.12m as=1.795n ps=0.12m w=57 l=15
X293 control_logic_rw_0/pdriver_0_0/pinv_7_0/nmos_m11_w0_570_sli_dli_da_p_0/a_444_0# control_logic_rw_0/pdriver_0_0/pinv_7_0/A control_logic_rw_0/pdriver_0_0/pinv_7_0/nmos_m11_w0_570_sli_dli_da_p_0/a_366_0# vdd sky130_fd_pr__nfet_01v8 ad=1.795n pd=0.12m as=1.795n ps=0.12m w=57 l=15
X294 control_logic_rw_0/pdriver_0_0/pinv_7_0/nmos_m11_w0_570_sli_dli_da_p_0/a_678_0# control_logic_rw_0/pdriver_0_0/pinv_7_0/A control_logic_rw_0/pdriver_0_0/pinv_7_0/nmos_m11_w0_570_sli_dli_da_p_0/a_600_0# vdd sky130_fd_pr__nfet_01v8 ad=1.795n pd=0.12m as=1.795n ps=0.12m w=57 l=15
X295 control_logic_rw_0/pdriver_0_0/pinv_7_0/pmos_m11_w1_150_sli_dli_da_p_0/a_288_0# control_logic_rw_0/pdriver_0_0/pinv_7_0/A control_logic_rw_0/pdriver_0_0/pinv_7_0/pmos_m11_w1_150_sli_dli_da_p_0/a_210_0# control_logic_rw_0/pinv_3_1/w_n127_195# sky130_fd_pr__pfet_01v8 ad=3.622n pd=0.178m as=3.622n ps=0.178m w=115 l=15
X296 control_logic_rw_0/pdriver_0_0/pinv_7_0/pmos_m11_w1_150_sli_dli_da_p_0/a_210_0# control_logic_rw_0/pdriver_0_0/pinv_7_0/A control_logic_rw_0/pdriver_0_0/pinv_7_0/pmos_m11_w1_150_sli_dli_da_p_0/a_132_0# control_logic_rw_0/pinv_3_1/w_n127_195# sky130_fd_pr__pfet_01v8 ad=3.622n pd=0.178m as=3.622n ps=0.178m w=115 l=15
X297 control_logic_rw_0/pdriver_0_0/pinv_7_0/pmos_m11_w1_150_sli_dli_da_p_0/a_54_0# control_logic_rw_0/pdriver_0_0/pinv_7_0/A control_logic_rw_0/pdriver_0_0/pinv_7_0/pmos_m11_w1_150_sli_dli_da_p_0/a_0_0# control_logic_rw_0/pinv_3_1/w_n127_195# sky130_fd_pr__pfet_01v8 ad=3.622n pd=0.178m as=4.485n ps=0.308m w=115 l=15
X298 control_logic_rw_0/pdriver_0_0/pinv_7_0/pmos_m11_w1_150_sli_dli_da_p_0/a_834_0# control_logic_rw_0/pdriver_0_0/pinv_7_0/A control_logic_rw_0/pdriver_0_0/pinv_7_0/pmos_m11_w1_150_sli_dli_da_p_0/a_756_0# control_logic_rw_0/pinv_3_1/w_n127_195# sky130_fd_pr__pfet_01v8 ad=4.37n pd=0.306m as=3.622n ps=0.178m w=115 l=15
X299 control_logic_rw_0/pdriver_0_0/pinv_7_0/pmos_m11_w1_150_sli_dli_da_p_0/a_522_0# control_logic_rw_0/pdriver_0_0/pinv_7_0/A control_logic_rw_0/pdriver_0_0/pinv_7_0/pmos_m11_w1_150_sli_dli_da_p_0/a_444_0# control_logic_rw_0/pinv_3_1/w_n127_195# sky130_fd_pr__pfet_01v8 ad=3.622n pd=0.178m as=3.622n ps=0.178m w=115 l=15
X300 control_logic_rw_0/pdriver_0_0/pinv_7_0/pmos_m11_w1_150_sli_dli_da_p_0/a_756_0# control_logic_rw_0/pdriver_0_0/pinv_7_0/A control_logic_rw_0/pdriver_0_0/pinv_7_0/pmos_m11_w1_150_sli_dli_da_p_0/a_678_0# control_logic_rw_0/pinv_3_1/w_n127_195# sky130_fd_pr__pfet_01v8 ad=3.622n pd=0.178m as=3.622n ps=0.178m w=115 l=15
X301 control_logic_rw_0/pdriver_0_0/pinv_7_0/pmos_m11_w1_150_sli_dli_da_p_0/a_444_0# control_logic_rw_0/pdriver_0_0/pinv_7_0/A control_logic_rw_0/pdriver_0_0/pinv_7_0/pmos_m11_w1_150_sli_dli_da_p_0/a_366_0# control_logic_rw_0/pinv_3_1/w_n127_195# sky130_fd_pr__pfet_01v8 ad=3.622n pd=0.178m as=3.622n ps=0.178m w=115 l=15
X302 control_logic_rw_0/pdriver_0_0/pinv_7_0/pmos_m11_w1_150_sli_dli_da_p_0/a_678_0# control_logic_rw_0/pdriver_0_0/pinv_7_0/A control_logic_rw_0/pdriver_0_0/pinv_7_0/pmos_m11_w1_150_sli_dli_da_p_0/a_600_0# control_logic_rw_0/pinv_3_1/w_n127_195# sky130_fd_pr__pfet_01v8 ad=3.622n pd=0.178m as=3.622n ps=0.178m w=115 l=15
X303 control_logic_rw_0/pdriver_0_0/pinv_7_0/pmos_m11_w1_150_sli_dli_da_p_0/a_132_0# control_logic_rw_0/pdriver_0_0/pinv_7_0/A control_logic_rw_0/pdriver_0_0/pinv_7_0/pmos_m11_w1_150_sli_dli_da_p_0/a_54_0# control_logic_rw_0/pinv_3_1/w_n127_195# sky130_fd_pr__pfet_01v8 ad=3.622n pd=0.178m as=3.622n ps=0.178m w=115 l=15
X304 control_logic_rw_0/pdriver_0_0/pinv_7_0/pmos_m11_w1_150_sli_dli_da_p_0/a_366_0# control_logic_rw_0/pdriver_0_0/pinv_7_0/A control_logic_rw_0/pdriver_0_0/pinv_7_0/pmos_m11_w1_150_sli_dli_da_p_0/a_288_0# control_logic_rw_0/pinv_3_1/w_n127_195# sky130_fd_pr__pfet_01v8 ad=3.622n pd=0.178m as=3.622n ps=0.178m w=115 l=15
X305 control_logic_rw_0/pdriver_0_0/pinv_7_0/pmos_m11_w1_150_sli_dli_da_p_0/a_600_0# control_logic_rw_0/pdriver_0_0/pinv_7_0/A control_logic_rw_0/pdriver_0_0/pinv_7_0/pmos_m11_w1_150_sli_dli_da_p_0/a_522_0# control_logic_rw_0/pinv_3_1/w_n127_195# sky130_fd_pr__pfet_01v8 ad=3.622n pd=0.178m as=3.622n ps=0.178m w=115 l=15
X306 control_logic_rw_0/pdriver_0_0/pinv_5_0/pmos_m1_w0_840_sli_dli_da_p_0/a_54_0# clk0 control_logic_rw_0/pdriver_0_0/pinv_5_0/pmos_m1_w0_840_sli_dli_da_p_0/a_0_0# control_logic_rw_0/pinv_3_1/w_n127_195# sky130_fd_pr__pfet_01v8 ad=3.193n pd=0.245m as=3.277n ps=0.247m w=84 l=15
X307 control_logic_rw_0/pdriver_0_0/pinv_5_0/nmos_m1_w0_420_sli_dli_da_p_0/a_54_0# clk0 control_logic_rw_0/pdriver_0_0/pinv_5_0/nmos_m1_w0_420_sli_dli_da_p_0/a_0_0# vdd sky130_fd_pr__nfet_01v8 ad=1.597n pd=0.161m as=1.639n ps=0.163m w=42 l=15
X308 control_logic_rw_0/pdriver_0_0/pinv_6_0/pmos_m4_w1_050_sli_dli_da_p_0/a_288_0# control_logic_rw_0/pdriver_0_0/pinv_6_0/A control_logic_rw_0/pdriver_0_0/pinv_6_0/pmos_m4_w1_050_sli_dli_da_p_0/a_210_0# control_logic_rw_0/pinv_3_1/w_n127_195# sky130_fd_pr__pfet_01v8 ad=3.991n pd=0.287m as=6.616n ps=0.337m w=105 l=15
X309 control_logic_rw_0/pdriver_0_0/pinv_6_0/pmos_m4_w1_050_sli_dli_da_p_0/a_210_0# control_logic_rw_0/pdriver_0_0/pinv_6_0/A control_logic_rw_0/pdriver_0_0/pinv_6_0/pmos_m4_w1_050_sli_dli_da_p_0/a_132_0# control_logic_rw_0/pinv_3_1/w_n127_195# sky130_fd_pr__pfet_01v8 ad=0 pd=0 as=6.616n ps=0.337m w=105 l=15
X310 control_logic_rw_0/pdriver_0_0/pinv_6_0/pmos_m4_w1_050_sli_dli_da_p_0/a_54_0# control_logic_rw_0/pdriver_0_0/pinv_6_0/A control_logic_rw_0/pdriver_0_0/pinv_6_0/pmos_m4_w1_050_sli_dli_da_p_0/a_0_0# control_logic_rw_0/pinv_3_1/w_n127_195# sky130_fd_pr__pfet_01v8 ad=6.616n pd=0.337m as=4.096n ps=0.289m w=105 l=15
X311 control_logic_rw_0/pdriver_0_0/pinv_6_0/pmos_m4_w1_050_sli_dli_da_p_0/a_132_0# control_logic_rw_0/pdriver_0_0/pinv_6_0/A control_logic_rw_0/pdriver_0_0/pinv_6_0/pmos_m4_w1_050_sli_dli_da_p_0/a_54_0# control_logic_rw_0/pinv_3_1/w_n127_195# sky130_fd_pr__pfet_01v8 ad=0 pd=0 as=0 ps=0 w=105 l=15
X312 control_logic_rw_0/pdriver_0_0/pinv_6_0/nmos_m4_w0_520_sli_dli_da_p_0/a_132_0# control_logic_rw_0/pdriver_0_0/pinv_6_0/A control_logic_rw_0/pdriver_0_0/pinv_6_0/nmos_m4_w0_520_sli_dli_da_p_0/a_54_0# vdd sky130_fd_pr__nfet_01v8 ad=3.277n pd=0.231m as=3.277n ps=0.231m w=52 l=15
X313 control_logic_rw_0/pdriver_0_0/pinv_6_0/nmos_m4_w0_520_sli_dli_da_p_0/a_288_0# control_logic_rw_0/pdriver_0_0/pinv_6_0/A control_logic_rw_0/pdriver_0_0/pinv_6_0/nmos_m4_w0_520_sli_dli_da_p_0/a_210_0# vdd sky130_fd_pr__nfet_01v8 ad=1.977n pd=0.181m as=3.277n ps=0.231m w=52 l=15
X314 control_logic_rw_0/pdriver_0_0/pinv_6_0/nmos_m4_w0_520_sli_dli_da_p_0/a_210_0# control_logic_rw_0/pdriver_0_0/pinv_6_0/A control_logic_rw_0/pdriver_0_0/pinv_6_0/nmos_m4_w0_520_sli_dli_da_p_0/a_132_0# vdd sky130_fd_pr__nfet_01v8 ad=0 pd=0 as=0 ps=0 w=52 l=15
X315 control_logic_rw_0/pdriver_0_0/pinv_6_0/nmos_m4_w0_520_sli_dli_da_p_0/a_54_0# control_logic_rw_0/pdriver_0_0/pinv_6_0/A control_logic_rw_0/pdriver_0_0/pinv_6_0/nmos_m4_w0_520_sli_dli_da_p_0/a_0_0# vdd sky130_fd_pr__nfet_01v8 ad=0 pd=0 as=2.029n ps=0.183m w=52 l=15
X316 control_logic_rw_0/pdriver_0_0/pinv_4_0/nmos_m2_w0_420_sli_dli_da_p_0/a_132_0# control_logic_rw_0/pdriver_0_0/pinv_5_0/Z control_logic_rw_0/pdriver_0_0/pinv_4_0/nmos_m2_w0_420_sli_dli_da_p_0/a_54_0# vdd sky130_fd_pr__nfet_01v8 ad=1.597n pd=0.161m as=2.647n ps=0.211m w=42 l=15
X317 control_logic_rw_0/pdriver_0_0/pinv_4_0/nmos_m2_w0_420_sli_dli_da_p_0/a_54_0# control_logic_rw_0/pdriver_0_0/pinv_5_0/Z control_logic_rw_0/pdriver_0_0/pinv_4_0/nmos_m2_w0_420_sli_dli_da_p_0/a_0_0# vdd sky130_fd_pr__nfet_01v8 ad=0 pd=0 as=1.639n ps=0.163m w=42 l=15
X318 control_logic_rw_0/pdriver_0_0/pinv_4_0/pmos_m2_w0_840_sli_dli_da_p_0/a_54_0# control_logic_rw_0/pdriver_0_0/pinv_5_0/Z control_logic_rw_0/pdriver_0_0/pinv_4_0/pmos_m2_w0_840_sli_dli_da_p_0/a_0_0# control_logic_rw_0/pinv_3_1/w_n127_195# sky130_fd_pr__pfet_01v8 ad=5.293n pd=0.295m as=3.277n ps=0.247m w=84 l=15
X319 control_logic_rw_0/pdriver_0_0/pinv_4_0/pmos_m2_w0_840_sli_dli_da_p_0/a_132_0# control_logic_rw_0/pdriver_0_0/pinv_5_0/Z control_logic_rw_0/pdriver_0_0/pinv_4_0/pmos_m2_w0_840_sli_dli_da_p_0/a_54_0# control_logic_rw_0/pinv_3_1/w_n127_195# sky130_fd_pr__pfet_01v8 ad=3.193n pd=0.245m as=0 ps=0 w=84 l=15
X320 vdd row_addr_dff_0/dff_0/net3 row_addr_dff_0/dff_0/net2 vdd sky130_fd_pr__pfet_01v8 ad=0 pd=0 as=6.655n ps=0.462m w=55 l=15
X321 row_addr_dff_0/dff_0/net4 row_addr_dff_0/dff_0/clkb row_addr_dff_0/dff_0/net3 vdd sky130_fd_pr__pfet_01v8 ad=5.83n pd=0.322m as=6.985n ps=0.474m w=55 l=15
X322 row_addr_dff_0/dff_0/clkb row_addr_dff_0/dff_3/clk vdd vdd sky130_fd_pr__nfet_01v8 ad=1.932n pd=0.176m as=0 ps=0 w=42 l=15
X323 row_addr_dff_0/dff_0/net1 row_addr_dff_0/dff_0/clkb addr0[3] vdd sky130_fd_pr__nfet_01v8 ad=4.452n pd=0.296m as=1.932n ps=0.176m w=42 l=15
X324 vdd row_addr_dff_0/dff_0/net3 row_addr_dff_0/dff_0/net2 vdd sky130_fd_pr__nfet_01v8 ad=0 pd=0 as=5.082n ps=0.41m w=42 l=15
X325 row_addr_dff_0/dff_0/net2 row_addr_dff_0/dff_3/clk row_addr_dff_0/dff_0/net1 vdd sky130_fd_pr__nfet_01v8 ad=0 pd=0 as=0 ps=0 w=42 l=15
X326 row_addr_dff_0/dff_0/net1 row_addr_dff_0/dff_3/clk addr0[3] vdd sky130_fd_pr__pfet_01v8 ad=5.83n pd=0.322m as=2.53n ps=0.202m w=55 l=15
X327 row_addr_dff_0/dff_0/net4 row_addr_dff_0/dff_3/clk row_addr_dff_0/dff_0/net3 vdd sky130_fd_pr__nfet_01v8 ad=4.452n pd=0.296m as=5.334n ps=0.422m w=42 l=15
X328 bank_0/addr0_3 row_addr_dff_0/dff_0/net4 vdd vdd sky130_fd_pr__nfet_01v8 ad=1.68n pd=0.164m as=0 ps=0 w=42 l=15
X329 row_addr_dff_0/dff_0/net5 row_addr_dff_0/dff_3/clk row_addr_dff_0/dff_0/net4 vdd sky130_fd_pr__pfet_01v8 ad=7.425n pd=0.49m as=0 ps=0 w=55 l=15
X330 row_addr_dff_0/dff_0/net5 row_addr_dff_0/dff_0/clkb row_addr_dff_0/dff_0/net4 vdd sky130_fd_pr__nfet_01v8 ad=5.67n pd=0.438m as=0 ps=0 w=42 l=15
X331 row_addr_dff_0/dff_0/clkb row_addr_dff_0/dff_3/clk vdd vdd sky130_fd_pr__pfet_01v8 ad=2.53n pd=0.202m as=0 ps=0 w=55 l=15
X332 vdd bank_0/addr0_3 row_addr_dff_0/dff_0/net5 vdd sky130_fd_pr__nfet_01v8 ad=0 pd=0 as=0 ps=0 w=42 l=15
X333 bank_0/addr0_3 row_addr_dff_0/dff_0/net4 vdd vdd sky130_fd_pr__pfet_01v8 ad=2.2n pd=0.19m as=0 ps=0 w=55 l=15
X334 row_addr_dff_0/dff_0/net3 row_addr_dff_0/dff_0/net1 vdd vdd sky130_fd_pr__pfet_01v8 ad=0 pd=0 as=0 ps=0 w=55 l=15
X335 row_addr_dff_0/dff_0/net3 row_addr_dff_0/dff_0/net1 vdd vdd sky130_fd_pr__nfet_01v8 ad=0 pd=0 as=0 ps=0 w=42 l=15
X336 row_addr_dff_0/dff_0/net2 row_addr_dff_0/dff_0/clkb row_addr_dff_0/dff_0/net1 vdd sky130_fd_pr__pfet_01v8 ad=0 pd=0 as=0 ps=0 w=55 l=15
X337 vdd bank_0/addr0_3 row_addr_dff_0/dff_0/net5 vdd sky130_fd_pr__pfet_01v8 ad=0 pd=0 as=0 ps=0 w=55 l=15
X338 vdd row_addr_dff_0/dff_1/net3 row_addr_dff_0/dff_1/net2 vdd sky130_fd_pr__pfet_01v8 ad=0 pd=0 as=6.655n ps=0.462m w=55 l=15
X339 row_addr_dff_0/dff_1/net4 row_addr_dff_0/dff_1/clkb row_addr_dff_0/dff_1/net3 vdd sky130_fd_pr__pfet_01v8 ad=5.83n pd=0.322m as=6.985n ps=0.474m w=55 l=15
X340 row_addr_dff_0/dff_1/clkb row_addr_dff_0/dff_3/clk vdd vdd sky130_fd_pr__nfet_01v8 ad=1.932n pd=0.176m as=0 ps=0 w=42 l=15
X341 row_addr_dff_0/dff_1/net1 row_addr_dff_0/dff_1/clkb addr0[2] vdd sky130_fd_pr__nfet_01v8 ad=4.452n pd=0.296m as=1.932n ps=0.176m w=42 l=15
X342 vdd row_addr_dff_0/dff_1/net3 row_addr_dff_0/dff_1/net2 vdd sky130_fd_pr__nfet_01v8 ad=0 pd=0 as=5.082n ps=0.41m w=42 l=15
X343 row_addr_dff_0/dff_1/net2 row_addr_dff_0/dff_3/clk row_addr_dff_0/dff_1/net1 vdd sky130_fd_pr__nfet_01v8 ad=0 pd=0 as=0 ps=0 w=42 l=15
X344 row_addr_dff_0/dff_1/net1 row_addr_dff_0/dff_3/clk addr0[2] vdd sky130_fd_pr__pfet_01v8 ad=5.83n pd=0.322m as=2.53n ps=0.202m w=55 l=15
X345 row_addr_dff_0/dff_1/net4 row_addr_dff_0/dff_3/clk row_addr_dff_0/dff_1/net3 vdd sky130_fd_pr__nfet_01v8 ad=4.452n pd=0.296m as=5.334n ps=0.422m w=42 l=15
X346 bank_0/addr0_2 row_addr_dff_0/dff_1/net4 vdd vdd sky130_fd_pr__nfet_01v8 ad=1.68n pd=0.164m as=0 ps=0 w=42 l=15
X347 row_addr_dff_0/dff_1/net5 row_addr_dff_0/dff_3/clk row_addr_dff_0/dff_1/net4 vdd sky130_fd_pr__pfet_01v8 ad=7.425n pd=0.49m as=0 ps=0 w=55 l=15
X348 row_addr_dff_0/dff_1/net5 row_addr_dff_0/dff_1/clkb row_addr_dff_0/dff_1/net4 vdd sky130_fd_pr__nfet_01v8 ad=5.67n pd=0.438m as=0 ps=0 w=42 l=15
X349 row_addr_dff_0/dff_1/clkb row_addr_dff_0/dff_3/clk vdd vdd sky130_fd_pr__pfet_01v8 ad=2.53n pd=0.202m as=0 ps=0 w=55 l=15
X350 vdd bank_0/addr0_2 row_addr_dff_0/dff_1/net5 vdd sky130_fd_pr__nfet_01v8 ad=0 pd=0 as=0 ps=0 w=42 l=15
X351 bank_0/addr0_2 row_addr_dff_0/dff_1/net4 vdd vdd sky130_fd_pr__pfet_01v8 ad=2.2n pd=0.19m as=0 ps=0 w=55 l=15
X352 row_addr_dff_0/dff_1/net3 row_addr_dff_0/dff_1/net1 vdd vdd sky130_fd_pr__pfet_01v8 ad=0 pd=0 as=0 ps=0 w=55 l=15
X353 row_addr_dff_0/dff_1/net3 row_addr_dff_0/dff_1/net1 vdd vdd sky130_fd_pr__nfet_01v8 ad=0 pd=0 as=0 ps=0 w=42 l=15
X354 row_addr_dff_0/dff_1/net2 row_addr_dff_0/dff_1/clkb row_addr_dff_0/dff_1/net1 vdd sky130_fd_pr__pfet_01v8 ad=0 pd=0 as=0 ps=0 w=55 l=15
X355 vdd bank_0/addr0_2 row_addr_dff_0/dff_1/net5 vdd sky130_fd_pr__pfet_01v8 ad=0 pd=0 as=0 ps=0 w=55 l=15
X356 vdd row_addr_dff_0/dff_2/net3 row_addr_dff_0/dff_2/net2 vdd sky130_fd_pr__pfet_01v8 ad=0 pd=0 as=6.655n ps=0.462m w=55 l=15
X357 row_addr_dff_0/dff_2/net4 row_addr_dff_0/dff_2/clkb row_addr_dff_0/dff_2/net3 vdd sky130_fd_pr__pfet_01v8 ad=5.83n pd=0.322m as=6.985n ps=0.474m w=55 l=15
X358 row_addr_dff_0/dff_2/clkb row_addr_dff_0/dff_3/clk vdd vdd sky130_fd_pr__nfet_01v8 ad=1.932n pd=0.176m as=0 ps=0 w=42 l=15
X359 row_addr_dff_0/dff_2/net1 row_addr_dff_0/dff_2/clkb addr0[1] vdd sky130_fd_pr__nfet_01v8 ad=4.452n pd=0.296m as=1.932n ps=0.176m w=42 l=15
X360 vdd row_addr_dff_0/dff_2/net3 row_addr_dff_0/dff_2/net2 vdd sky130_fd_pr__nfet_01v8 ad=0 pd=0 as=5.082n ps=0.41m w=42 l=15
X361 row_addr_dff_0/dff_2/net2 row_addr_dff_0/dff_3/clk row_addr_dff_0/dff_2/net1 vdd sky130_fd_pr__nfet_01v8 ad=0 pd=0 as=0 ps=0 w=42 l=15
X362 row_addr_dff_0/dff_2/net1 row_addr_dff_0/dff_3/clk addr0[1] vdd sky130_fd_pr__pfet_01v8 ad=5.83n pd=0.322m as=2.53n ps=0.202m w=55 l=15
X363 row_addr_dff_0/dff_2/net4 row_addr_dff_0/dff_3/clk row_addr_dff_0/dff_2/net3 vdd sky130_fd_pr__nfet_01v8 ad=4.452n pd=0.296m as=5.334n ps=0.422m w=42 l=15
X364 bank_0/addr0_1 row_addr_dff_0/dff_2/net4 vdd vdd sky130_fd_pr__nfet_01v8 ad=1.68n pd=0.164m as=0 ps=0 w=42 l=15
X365 row_addr_dff_0/dff_2/net5 row_addr_dff_0/dff_3/clk row_addr_dff_0/dff_2/net4 vdd sky130_fd_pr__pfet_01v8 ad=7.425n pd=0.49m as=0 ps=0 w=55 l=15
X366 row_addr_dff_0/dff_2/net5 row_addr_dff_0/dff_2/clkb row_addr_dff_0/dff_2/net4 vdd sky130_fd_pr__nfet_01v8 ad=5.67n pd=0.438m as=0 ps=0 w=42 l=15
X367 row_addr_dff_0/dff_2/clkb row_addr_dff_0/dff_3/clk vdd vdd sky130_fd_pr__pfet_01v8 ad=2.53n pd=0.202m as=0 ps=0 w=55 l=15
X368 vdd bank_0/addr0_1 row_addr_dff_0/dff_2/net5 vdd sky130_fd_pr__nfet_01v8 ad=0 pd=0 as=0 ps=0 w=42 l=15
X369 bank_0/addr0_1 row_addr_dff_0/dff_2/net4 vdd vdd sky130_fd_pr__pfet_01v8 ad=2.2n pd=0.19m as=0 ps=0 w=55 l=15
X370 row_addr_dff_0/dff_2/net3 row_addr_dff_0/dff_2/net1 vdd vdd sky130_fd_pr__pfet_01v8 ad=0 pd=0 as=0 ps=0 w=55 l=15
X371 row_addr_dff_0/dff_2/net3 row_addr_dff_0/dff_2/net1 vdd vdd sky130_fd_pr__nfet_01v8 ad=0 pd=0 as=0 ps=0 w=42 l=15
X372 row_addr_dff_0/dff_2/net2 row_addr_dff_0/dff_2/clkb row_addr_dff_0/dff_2/net1 vdd sky130_fd_pr__pfet_01v8 ad=0 pd=0 as=0 ps=0 w=55 l=15
X373 vdd bank_0/addr0_1 row_addr_dff_0/dff_2/net5 vdd sky130_fd_pr__pfet_01v8 ad=0 pd=0 as=0 ps=0 w=55 l=15
X374 vdd row_addr_dff_0/dff_3/net3 row_addr_dff_0/dff_3/net2 vdd sky130_fd_pr__pfet_01v8 ad=0 pd=0 as=6.655n ps=0.462m w=55 l=15
X375 row_addr_dff_0/dff_3/net4 row_addr_dff_0/dff_3/clkb row_addr_dff_0/dff_3/net3 vdd sky130_fd_pr__pfet_01v8 ad=5.83n pd=0.322m as=6.985n ps=0.474m w=55 l=15
X376 row_addr_dff_0/dff_3/clkb row_addr_dff_0/dff_3/clk vdd vdd sky130_fd_pr__nfet_01v8 ad=1.932n pd=0.176m as=0 ps=0 w=42 l=15
X377 row_addr_dff_0/dff_3/net1 row_addr_dff_0/dff_3/clkb addr0[0] vdd sky130_fd_pr__nfet_01v8 ad=4.452n pd=0.296m as=1.932n ps=0.176m w=42 l=15
X378 vdd row_addr_dff_0/dff_3/net3 row_addr_dff_0/dff_3/net2 vdd sky130_fd_pr__nfet_01v8 ad=0 pd=0 as=5.082n ps=0.41m w=42 l=15
X379 row_addr_dff_0/dff_3/net2 row_addr_dff_0/dff_3/clk row_addr_dff_0/dff_3/net1 vdd sky130_fd_pr__nfet_01v8 ad=0 pd=0 as=0 ps=0 w=42 l=15
X380 row_addr_dff_0/dff_3/net1 row_addr_dff_0/dff_3/clk addr0[0] vdd sky130_fd_pr__pfet_01v8 ad=5.83n pd=0.322m as=2.53n ps=0.202m w=55 l=15
X381 row_addr_dff_0/dff_3/net4 row_addr_dff_0/dff_3/clk row_addr_dff_0/dff_3/net3 vdd sky130_fd_pr__nfet_01v8 ad=4.452n pd=0.296m as=5.334n ps=0.422m w=42 l=15
X382 vdd row_addr_dff_0/dff_3/net4 vdd vdd sky130_fd_pr__nfet_01v8 ad=0 pd=0 as=0 ps=0 w=42 l=15
X383 row_addr_dff_0/dff_3/net5 row_addr_dff_0/dff_3/clk row_addr_dff_0/dff_3/net4 vdd sky130_fd_pr__pfet_01v8 ad=7.425n pd=0.49m as=0 ps=0 w=55 l=15
X384 row_addr_dff_0/dff_3/net5 row_addr_dff_0/dff_3/clkb row_addr_dff_0/dff_3/net4 vdd sky130_fd_pr__nfet_01v8 ad=5.67n pd=0.438m as=0 ps=0 w=42 l=15
X385 row_addr_dff_0/dff_3/clkb row_addr_dff_0/dff_3/clk vdd vdd sky130_fd_pr__pfet_01v8 ad=2.53n pd=0.202m as=0 ps=0 w=55 l=15
X386 vdd vdd row_addr_dff_0/dff_3/net5 vdd sky130_fd_pr__nfet_01v8 ad=0 pd=0 as=0 ps=0 w=42 l=15
X387 vdd row_addr_dff_0/dff_3/net4 vdd vdd sky130_fd_pr__pfet_01v8 ad=0 pd=0 as=0 ps=0 w=55 l=15
X388 row_addr_dff_0/dff_3/net3 row_addr_dff_0/dff_3/net1 vdd vdd sky130_fd_pr__pfet_01v8 ad=0 pd=0 as=0 ps=0 w=55 l=15
X389 row_addr_dff_0/dff_3/net3 row_addr_dff_0/dff_3/net1 vdd vdd sky130_fd_pr__nfet_01v8 ad=0 pd=0 as=0 ps=0 w=42 l=15
X390 row_addr_dff_0/dff_3/net2 row_addr_dff_0/dff_3/clkb row_addr_dff_0/dff_3/net1 vdd sky130_fd_pr__pfet_01v8 ad=0 pd=0 as=0 ps=0 w=55 l=15
X391 vdd vdd row_addr_dff_0/dff_3/net5 vdd sky130_fd_pr__pfet_01v8 ad=0 pd=0 as=0 ps=0 w=55 l=15
X392 vdd vdd vdd vdd sky130_fd_pr__nfet_01v8 ad=1.68n pd=0.164m as=1.89n ps=0.174m w=42 l=15
X393 vdd vdd vdd vdd sky130_fd_pr__nfet_01v8 ad=4n pd=0.28m as=4.5n ps=0.29m w=100 l=15
X394 vdd vdd vdd vdd sky130_fd_pr__nfet_01v8 ad=1.68n pd=0.164m as=1.89n ps=0.174m w=42 l=15
X395 vdd vdd vdd vdd sky130_fd_pr__pfet_01v8 ad=4n pd=0.28m as=4.5n ps=0.29m w=100 l=15
X396 vdd vdd vdd vdd sky130_fd_pr__nfet_01v8 ad=1.68n pd=0.164m as=1.89n ps=0.174m w=42 l=15
X397 vdd vdd vdd vdd sky130_fd_pr__pfet_01v8 ad=2.2n pd=0.19m as=2.475n ps=0.2m w=55 l=15
X398 vdd vdd vdd vdd sky130_fd_pr__pfet_01v8 ad=2.2n pd=0.19m as=2.475n ps=0.2m w=55 l=15
X399 vdd vdd vdd vdd sky130_fd_pr__nfet_01v8 ad=0 pd=0 as=0 ps=0 w=42 l=15
X400 vdd vdd vdd vdd sky130_fd_pr__nfet_01v8 ad=0 pd=0 as=0 ps=0 w=100 l=15
X401 bank_0/port_data_0/sense_amp_array_0/sense_amp_1/net1 vdd vdd vdd sky130_fd_pr__nfet_01v8 ad=1.68n pd=0.164m as=0 ps=0 w=42 l=15
X402 vdd bank_0/port_data_0/sense_amp_array_0/sense_amp_1/net1 vdd vdd sky130_fd_pr__pfet_01v8 ad=0 pd=0 as=0 ps=0 w=100 l=15
X403 vdd vdd vdd vdd sky130_fd_pr__nfet_01v8 ad=0 pd=0 as=0 ps=0 w=42 l=15
X404 bank_0/port_data_0/sense_amp_array_0/sense_amp_1/net1 bank_0/port_data_0/sense_amp_array_0/sense_amp_1/net1 vdd vdd sky130_fd_pr__pfet_01v8 ad=2.2n pd=0.19m as=0 ps=0 w=55 l=15
X405 vdd vdd vdd vdd sky130_fd_pr__pfet_01v8 ad=0 pd=0 as=0 ps=0 w=55 l=15
X406 vdd vdd bank_0/port_data_0/write_driver_array_0/write_driver_0/net5 vdd sky130_fd_pr__pfet_01v8 ad=2.75n pd=0.21m as=2.75n ps=0.21m w=55 l=15
X407 vdd vdd vdd vdd sky130_fd_pr__nfet_01v8 ad=1.638n pd=0.162m as=2.1n ps=0.184m w=42 l=15
X408 vdd vdd vdd vdd sky130_fd_pr__nfet_01v8 ad=2.1n pd=0.184m as=1.974n ps=0.178m w=42 l=15
X409 bank_0/port_data_0/write_driver_array_0/write_driver_0/net5 vdd vdd vdd sky130_fd_pr__pfet_01v8 ad=2.75n pd=0.21m as=2.75n ps=0.21m w=55 l=15
X410 vdd vdd vdd vdd sky130_fd_pr__nfet_01v8 ad=2.1n pd=0.184m as=2.1n ps=0.184m w=42 l=15
X411 vdd vdd vdd vdd sky130_fd_pr__nfet_01v8 ad=4.2n pd=0.268m as=4.2n ps=0.268m w=84 l=15
X412 vdd vdd vdd vdd sky130_fd_pr__pfet_01v8 ad=2.75n pd=0.21m as=2.75n ps=0.21m w=55 l=15
X413 vdd vdd vdd vdd sky130_fd_pr__nfet_01v8 ad=2.1n pd=0.184m as=2.1n ps=0.184m w=42 l=15
X414 vdd vdd vdd vdd sky130_fd_pr__pfet_01v8 ad=2.75n pd=0.21m as=2.75n ps=0.21m w=55 l=15
X415 vdd vdd vdd vdd sky130_fd_pr__nfet_01v8 ad=4.2n pd=0.268m as=4.2n ps=0.268m w=84 l=15
X416 vdd vdd vdd vdd sky130_fd_pr__nfet_01v8 ad=2.1n pd=0.184m as=2.1n ps=0.184m w=42 l=15
X417 vdd vdd vdd vdd sky130_fd_pr__nfet_01v8 ad=2.1n pd=0.184m as=2.1n ps=0.184m w=42 l=15
X418 bank_0/port_data_0/write_driver_array_0/write_driver_0/net6 vdd vdd vdd sky130_fd_pr__pfet_01v8 ad=2.75n pd=0.21m as=2.75n ps=0.21m w=55 l=15
X419 vdd vdd bank_0/port_data_0/write_driver_array_0/write_driver_0/net6 vdd sky130_fd_pr__pfet_01v8 ad=2.75n pd=0.21m as=2.75n ps=0.21m w=55 l=15
X420 vdd vdd vdd vdd sky130_fd_pr__pfet_01v8 ad=0 pd=0 as=0 ps=0 w=55 l=15
X421 vdd vdd vdd vdd sky130_fd_pr__nfet_01v8 ad=0 pd=0 as=0 ps=0 w=42 l=15
X422 vdd vdd vdd vdd sky130_fd_pr__nfet_01v8 ad=0 pd=0 as=0 ps=0 w=42 l=15
X423 vdd vdd vdd vdd sky130_fd_pr__pfet_01v8 ad=0 pd=0 as=0 ps=0 w=55 l=15
X424 vdd vdd vdd vdd sky130_fd_pr__nfet_01v8 ad=0 pd=0 as=0 ps=0 w=42 l=15
X425 vdd vdd vdd vdd sky130_fd_pr__nfet_01v8 ad=0 pd=0 as=0 ps=0 w=84 l=15
X426 vdd vdd vdd vdd sky130_fd_pr__pfet_01v8 ad=0 pd=0 as=0 ps=0 w=55 l=15
X427 vdd vdd vdd vdd sky130_fd_pr__nfet_01v8 ad=0 pd=0 as=0 ps=0 w=42 l=15
X428 vdd vdd vdd vdd sky130_fd_pr__pfet_01v8 ad=0 pd=0 as=0 ps=0 w=55 l=15
X429 vdd vdd vdd vdd sky130_fd_pr__nfet_01v8 ad=0 pd=0 as=0 ps=0 w=84 l=15
X430 vdd vdd vdd vdd sky130_fd_pr__nfet_01v8 ad=0 pd=0 as=0 ps=0 w=42 l=15
X431 vdd vdd vdd vdd sky130_fd_pr__nfet_01v8 ad=0 pd=0 as=0 ps=0 w=42 l=15
X432 vdd vdd vdd vdd sky130_fd_pr__pfet_01v8 ad=0 pd=0 as=0 ps=0 w=55 l=15
X433 vdd vdd vdd vdd sky130_fd_pr__pfet_01v8 ad=0 pd=0 as=0 ps=0 w=55 l=15
X434 bank_0/port_data_0/precharge_array_0/precharge_0_0/pmos_m1_w0_840_sli_dli_0/a_54_0# bank_0/p_en_bar0 bank_0/port_data_0/precharge_array_0/precharge_0_0/pmos_m1_w0_840_sli_dli_0/a_0_0# bank_0/port_data_0/precharge_array_0/precharge_0_2/w_0_0# sky130_fd_pr__pfet_01v8 ad=3.193n pd=0.245m as=3.699n ps=0.259m w=84 l=15
X435 bank_0/port_data_0/precharge_array_0/precharge_0_0/pmos_m1_w0_840_sli_dli_0/a_0_0# bank_0/p_en_bar0 bank_0/port_data_0/precharge_array_0/precharge_0_0/pmos_m1_w0_840_sli_dli_1/a_0_0# bank_0/port_data_0/precharge_array_0/precharge_0_2/w_0_0# sky130_fd_pr__pfet_01v8 ad=0 pd=0 as=3.277n ps=0.247m w=84 l=15
X436 bank_0/port_data_0/precharge_array_0/precharge_0_0/pmos_m1_w0_840_sli_dli_2/a_54_0# bank_0/p_en_bar0 bank_0/port_data_0/precharge_array_0/precharge_0_0/pmos_m1_w0_840_sli_dli_2/a_0_0# bank_0/port_data_0/precharge_array_0/precharge_0_2/w_0_0# sky130_fd_pr__pfet_01v8 ad=3.193n pd=0.245m as=3.277n ps=0.247m w=84 l=15
X437 bank_0/port_data_0/precharge_array_0/precharge_0_1/pmos_m1_w0_840_sli_dli_0/a_54_0# bank_0/p_en_bar0 bank_0/port_data_0/precharge_array_0/precharge_0_1/pmos_m1_w0_840_sli_dli_0/a_0_0# bank_0/port_data_0/precharge_array_0/precharge_0_2/w_0_0# sky130_fd_pr__pfet_01v8 ad=3.193n pd=0.245m as=3.699n ps=0.259m w=84 l=15
X438 bank_0/port_data_0/precharge_array_0/precharge_0_1/pmos_m1_w0_840_sli_dli_0/a_0_0# bank_0/p_en_bar0 bank_0/port_data_0/precharge_array_0/precharge_0_1/pmos_m1_w0_840_sli_dli_1/a_0_0# bank_0/port_data_0/precharge_array_0/precharge_0_2/w_0_0# sky130_fd_pr__pfet_01v8 ad=0 pd=0 as=3.277n ps=0.247m w=84 l=15
X439 bank_0/port_data_0/precharge_array_0/precharge_0_1/pmos_m1_w0_840_sli_dli_2/a_54_0# bank_0/p_en_bar0 bank_0/port_data_0/precharge_array_0/precharge_0_1/pmos_m1_w0_840_sli_dli_2/a_0_0# bank_0/port_data_0/precharge_array_0/precharge_0_2/w_0_0# sky130_fd_pr__pfet_01v8 ad=3.193n pd=0.245m as=3.277n ps=0.247m w=84 l=15
X440 bank_0/port_data_0/precharge_array_0/precharge_0_2/pmos_m1_w0_840_sli_dli_0/a_54_0# bank_0/p_en_bar0 bank_0/port_data_0/precharge_array_0/precharge_0_2/pmos_m1_w0_840_sli_dli_0/a_0_0# bank_0/port_data_0/precharge_array_0/precharge_0_2/w_0_0# sky130_fd_pr__pfet_01v8 ad=3.193n pd=0.245m as=3.699n ps=0.259m w=84 l=15
X441 bank_0/port_data_0/precharge_array_0/precharge_0_2/pmos_m1_w0_840_sli_dli_0/a_0_0# bank_0/p_en_bar0 bank_0/port_data_0/precharge_array_0/precharge_0_2/pmos_m1_w0_840_sli_dli_1/a_0_0# bank_0/port_data_0/precharge_array_0/precharge_0_2/w_0_0# sky130_fd_pr__pfet_01v8 ad=0 pd=0 as=3.277n ps=0.247m w=84 l=15
X442 bank_0/port_data_0/precharge_array_0/precharge_0_2/pmos_m1_w0_840_sli_dli_2/a_54_0# bank_0/p_en_bar0 bank_0/port_data_0/precharge_array_0/precharge_0_2/pmos_m1_w0_840_sli_dli_2/a_0_0# bank_0/port_data_0/precharge_array_0/precharge_0_2/w_0_0# sky130_fd_pr__pfet_01v8 ad=3.193n pd=0.245m as=3.277n ps=0.247m w=84 l=15
X443 bank_0/port_address_0/and2_dec_0_0/pinv_0/pmos_m1_w0_840_sli_dli_da_p_0/a_54_0# vdd bank_0/port_address_0/and2_dec_0_0/pinv_0/pmos_m1_w0_840_sli_dli_da_p_0/a_0_0# bank_0/port_address_0/and2_dec_0_0/pinv_0/w_n127_244# sky130_fd_pr__pfet_01v8 ad=3.193n pd=0.245m as=3.277n ps=0.247m w=84 l=15
X444 bank_0/port_address_0/and2_dec_0_0/pinv_0/nmos_m1_w0_420_sli_dli_da_p_0/a_54_0# vdd bank_0/port_address_0/and2_dec_0_0/pinv_0/nmos_m1_w0_420_sli_dli_da_p_0/a_0_0# vdd sky130_fd_pr__nfet_01v8 ad=1.597n pd=0.161m as=1.639n ps=0.163m w=42 l=15
X445 bank_0/port_address_0/and2_dec_0_0/pnand2_0/pmos_m1_w0_840_sli_dli_0/a_54_0# vdd bank_0/port_address_0/and2_dec_0_0/pnand2_0/pmos_m1_w0_840_sli_dli_0/a_0_0# bank_0/port_address_0/and2_dec_0_0/pinv_0/w_n127_244# sky130_fd_pr__pfet_01v8 ad=3.193n pd=0.245m as=3.699n ps=0.259m w=84 l=15
X446 bank_0/port_address_0/and2_dec_0_0/pnand2_0/pmos_m1_w0_840_sli_dli_0/a_0_0# bank_0/wl_en0 bank_0/port_address_0/and2_dec_0_0/pnand2_0/pmos_m1_w0_840_sli_dli_1/a_0_0# bank_0/port_address_0/and2_dec_0_0/pinv_0/w_n127_244# sky130_fd_pr__pfet_01v8 ad=0 pd=0 as=3.277n ps=0.247m w=84 l=15
X447 bank_0/port_address_0/and2_dec_0_0/pnand2_0/nmos_m1_w0_840_sli_dactive_0/D bank_0/wl_en0 bank_0/port_address_0/and2_dec_0_0/pnand2_0/nmos_m1_w0_840_sli_dactive_0/a_0_0# vdd sky130_fd_pr__nfet_01v8 ad=3.697n pd=0.257m as=3.277n ps=0.247m w=84 l=15
X448 bank_0/port_address_0/and2_dec_0_0/pnand2_0/nmos_m1_w0_840_sactive_dli_0/a_54_0# vdd bank_0/port_address_0/and2_dec_0_0/pnand2_0/nmos_m1_w0_840_sli_dactive_0/D vdd sky130_fd_pr__nfet_01v8 ad=3.193n pd=0.245m as=0 ps=0 w=84 l=15
X449 bank_0/port_address_0/hierarchical_decoder_0/and2_dec_0/pinv_0/pmos_m1_w0_840_sli_dli_da_p_0/a_54_0# vdd bank_0/port_address_0/hierarchical_decoder_0/and2_dec_0/pinv_0/pmos_m1_w0_840_sli_dli_da_p_0/a_0_0# bank_0/port_address_0/hierarchical_decoder_0/and2_dec_1/pinv_0/w_n127_244# sky130_fd_pr__pfet_01v8 ad=3.193n pd=0.245m as=3.277n ps=0.247m w=84 l=15
X450 bank_0/port_address_0/hierarchical_decoder_0/and2_dec_0/pinv_0/nmos_m1_w0_420_sli_dli_da_p_0/a_54_0# vdd bank_0/port_address_0/hierarchical_decoder_0/and2_dec_0/pinv_0/nmos_m1_w0_420_sli_dli_da_p_0/a_0_0# vdd sky130_fd_pr__nfet_01v8 ad=1.597n pd=0.161m as=1.639n ps=0.163m w=42 l=15
X451 bank_0/port_address_0/hierarchical_decoder_0/and2_dec_0/pnand2_0/pmos_m1_w0_840_sli_dli_0/a_54_0# bank_0/port_address_0/hierarchical_decoder_0/predecode_7 bank_0/port_address_0/hierarchical_decoder_0/and2_dec_0/pnand2_0/pmos_m1_w0_840_sli_dli_0/a_0_0# bank_0/port_address_0/hierarchical_decoder_0/and2_dec_1/pinv_0/w_n127_244# sky130_fd_pr__pfet_01v8 ad=3.193n pd=0.245m as=3.699n ps=0.259m w=84 l=15
X452 bank_0/port_address_0/hierarchical_decoder_0/and2_dec_0/pnand2_0/pmos_m1_w0_840_sli_dli_0/a_0_0# bank_0/port_address_0/hierarchical_decoder_0/predecode_3 bank_0/port_address_0/hierarchical_decoder_0/and2_dec_0/pnand2_0/pmos_m1_w0_840_sli_dli_1/a_0_0# bank_0/port_address_0/hierarchical_decoder_0/and2_dec_1/pinv_0/w_n127_244# sky130_fd_pr__pfet_01v8 ad=0 pd=0 as=3.277n ps=0.247m w=84 l=15
X453 bank_0/port_address_0/hierarchical_decoder_0/and2_dec_0/pnand2_0/nmos_m1_w0_840_sli_dactive_0/D bank_0/port_address_0/hierarchical_decoder_0/predecode_3 bank_0/port_address_0/hierarchical_decoder_0/and2_dec_0/pnand2_0/nmos_m1_w0_840_sli_dactive_0/a_0_0# vdd sky130_fd_pr__nfet_01v8 ad=3.697n pd=0.257m as=3.277n ps=0.247m w=84 l=15
X454 bank_0/port_address_0/hierarchical_decoder_0/and2_dec_0/pnand2_0/nmos_m1_w0_840_sactive_dli_0/a_54_0# bank_0/port_address_0/hierarchical_decoder_0/predecode_7 bank_0/port_address_0/hierarchical_decoder_0/and2_dec_0/pnand2_0/nmos_m1_w0_840_sli_dactive_0/D vdd sky130_fd_pr__nfet_01v8 ad=3.193n pd=0.245m as=0 ps=0 w=84 l=15
X455 bank_0/port_address_0/hierarchical_decoder_0/and2_dec_1/pinv_0/pmos_m1_w0_840_sli_dli_da_p_0/a_54_0# vdd bank_0/port_address_0/hierarchical_decoder_0/and2_dec_1/pinv_0/pmos_m1_w0_840_sli_dli_da_p_0/a_0_0# bank_0/port_address_0/hierarchical_decoder_0/and2_dec_1/pinv_0/w_n127_244# sky130_fd_pr__pfet_01v8 ad=3.193n pd=0.245m as=3.277n ps=0.247m w=84 l=15
X456 bank_0/port_address_0/hierarchical_decoder_0/and2_dec_1/pinv_0/nmos_m1_w0_420_sli_dli_da_p_0/a_54_0# vdd bank_0/port_address_0/hierarchical_decoder_0/and2_dec_1/pinv_0/nmos_m1_w0_420_sli_dli_da_p_0/a_0_0# vdd sky130_fd_pr__nfet_01v8 ad=1.597n pd=0.161m as=1.639n ps=0.163m w=42 l=15
X457 bank_0/port_address_0/hierarchical_decoder_0/and2_dec_1/pnand2_0/pmos_m1_w0_840_sli_dli_0/a_54_0# bank_0/port_address_0/hierarchical_decoder_0/predecode_7 bank_0/port_address_0/hierarchical_decoder_0/and2_dec_1/pnand2_0/pmos_m1_w0_840_sli_dli_0/a_0_0# bank_0/port_address_0/hierarchical_decoder_0/and2_dec_1/pinv_0/w_n127_244# sky130_fd_pr__pfet_01v8 ad=3.193n pd=0.245m as=3.699n ps=0.259m w=84 l=15
X458 bank_0/port_address_0/hierarchical_decoder_0/and2_dec_1/pnand2_0/pmos_m1_w0_840_sli_dli_0/a_0_0# bank_0/port_address_0/hierarchical_decoder_0/predecode_2 bank_0/port_address_0/hierarchical_decoder_0/and2_dec_1/pnand2_0/pmos_m1_w0_840_sli_dli_1/a_0_0# bank_0/port_address_0/hierarchical_decoder_0/and2_dec_1/pinv_0/w_n127_244# sky130_fd_pr__pfet_01v8 ad=0 pd=0 as=3.277n ps=0.247m w=84 l=15
X459 bank_0/port_address_0/hierarchical_decoder_0/and2_dec_1/pnand2_0/nmos_m1_w0_840_sli_dactive_0/D bank_0/port_address_0/hierarchical_decoder_0/predecode_2 bank_0/port_address_0/hierarchical_decoder_0/and2_dec_1/pnand2_0/nmos_m1_w0_840_sli_dactive_0/a_0_0# vdd sky130_fd_pr__nfet_01v8 ad=3.697n pd=0.257m as=3.277n ps=0.247m w=84 l=15
X460 bank_0/port_address_0/hierarchical_decoder_0/and2_dec_1/pnand2_0/nmos_m1_w0_840_sactive_dli_0/a_54_0# bank_0/port_address_0/hierarchical_decoder_0/predecode_7 bank_0/port_address_0/hierarchical_decoder_0/and2_dec_1/pnand2_0/nmos_m1_w0_840_sli_dactive_0/D vdd sky130_fd_pr__nfet_01v8 ad=3.193n pd=0.245m as=0 ps=0 w=84 l=15
X461 bank_0/port_address_0/hierarchical_decoder_0/and2_dec_2/pinv_0/pmos_m1_w0_840_sli_dli_da_p_0/a_54_0# vdd bank_0/port_address_0/hierarchical_decoder_0/and2_dec_2/pinv_0/pmos_m1_w0_840_sli_dli_da_p_0/a_0_0# bank_0/port_address_0/hierarchical_decoder_0/and2_dec_3/pinv_0/w_n127_244# sky130_fd_pr__pfet_01v8 ad=3.193n pd=0.245m as=3.277n ps=0.247m w=84 l=15
X462 bank_0/port_address_0/hierarchical_decoder_0/and2_dec_2/pinv_0/nmos_m1_w0_420_sli_dli_da_p_0/a_54_0# vdd bank_0/port_address_0/hierarchical_decoder_0/and2_dec_2/pinv_0/nmos_m1_w0_420_sli_dli_da_p_0/a_0_0# vdd sky130_fd_pr__nfet_01v8 ad=1.597n pd=0.161m as=1.639n ps=0.163m w=42 l=15
X463 bank_0/port_address_0/hierarchical_decoder_0/and2_dec_2/pnand2_0/pmos_m1_w0_840_sli_dli_0/a_54_0# bank_0/port_address_0/hierarchical_decoder_0/predecode_7 bank_0/port_address_0/hierarchical_decoder_0/and2_dec_2/pnand2_0/pmos_m1_w0_840_sli_dli_0/a_0_0# bank_0/port_address_0/hierarchical_decoder_0/and2_dec_3/pinv_0/w_n127_244# sky130_fd_pr__pfet_01v8 ad=3.193n pd=0.245m as=3.699n ps=0.259m w=84 l=15
X464 bank_0/port_address_0/hierarchical_decoder_0/and2_dec_2/pnand2_0/pmos_m1_w0_840_sli_dli_0/a_0_0# bank_0/port_address_0/hierarchical_decoder_0/predecode_1 bank_0/port_address_0/hierarchical_decoder_0/and2_dec_2/pnand2_0/pmos_m1_w0_840_sli_dli_1/a_0_0# bank_0/port_address_0/hierarchical_decoder_0/and2_dec_3/pinv_0/w_n127_244# sky130_fd_pr__pfet_01v8 ad=0 pd=0 as=3.277n ps=0.247m w=84 l=15
X465 bank_0/port_address_0/hierarchical_decoder_0/and2_dec_2/pnand2_0/nmos_m1_w0_840_sli_dactive_0/D bank_0/port_address_0/hierarchical_decoder_0/predecode_1 bank_0/port_address_0/hierarchical_decoder_0/and2_dec_2/pnand2_0/nmos_m1_w0_840_sli_dactive_0/a_0_0# vdd sky130_fd_pr__nfet_01v8 ad=3.697n pd=0.257m as=3.277n ps=0.247m w=84 l=15
X466 bank_0/port_address_0/hierarchical_decoder_0/and2_dec_2/pnand2_0/nmos_m1_w0_840_sactive_dli_0/a_54_0# bank_0/port_address_0/hierarchical_decoder_0/predecode_7 bank_0/port_address_0/hierarchical_decoder_0/and2_dec_2/pnand2_0/nmos_m1_w0_840_sli_dactive_0/D vdd sky130_fd_pr__nfet_01v8 ad=3.193n pd=0.245m as=0 ps=0 w=84 l=15
X467 bank_0/port_address_0/hierarchical_decoder_0/and2_dec_3/pinv_0/pmos_m1_w0_840_sli_dli_da_p_0/a_54_0# vdd bank_0/port_address_0/hierarchical_decoder_0/and2_dec_3/pinv_0/pmos_m1_w0_840_sli_dli_da_p_0/a_0_0# bank_0/port_address_0/hierarchical_decoder_0/and2_dec_3/pinv_0/w_n127_244# sky130_fd_pr__pfet_01v8 ad=3.193n pd=0.245m as=3.277n ps=0.247m w=84 l=15
X468 bank_0/port_address_0/hierarchical_decoder_0/and2_dec_3/pinv_0/nmos_m1_w0_420_sli_dli_da_p_0/a_54_0# vdd bank_0/port_address_0/hierarchical_decoder_0/and2_dec_3/pinv_0/nmos_m1_w0_420_sli_dli_da_p_0/a_0_0# vdd sky130_fd_pr__nfet_01v8 ad=1.597n pd=0.161m as=1.639n ps=0.163m w=42 l=15
X469 bank_0/port_address_0/hierarchical_decoder_0/and2_dec_3/pnand2_0/pmos_m1_w0_840_sli_dli_0/a_54_0# bank_0/port_address_0/hierarchical_decoder_0/predecode_7 bank_0/port_address_0/hierarchical_decoder_0/and2_dec_3/pnand2_0/pmos_m1_w0_840_sli_dli_0/a_0_0# bank_0/port_address_0/hierarchical_decoder_0/and2_dec_3/pinv_0/w_n127_244# sky130_fd_pr__pfet_01v8 ad=3.193n pd=0.245m as=3.699n ps=0.259m w=84 l=15
X470 bank_0/port_address_0/hierarchical_decoder_0/and2_dec_3/pnand2_0/pmos_m1_w0_840_sli_dli_0/a_0_0# bank_0/port_address_0/hierarchical_decoder_0/predecode_0 bank_0/port_address_0/hierarchical_decoder_0/and2_dec_3/pnand2_0/pmos_m1_w0_840_sli_dli_1/a_0_0# bank_0/port_address_0/hierarchical_decoder_0/and2_dec_3/pinv_0/w_n127_244# sky130_fd_pr__pfet_01v8 ad=0 pd=0 as=3.277n ps=0.247m w=84 l=15
X471 bank_0/port_address_0/hierarchical_decoder_0/and2_dec_3/pnand2_0/nmos_m1_w0_840_sli_dactive_0/D bank_0/port_address_0/hierarchical_decoder_0/predecode_0 bank_0/port_address_0/hierarchical_decoder_0/and2_dec_3/pnand2_0/nmos_m1_w0_840_sli_dactive_0/a_0_0# vdd sky130_fd_pr__nfet_01v8 ad=3.697n pd=0.257m as=3.277n ps=0.247m w=84 l=15
X472 bank_0/port_address_0/hierarchical_decoder_0/and2_dec_3/pnand2_0/nmos_m1_w0_840_sactive_dli_0/a_54_0# bank_0/port_address_0/hierarchical_decoder_0/predecode_7 bank_0/port_address_0/hierarchical_decoder_0/and2_dec_3/pnand2_0/nmos_m1_w0_840_sli_dactive_0/D vdd sky130_fd_pr__nfet_01v8 ad=3.193n pd=0.245m as=0 ps=0 w=84 l=15
X473 bank_0/port_address_0/hierarchical_decoder_0/and2_dec_4/pinv_0/pmos_m1_w0_840_sli_dli_da_p_0/a_54_0# vdd bank_0/port_address_0/hierarchical_decoder_0/and2_dec_4/pinv_0/pmos_m1_w0_840_sli_dli_da_p_0/a_0_0# bank_0/port_address_0/hierarchical_decoder_0/and2_dec_5/pinv_0/w_n127_244# sky130_fd_pr__pfet_01v8 ad=3.193n pd=0.245m as=3.277n ps=0.247m w=84 l=15
X474 bank_0/port_address_0/hierarchical_decoder_0/and2_dec_4/pinv_0/nmos_m1_w0_420_sli_dli_da_p_0/a_54_0# vdd bank_0/port_address_0/hierarchical_decoder_0/and2_dec_4/pinv_0/nmos_m1_w0_420_sli_dli_da_p_0/a_0_0# vdd sky130_fd_pr__nfet_01v8 ad=1.597n pd=0.161m as=1.639n ps=0.163m w=42 l=15
X475 bank_0/port_address_0/hierarchical_decoder_0/and2_dec_4/pnand2_0/pmos_m1_w0_840_sli_dli_0/a_54_0# bank_0/port_address_0/hierarchical_decoder_0/predecode_6 bank_0/port_address_0/hierarchical_decoder_0/and2_dec_4/pnand2_0/pmos_m1_w0_840_sli_dli_0/a_0_0# bank_0/port_address_0/hierarchical_decoder_0/and2_dec_5/pinv_0/w_n127_244# sky130_fd_pr__pfet_01v8 ad=3.193n pd=0.245m as=3.699n ps=0.259m w=84 l=15
X476 bank_0/port_address_0/hierarchical_decoder_0/and2_dec_4/pnand2_0/pmos_m1_w0_840_sli_dli_0/a_0_0# bank_0/port_address_0/hierarchical_decoder_0/predecode_3 bank_0/port_address_0/hierarchical_decoder_0/and2_dec_4/pnand2_0/pmos_m1_w0_840_sli_dli_1/a_0_0# bank_0/port_address_0/hierarchical_decoder_0/and2_dec_5/pinv_0/w_n127_244# sky130_fd_pr__pfet_01v8 ad=0 pd=0 as=3.277n ps=0.247m w=84 l=15
X477 bank_0/port_address_0/hierarchical_decoder_0/and2_dec_4/pnand2_0/nmos_m1_w0_840_sli_dactive_0/D bank_0/port_address_0/hierarchical_decoder_0/predecode_3 bank_0/port_address_0/hierarchical_decoder_0/and2_dec_4/pnand2_0/nmos_m1_w0_840_sli_dactive_0/a_0_0# vdd sky130_fd_pr__nfet_01v8 ad=3.697n pd=0.257m as=3.277n ps=0.247m w=84 l=15
X478 bank_0/port_address_0/hierarchical_decoder_0/and2_dec_4/pnand2_0/nmos_m1_w0_840_sactive_dli_0/a_54_0# bank_0/port_address_0/hierarchical_decoder_0/predecode_6 bank_0/port_address_0/hierarchical_decoder_0/and2_dec_4/pnand2_0/nmos_m1_w0_840_sli_dactive_0/D vdd sky130_fd_pr__nfet_01v8 ad=3.193n pd=0.245m as=0 ps=0 w=84 l=15
X479 bank_0/port_address_0/hierarchical_decoder_0/and2_dec_5/pinv_0/pmos_m1_w0_840_sli_dli_da_p_0/a_54_0# vdd bank_0/port_address_0/hierarchical_decoder_0/and2_dec_5/pinv_0/pmos_m1_w0_840_sli_dli_da_p_0/a_0_0# bank_0/port_address_0/hierarchical_decoder_0/and2_dec_5/pinv_0/w_n127_244# sky130_fd_pr__pfet_01v8 ad=3.193n pd=0.245m as=3.277n ps=0.247m w=84 l=15
X480 bank_0/port_address_0/hierarchical_decoder_0/and2_dec_5/pinv_0/nmos_m1_w0_420_sli_dli_da_p_0/a_54_0# vdd bank_0/port_address_0/hierarchical_decoder_0/and2_dec_5/pinv_0/nmos_m1_w0_420_sli_dli_da_p_0/a_0_0# vdd sky130_fd_pr__nfet_01v8 ad=1.597n pd=0.161m as=1.639n ps=0.163m w=42 l=15
X481 bank_0/port_address_0/hierarchical_decoder_0/and2_dec_5/pnand2_0/pmos_m1_w0_840_sli_dli_0/a_54_0# bank_0/port_address_0/hierarchical_decoder_0/predecode_6 bank_0/port_address_0/hierarchical_decoder_0/and2_dec_5/pnand2_0/pmos_m1_w0_840_sli_dli_0/a_0_0# bank_0/port_address_0/hierarchical_decoder_0/and2_dec_5/pinv_0/w_n127_244# sky130_fd_pr__pfet_01v8 ad=3.193n pd=0.245m as=3.699n ps=0.259m w=84 l=15
X482 bank_0/port_address_0/hierarchical_decoder_0/and2_dec_5/pnand2_0/pmos_m1_w0_840_sli_dli_0/a_0_0# bank_0/port_address_0/hierarchical_decoder_0/predecode_2 bank_0/port_address_0/hierarchical_decoder_0/and2_dec_5/pnand2_0/pmos_m1_w0_840_sli_dli_1/a_0_0# bank_0/port_address_0/hierarchical_decoder_0/and2_dec_5/pinv_0/w_n127_244# sky130_fd_pr__pfet_01v8 ad=0 pd=0 as=3.277n ps=0.247m w=84 l=15
X483 bank_0/port_address_0/hierarchical_decoder_0/and2_dec_5/pnand2_0/nmos_m1_w0_840_sli_dactive_0/D bank_0/port_address_0/hierarchical_decoder_0/predecode_2 bank_0/port_address_0/hierarchical_decoder_0/and2_dec_5/pnand2_0/nmos_m1_w0_840_sli_dactive_0/a_0_0# vdd sky130_fd_pr__nfet_01v8 ad=3.697n pd=0.257m as=3.277n ps=0.247m w=84 l=15
X484 bank_0/port_address_0/hierarchical_decoder_0/and2_dec_5/pnand2_0/nmos_m1_w0_840_sactive_dli_0/a_54_0# bank_0/port_address_0/hierarchical_decoder_0/predecode_6 bank_0/port_address_0/hierarchical_decoder_0/and2_dec_5/pnand2_0/nmos_m1_w0_840_sli_dactive_0/D vdd sky130_fd_pr__nfet_01v8 ad=3.193n pd=0.245m as=0 ps=0 w=84 l=15
X485 bank_0/port_address_0/hierarchical_decoder_0/and2_dec_6/pinv_0/pmos_m1_w0_840_sli_dli_da_p_0/a_54_0# vdd bank_0/port_address_0/hierarchical_decoder_0/and2_dec_6/pinv_0/pmos_m1_w0_840_sli_dli_da_p_0/a_0_0# bank_0/port_address_0/hierarchical_decoder_0/and2_dec_7/pinv_0/w_n127_244# sky130_fd_pr__pfet_01v8 ad=3.193n pd=0.245m as=3.277n ps=0.247m w=84 l=15
X486 bank_0/port_address_0/hierarchical_decoder_0/and2_dec_6/pinv_0/nmos_m1_w0_420_sli_dli_da_p_0/a_54_0# vdd bank_0/port_address_0/hierarchical_decoder_0/and2_dec_6/pinv_0/nmos_m1_w0_420_sli_dli_da_p_0/a_0_0# vdd sky130_fd_pr__nfet_01v8 ad=1.597n pd=0.161m as=1.639n ps=0.163m w=42 l=15
X487 bank_0/port_address_0/hierarchical_decoder_0/and2_dec_6/pnand2_0/pmos_m1_w0_840_sli_dli_0/a_54_0# bank_0/port_address_0/hierarchical_decoder_0/predecode_6 bank_0/port_address_0/hierarchical_decoder_0/and2_dec_6/pnand2_0/pmos_m1_w0_840_sli_dli_0/a_0_0# bank_0/port_address_0/hierarchical_decoder_0/and2_dec_7/pinv_0/w_n127_244# sky130_fd_pr__pfet_01v8 ad=3.193n pd=0.245m as=3.699n ps=0.259m w=84 l=15
X488 bank_0/port_address_0/hierarchical_decoder_0/and2_dec_6/pnand2_0/pmos_m1_w0_840_sli_dli_0/a_0_0# bank_0/port_address_0/hierarchical_decoder_0/predecode_1 bank_0/port_address_0/hierarchical_decoder_0/and2_dec_6/pnand2_0/pmos_m1_w0_840_sli_dli_1/a_0_0# bank_0/port_address_0/hierarchical_decoder_0/and2_dec_7/pinv_0/w_n127_244# sky130_fd_pr__pfet_01v8 ad=0 pd=0 as=3.277n ps=0.247m w=84 l=15
X489 bank_0/port_address_0/hierarchical_decoder_0/and2_dec_6/pnand2_0/nmos_m1_w0_840_sli_dactive_0/D bank_0/port_address_0/hierarchical_decoder_0/predecode_1 bank_0/port_address_0/hierarchical_decoder_0/and2_dec_6/pnand2_0/nmos_m1_w0_840_sli_dactive_0/a_0_0# vdd sky130_fd_pr__nfet_01v8 ad=3.697n pd=0.257m as=3.277n ps=0.247m w=84 l=15
X490 bank_0/port_address_0/hierarchical_decoder_0/and2_dec_6/pnand2_0/nmos_m1_w0_840_sactive_dli_0/a_54_0# bank_0/port_address_0/hierarchical_decoder_0/predecode_6 bank_0/port_address_0/hierarchical_decoder_0/and2_dec_6/pnand2_0/nmos_m1_w0_840_sli_dactive_0/D vdd sky130_fd_pr__nfet_01v8 ad=3.193n pd=0.245m as=0 ps=0 w=84 l=15
X491 bank_0/port_address_0/hierarchical_decoder_0/and2_dec_7/pinv_0/pmos_m1_w0_840_sli_dli_da_p_0/a_54_0# vdd bank_0/port_address_0/hierarchical_decoder_0/and2_dec_7/pinv_0/pmos_m1_w0_840_sli_dli_da_p_0/a_0_0# bank_0/port_address_0/hierarchical_decoder_0/and2_dec_7/pinv_0/w_n127_244# sky130_fd_pr__pfet_01v8 ad=3.193n pd=0.245m as=3.277n ps=0.247m w=84 l=15
X492 bank_0/port_address_0/hierarchical_decoder_0/and2_dec_7/pinv_0/nmos_m1_w0_420_sli_dli_da_p_0/a_54_0# vdd bank_0/port_address_0/hierarchical_decoder_0/and2_dec_7/pinv_0/nmos_m1_w0_420_sli_dli_da_p_0/a_0_0# vdd sky130_fd_pr__nfet_01v8 ad=1.597n pd=0.161m as=1.639n ps=0.163m w=42 l=15
X493 bank_0/port_address_0/hierarchical_decoder_0/and2_dec_7/pnand2_0/pmos_m1_w0_840_sli_dli_0/a_54_0# bank_0/port_address_0/hierarchical_decoder_0/predecode_6 bank_0/port_address_0/hierarchical_decoder_0/and2_dec_7/pnand2_0/pmos_m1_w0_840_sli_dli_0/a_0_0# bank_0/port_address_0/hierarchical_decoder_0/and2_dec_7/pinv_0/w_n127_244# sky130_fd_pr__pfet_01v8 ad=3.193n pd=0.245m as=3.699n ps=0.259m w=84 l=15
X494 bank_0/port_address_0/hierarchical_decoder_0/and2_dec_7/pnand2_0/pmos_m1_w0_840_sli_dli_0/a_0_0# bank_0/port_address_0/hierarchical_decoder_0/predecode_0 bank_0/port_address_0/hierarchical_decoder_0/and2_dec_7/pnand2_0/pmos_m1_w0_840_sli_dli_1/a_0_0# bank_0/port_address_0/hierarchical_decoder_0/and2_dec_7/pinv_0/w_n127_244# sky130_fd_pr__pfet_01v8 ad=0 pd=0 as=3.277n ps=0.247m w=84 l=15
X495 bank_0/port_address_0/hierarchical_decoder_0/and2_dec_7/pnand2_0/nmos_m1_w0_840_sli_dactive_0/D bank_0/port_address_0/hierarchical_decoder_0/predecode_0 bank_0/port_address_0/hierarchical_decoder_0/and2_dec_7/pnand2_0/nmos_m1_w0_840_sli_dactive_0/a_0_0# vdd sky130_fd_pr__nfet_01v8 ad=3.697n pd=0.257m as=3.277n ps=0.247m w=84 l=15
X496 bank_0/port_address_0/hierarchical_decoder_0/and2_dec_7/pnand2_0/nmos_m1_w0_840_sactive_dli_0/a_54_0# bank_0/port_address_0/hierarchical_decoder_0/predecode_6 bank_0/port_address_0/hierarchical_decoder_0/and2_dec_7/pnand2_0/nmos_m1_w0_840_sli_dactive_0/D vdd sky130_fd_pr__nfet_01v8 ad=3.193n pd=0.245m as=0 ps=0 w=84 l=15
X497 bank_0/port_address_0/hierarchical_decoder_0/hierarchical_predecode2x4_0/and2_dec_0/pinv_0/pmos_m1_w0_840_sli_dli_da_p_0/a_54_0# vdd bank_0/port_address_0/hierarchical_decoder_0/hierarchical_predecode2x4_0/and2_dec_0/pinv_0/pmos_m1_w0_840_sli_dli_da_p_0/a_0_0# bank_0/port_address_0/hierarchical_decoder_0/hierarchical_predecode2x4_0/and2_dec_1/pinv_0/w_n127_244# sky130_fd_pr__pfet_01v8 ad=3.193n pd=0.245m as=3.277n ps=0.247m w=84 l=15
X498 bank_0/port_address_0/hierarchical_decoder_0/hierarchical_predecode2x4_0/and2_dec_0/pinv_0/nmos_m1_w0_420_sli_dli_da_p_0/a_54_0# vdd bank_0/port_address_0/hierarchical_decoder_0/hierarchical_predecode2x4_0/and2_dec_0/pinv_0/nmos_m1_w0_420_sli_dli_da_p_0/a_0_0# vdd sky130_fd_pr__nfet_01v8 ad=1.597n pd=0.161m as=1.639n ps=0.163m w=42 l=15
X499 bank_0/port_address_0/hierarchical_decoder_0/hierarchical_predecode2x4_0/and2_dec_0/pnand2_0/pmos_m1_w0_840_sli_dli_0/a_54_0# bank_0/addr0_3 bank_0/port_address_0/hierarchical_decoder_0/hierarchical_predecode2x4_0/and2_dec_0/pnand2_0/pmos_m1_w0_840_sli_dli_0/a_0_0# bank_0/port_address_0/hierarchical_decoder_0/hierarchical_predecode2x4_0/and2_dec_1/pinv_0/w_n127_244# sky130_fd_pr__pfet_01v8 ad=3.193n pd=0.245m as=3.699n ps=0.259m w=84 l=15
X500 bank_0/port_address_0/hierarchical_decoder_0/hierarchical_predecode2x4_0/and2_dec_0/pnand2_0/pmos_m1_w0_840_sli_dli_0/a_0_0# bank_0/addr0_2 bank_0/port_address_0/hierarchical_decoder_0/hierarchical_predecode2x4_0/and2_dec_0/pnand2_0/pmos_m1_w0_840_sli_dli_1/a_0_0# bank_0/port_address_0/hierarchical_decoder_0/hierarchical_predecode2x4_0/and2_dec_1/pinv_0/w_n127_244# sky130_fd_pr__pfet_01v8 ad=0 pd=0 as=3.277n ps=0.247m w=84 l=15
X501 bank_0/port_address_0/hierarchical_decoder_0/hierarchical_predecode2x4_0/and2_dec_0/pnand2_0/nmos_m1_w0_840_sli_dactive_0/D bank_0/addr0_2 bank_0/port_address_0/hierarchical_decoder_0/hierarchical_predecode2x4_0/and2_dec_0/pnand2_0/nmos_m1_w0_840_sli_dactive_0/a_0_0# vdd sky130_fd_pr__nfet_01v8 ad=3.697n pd=0.257m as=3.277n ps=0.247m w=84 l=15
X502 bank_0/port_address_0/hierarchical_decoder_0/hierarchical_predecode2x4_0/and2_dec_0/pnand2_0/nmos_m1_w0_840_sactive_dli_0/a_54_0# bank_0/addr0_3 bank_0/port_address_0/hierarchical_decoder_0/hierarchical_predecode2x4_0/and2_dec_0/pnand2_0/nmos_m1_w0_840_sli_dactive_0/D vdd sky130_fd_pr__nfet_01v8 ad=3.193n pd=0.245m as=0 ps=0 w=84 l=15
X503 bank_0/port_address_0/hierarchical_decoder_0/hierarchical_predecode2x4_0/and2_dec_1/pinv_0/pmos_m1_w0_840_sli_dli_da_p_0/a_54_0# vdd bank_0/port_address_0/hierarchical_decoder_0/hierarchical_predecode2x4_0/and2_dec_1/pinv_0/pmos_m1_w0_840_sli_dli_da_p_0/a_0_0# bank_0/port_address_0/hierarchical_decoder_0/hierarchical_predecode2x4_0/and2_dec_1/pinv_0/w_n127_244# sky130_fd_pr__pfet_01v8 ad=3.193n pd=0.245m as=3.277n ps=0.247m w=84 l=15
X504 bank_0/port_address_0/hierarchical_decoder_0/hierarchical_predecode2x4_0/and2_dec_1/pinv_0/nmos_m1_w0_420_sli_dli_da_p_0/a_54_0# vdd bank_0/port_address_0/hierarchical_decoder_0/hierarchical_predecode2x4_0/and2_dec_1/pinv_0/nmos_m1_w0_420_sli_dli_da_p_0/a_0_0# vdd sky130_fd_pr__nfet_01v8 ad=1.597n pd=0.161m as=1.639n ps=0.163m w=42 l=15
X505 bank_0/port_address_0/hierarchical_decoder_0/hierarchical_predecode2x4_0/and2_dec_1/pnand2_0/pmos_m1_w0_840_sli_dli_0/a_54_0# bank_0/addr0_3 bank_0/port_address_0/hierarchical_decoder_0/hierarchical_predecode2x4_0/and2_dec_1/pnand2_0/pmos_m1_w0_840_sli_dli_0/a_0_0# bank_0/port_address_0/hierarchical_decoder_0/hierarchical_predecode2x4_0/and2_dec_1/pinv_0/w_n127_244# sky130_fd_pr__pfet_01v8 ad=3.193n pd=0.245m as=3.699n ps=0.259m w=84 l=15
X506 bank_0/port_address_0/hierarchical_decoder_0/hierarchical_predecode2x4_0/and2_dec_1/pnand2_0/pmos_m1_w0_840_sli_dli_0/a_0_0# bank_0/port_address_0/hierarchical_decoder_0/hierarchical_predecode2x4_0/pinv_1/Z bank_0/port_address_0/hierarchical_decoder_0/hierarchical_predecode2x4_0/and2_dec_1/pnand2_0/pmos_m1_w0_840_sli_dli_1/a_0_0# bank_0/port_address_0/hierarchical_decoder_0/hierarchical_predecode2x4_0/and2_dec_1/pinv_0/w_n127_244# sky130_fd_pr__pfet_01v8 ad=0 pd=0 as=3.277n ps=0.247m w=84 l=15
X507 bank_0/port_address_0/hierarchical_decoder_0/hierarchical_predecode2x4_0/and2_dec_1/pnand2_0/nmos_m1_w0_840_sli_dactive_0/D bank_0/port_address_0/hierarchical_decoder_0/hierarchical_predecode2x4_0/pinv_1/Z bank_0/port_address_0/hierarchical_decoder_0/hierarchical_predecode2x4_0/and2_dec_1/pnand2_0/nmos_m1_w0_840_sli_dactive_0/a_0_0# vdd sky130_fd_pr__nfet_01v8 ad=3.697n pd=0.257m as=3.277n ps=0.247m w=84 l=15
X508 bank_0/port_address_0/hierarchical_decoder_0/hierarchical_predecode2x4_0/and2_dec_1/pnand2_0/nmos_m1_w0_840_sactive_dli_0/a_54_0# bank_0/addr0_3 bank_0/port_address_0/hierarchical_decoder_0/hierarchical_predecode2x4_0/and2_dec_1/pnand2_0/nmos_m1_w0_840_sli_dactive_0/D vdd sky130_fd_pr__nfet_01v8 ad=3.193n pd=0.245m as=0 ps=0 w=84 l=15
X509 bank_0/port_address_0/hierarchical_decoder_0/hierarchical_predecode2x4_0/pinv_0/pmos_m1_w0_840_sli_dli_da_p_0/a_54_0# bank_0/addr0_3 bank_0/port_address_0/hierarchical_decoder_0/hierarchical_predecode2x4_0/pinv_0/pmos_m1_w0_840_sli_dli_da_p_0/a_0_0# bank_0/port_address_0/hierarchical_decoder_0/hierarchical_predecode2x4_0/pinv_1/w_n127_244# sky130_fd_pr__pfet_01v8 ad=3.193n pd=0.245m as=3.277n ps=0.247m w=84 l=15
X510 bank_0/port_address_0/hierarchical_decoder_0/hierarchical_predecode2x4_0/pinv_0/nmos_m1_w0_420_sli_dli_da_p_0/a_54_0# bank_0/addr0_3 bank_0/port_address_0/hierarchical_decoder_0/hierarchical_predecode2x4_0/pinv_0/nmos_m1_w0_420_sli_dli_da_p_0/a_0_0# vdd sky130_fd_pr__nfet_01v8 ad=1.597n pd=0.161m as=1.639n ps=0.163m w=42 l=15
X511 bank_0/port_address_0/hierarchical_decoder_0/hierarchical_predecode2x4_0/and2_dec_2/pinv_0/pmos_m1_w0_840_sli_dli_da_p_0/a_54_0# vdd bank_0/port_address_0/hierarchical_decoder_0/hierarchical_predecode2x4_0/and2_dec_2/pinv_0/pmos_m1_w0_840_sli_dli_da_p_0/a_0_0# bank_0/port_address_0/hierarchical_decoder_0/hierarchical_predecode2x4_0/and2_dec_3/pinv_0/w_n127_244# sky130_fd_pr__pfet_01v8 ad=3.193n pd=0.245m as=3.277n ps=0.247m w=84 l=15
X512 bank_0/port_address_0/hierarchical_decoder_0/hierarchical_predecode2x4_0/and2_dec_2/pinv_0/nmos_m1_w0_420_sli_dli_da_p_0/a_54_0# vdd bank_0/port_address_0/hierarchical_decoder_0/hierarchical_predecode2x4_0/and2_dec_2/pinv_0/nmos_m1_w0_420_sli_dli_da_p_0/a_0_0# vdd sky130_fd_pr__nfet_01v8 ad=1.597n pd=0.161m as=1.639n ps=0.163m w=42 l=15
X513 bank_0/port_address_0/hierarchical_decoder_0/hierarchical_predecode2x4_0/and2_dec_2/pnand2_0/pmos_m1_w0_840_sli_dli_0/a_54_0# bank_0/port_address_0/hierarchical_decoder_0/hierarchical_predecode2x4_0/pinv_0/Z bank_0/port_address_0/hierarchical_decoder_0/hierarchical_predecode2x4_0/and2_dec_2/pnand2_0/pmos_m1_w0_840_sli_dli_0/a_0_0# bank_0/port_address_0/hierarchical_decoder_0/hierarchical_predecode2x4_0/and2_dec_3/pinv_0/w_n127_244# sky130_fd_pr__pfet_01v8 ad=3.193n pd=0.245m as=3.699n ps=0.259m w=84 l=15
X514 bank_0/port_address_0/hierarchical_decoder_0/hierarchical_predecode2x4_0/and2_dec_2/pnand2_0/pmos_m1_w0_840_sli_dli_0/a_0_0# bank_0/addr0_2 bank_0/port_address_0/hierarchical_decoder_0/hierarchical_predecode2x4_0/and2_dec_2/pnand2_0/pmos_m1_w0_840_sli_dli_1/a_0_0# bank_0/port_address_0/hierarchical_decoder_0/hierarchical_predecode2x4_0/and2_dec_3/pinv_0/w_n127_244# sky130_fd_pr__pfet_01v8 ad=0 pd=0 as=3.277n ps=0.247m w=84 l=15
X515 bank_0/port_address_0/hierarchical_decoder_0/hierarchical_predecode2x4_0/and2_dec_2/pnand2_0/nmos_m1_w0_840_sli_dactive_0/D bank_0/addr0_2 bank_0/port_address_0/hierarchical_decoder_0/hierarchical_predecode2x4_0/and2_dec_2/pnand2_0/nmos_m1_w0_840_sli_dactive_0/a_0_0# vdd sky130_fd_pr__nfet_01v8 ad=3.697n pd=0.257m as=3.277n ps=0.247m w=84 l=15
X516 bank_0/port_address_0/hierarchical_decoder_0/hierarchical_predecode2x4_0/and2_dec_2/pnand2_0/nmos_m1_w0_840_sactive_dli_0/a_54_0# bank_0/port_address_0/hierarchical_decoder_0/hierarchical_predecode2x4_0/pinv_0/Z bank_0/port_address_0/hierarchical_decoder_0/hierarchical_predecode2x4_0/and2_dec_2/pnand2_0/nmos_m1_w0_840_sli_dactive_0/D vdd sky130_fd_pr__nfet_01v8 ad=3.193n pd=0.245m as=0 ps=0 w=84 l=15
X517 bank_0/port_address_0/hierarchical_decoder_0/hierarchical_predecode2x4_0/pinv_1/pmos_m1_w0_840_sli_dli_da_p_0/a_54_0# bank_0/addr0_2 bank_0/port_address_0/hierarchical_decoder_0/hierarchical_predecode2x4_0/pinv_1/pmos_m1_w0_840_sli_dli_da_p_0/a_0_0# bank_0/port_address_0/hierarchical_decoder_0/hierarchical_predecode2x4_0/pinv_1/w_n127_244# sky130_fd_pr__pfet_01v8 ad=3.193n pd=0.245m as=3.277n ps=0.247m w=84 l=15
X518 bank_0/port_address_0/hierarchical_decoder_0/hierarchical_predecode2x4_0/pinv_1/nmos_m1_w0_420_sli_dli_da_p_0/a_54_0# bank_0/addr0_2 bank_0/port_address_0/hierarchical_decoder_0/hierarchical_predecode2x4_0/pinv_1/nmos_m1_w0_420_sli_dli_da_p_0/a_0_0# vdd sky130_fd_pr__nfet_01v8 ad=1.597n pd=0.161m as=1.639n ps=0.163m w=42 l=15
X519 bank_0/port_address_0/hierarchical_decoder_0/hierarchical_predecode2x4_0/and2_dec_3/pinv_0/pmos_m1_w0_840_sli_dli_da_p_0/a_54_0# vdd bank_0/port_address_0/hierarchical_decoder_0/hierarchical_predecode2x4_0/and2_dec_3/pinv_0/pmos_m1_w0_840_sli_dli_da_p_0/a_0_0# bank_0/port_address_0/hierarchical_decoder_0/hierarchical_predecode2x4_0/and2_dec_3/pinv_0/w_n127_244# sky130_fd_pr__pfet_01v8 ad=3.193n pd=0.245m as=3.277n ps=0.247m w=84 l=15
X520 bank_0/port_address_0/hierarchical_decoder_0/hierarchical_predecode2x4_0/and2_dec_3/pinv_0/nmos_m1_w0_420_sli_dli_da_p_0/a_54_0# vdd bank_0/port_address_0/hierarchical_decoder_0/hierarchical_predecode2x4_0/and2_dec_3/pinv_0/nmos_m1_w0_420_sli_dli_da_p_0/a_0_0# vdd sky130_fd_pr__nfet_01v8 ad=1.597n pd=0.161m as=1.639n ps=0.163m w=42 l=15
X521 bank_0/port_address_0/hierarchical_decoder_0/hierarchical_predecode2x4_0/and2_dec_3/pnand2_0/pmos_m1_w0_840_sli_dli_0/a_54_0# bank_0/port_address_0/hierarchical_decoder_0/hierarchical_predecode2x4_0/pinv_0/Z bank_0/port_address_0/hierarchical_decoder_0/hierarchical_predecode2x4_0/and2_dec_3/pnand2_0/pmos_m1_w0_840_sli_dli_0/a_0_0# bank_0/port_address_0/hierarchical_decoder_0/hierarchical_predecode2x4_0/and2_dec_3/pinv_0/w_n127_244# sky130_fd_pr__pfet_01v8 ad=3.193n pd=0.245m as=3.699n ps=0.259m w=84 l=15
X522 bank_0/port_address_0/hierarchical_decoder_0/hierarchical_predecode2x4_0/and2_dec_3/pnand2_0/pmos_m1_w0_840_sli_dli_0/a_0_0# bank_0/port_address_0/hierarchical_decoder_0/hierarchical_predecode2x4_0/pinv_1/Z bank_0/port_address_0/hierarchical_decoder_0/hierarchical_predecode2x4_0/and2_dec_3/pnand2_0/pmos_m1_w0_840_sli_dli_1/a_0_0# bank_0/port_address_0/hierarchical_decoder_0/hierarchical_predecode2x4_0/and2_dec_3/pinv_0/w_n127_244# sky130_fd_pr__pfet_01v8 ad=0 pd=0 as=3.277n ps=0.247m w=84 l=15
X523 bank_0/port_address_0/hierarchical_decoder_0/hierarchical_predecode2x4_0/and2_dec_3/pnand2_0/nmos_m1_w0_840_sli_dactive_0/D bank_0/port_address_0/hierarchical_decoder_0/hierarchical_predecode2x4_0/pinv_1/Z bank_0/port_address_0/hierarchical_decoder_0/hierarchical_predecode2x4_0/and2_dec_3/pnand2_0/nmos_m1_w0_840_sli_dactive_0/a_0_0# vdd sky130_fd_pr__nfet_01v8 ad=3.697n pd=0.257m as=3.277n ps=0.247m w=84 l=15
X524 bank_0/port_address_0/hierarchical_decoder_0/hierarchical_predecode2x4_0/and2_dec_3/pnand2_0/nmos_m1_w0_840_sactive_dli_0/a_54_0# bank_0/port_address_0/hierarchical_decoder_0/hierarchical_predecode2x4_0/pinv_0/Z bank_0/port_address_0/hierarchical_decoder_0/hierarchical_predecode2x4_0/and2_dec_3/pnand2_0/nmos_m1_w0_840_sli_dactive_0/D vdd sky130_fd_pr__nfet_01v8 ad=3.193n pd=0.245m as=0 ps=0 w=84 l=15
X525 bank_0/port_address_0/hierarchical_decoder_0/and2_dec_8/pinv_0/pmos_m1_w0_840_sli_dli_da_p_0/a_54_0# vdd bank_0/port_address_0/hierarchical_decoder_0/and2_dec_8/pinv_0/pmos_m1_w0_840_sli_dli_da_p_0/a_0_0# bank_0/port_address_0/hierarchical_decoder_0/and2_dec_9/pinv_0/w_n127_244# sky130_fd_pr__pfet_01v8 ad=3.193n pd=0.245m as=3.277n ps=0.247m w=84 l=15
X526 bank_0/port_address_0/hierarchical_decoder_0/and2_dec_8/pinv_0/nmos_m1_w0_420_sli_dli_da_p_0/a_54_0# vdd bank_0/port_address_0/hierarchical_decoder_0/and2_dec_8/pinv_0/nmos_m1_w0_420_sli_dli_da_p_0/a_0_0# vdd sky130_fd_pr__nfet_01v8 ad=1.597n pd=0.161m as=1.639n ps=0.163m w=42 l=15
X527 bank_0/port_address_0/hierarchical_decoder_0/and2_dec_8/pnand2_0/pmos_m1_w0_840_sli_dli_0/a_54_0# bank_0/port_address_0/hierarchical_decoder_0/predecode_5 bank_0/port_address_0/hierarchical_decoder_0/and2_dec_8/pnand2_0/pmos_m1_w0_840_sli_dli_0/a_0_0# bank_0/port_address_0/hierarchical_decoder_0/and2_dec_9/pinv_0/w_n127_244# sky130_fd_pr__pfet_01v8 ad=3.193n pd=0.245m as=3.699n ps=0.259m w=84 l=15
X528 bank_0/port_address_0/hierarchical_decoder_0/and2_dec_8/pnand2_0/pmos_m1_w0_840_sli_dli_0/a_0_0# bank_0/port_address_0/hierarchical_decoder_0/predecode_3 bank_0/port_address_0/hierarchical_decoder_0/and2_dec_8/pnand2_0/pmos_m1_w0_840_sli_dli_1/a_0_0# bank_0/port_address_0/hierarchical_decoder_0/and2_dec_9/pinv_0/w_n127_244# sky130_fd_pr__pfet_01v8 ad=0 pd=0 as=3.277n ps=0.247m w=84 l=15
X529 bank_0/port_address_0/hierarchical_decoder_0/and2_dec_8/pnand2_0/nmos_m1_w0_840_sli_dactive_0/D bank_0/port_address_0/hierarchical_decoder_0/predecode_3 bank_0/port_address_0/hierarchical_decoder_0/and2_dec_8/pnand2_0/nmos_m1_w0_840_sli_dactive_0/a_0_0# vdd sky130_fd_pr__nfet_01v8 ad=3.697n pd=0.257m as=3.277n ps=0.247m w=84 l=15
X530 bank_0/port_address_0/hierarchical_decoder_0/and2_dec_8/pnand2_0/nmos_m1_w0_840_sactive_dli_0/a_54_0# bank_0/port_address_0/hierarchical_decoder_0/predecode_5 bank_0/port_address_0/hierarchical_decoder_0/and2_dec_8/pnand2_0/nmos_m1_w0_840_sli_dactive_0/D vdd sky130_fd_pr__nfet_01v8 ad=3.193n pd=0.245m as=0 ps=0 w=84 l=15
X531 bank_0/port_address_0/hierarchical_decoder_0/hierarchical_predecode2x4_1/and2_dec_0/pinv_0/pmos_m1_w0_840_sli_dli_da_p_0/a_54_0# vdd bank_0/port_address_0/hierarchical_decoder_0/hierarchical_predecode2x4_1/and2_dec_0/pinv_0/pmos_m1_w0_840_sli_dli_da_p_0/a_0_0# bank_0/port_address_0/hierarchical_decoder_0/hierarchical_predecode2x4_1/and2_dec_1/pinv_0/w_n127_244# sky130_fd_pr__pfet_01v8 ad=3.193n pd=0.245m as=3.277n ps=0.247m w=84 l=15
X532 bank_0/port_address_0/hierarchical_decoder_0/hierarchical_predecode2x4_1/and2_dec_0/pinv_0/nmos_m1_w0_420_sli_dli_da_p_0/a_54_0# vdd bank_0/port_address_0/hierarchical_decoder_0/hierarchical_predecode2x4_1/and2_dec_0/pinv_0/nmos_m1_w0_420_sli_dli_da_p_0/a_0_0# vdd sky130_fd_pr__nfet_01v8 ad=1.597n pd=0.161m as=1.639n ps=0.163m w=42 l=15
X533 bank_0/port_address_0/hierarchical_decoder_0/hierarchical_predecode2x4_1/and2_dec_0/pnand2_0/pmos_m1_w0_840_sli_dli_0/a_54_0# bank_0/addr0_1 bank_0/port_address_0/hierarchical_decoder_0/hierarchical_predecode2x4_1/and2_dec_0/pnand2_0/pmos_m1_w0_840_sli_dli_0/a_0_0# bank_0/port_address_0/hierarchical_decoder_0/hierarchical_predecode2x4_1/and2_dec_1/pinv_0/w_n127_244# sky130_fd_pr__pfet_01v8 ad=3.193n pd=0.245m as=3.699n ps=0.259m w=84 l=15
X534 bank_0/port_address_0/hierarchical_decoder_0/hierarchical_predecode2x4_1/and2_dec_0/pnand2_0/pmos_m1_w0_840_sli_dli_0/a_0_0# vdd bank_0/port_address_0/hierarchical_decoder_0/hierarchical_predecode2x4_1/and2_dec_0/pnand2_0/pmos_m1_w0_840_sli_dli_1/a_0_0# bank_0/port_address_0/hierarchical_decoder_0/hierarchical_predecode2x4_1/and2_dec_1/pinv_0/w_n127_244# sky130_fd_pr__pfet_01v8 ad=0 pd=0 as=3.277n ps=0.247m w=84 l=15
X535 bank_0/port_address_0/hierarchical_decoder_0/hierarchical_predecode2x4_1/and2_dec_0/pnand2_0/nmos_m1_w0_840_sli_dactive_0/D vdd bank_0/port_address_0/hierarchical_decoder_0/hierarchical_predecode2x4_1/and2_dec_0/pnand2_0/nmos_m1_w0_840_sli_dactive_0/a_0_0# vdd sky130_fd_pr__nfet_01v8 ad=3.697n pd=0.257m as=3.277n ps=0.247m w=84 l=15
X536 bank_0/port_address_0/hierarchical_decoder_0/hierarchical_predecode2x4_1/and2_dec_0/pnand2_0/nmos_m1_w0_840_sactive_dli_0/a_54_0# bank_0/addr0_1 bank_0/port_address_0/hierarchical_decoder_0/hierarchical_predecode2x4_1/and2_dec_0/pnand2_0/nmos_m1_w0_840_sli_dactive_0/D vdd sky130_fd_pr__nfet_01v8 ad=3.193n pd=0.245m as=0 ps=0 w=84 l=15
X537 bank_0/port_address_0/hierarchical_decoder_0/hierarchical_predecode2x4_1/and2_dec_1/pinv_0/pmos_m1_w0_840_sli_dli_da_p_0/a_54_0# vdd bank_0/port_address_0/hierarchical_decoder_0/hierarchical_predecode2x4_1/and2_dec_1/pinv_0/pmos_m1_w0_840_sli_dli_da_p_0/a_0_0# bank_0/port_address_0/hierarchical_decoder_0/hierarchical_predecode2x4_1/and2_dec_1/pinv_0/w_n127_244# sky130_fd_pr__pfet_01v8 ad=3.193n pd=0.245m as=3.277n ps=0.247m w=84 l=15
X538 bank_0/port_address_0/hierarchical_decoder_0/hierarchical_predecode2x4_1/and2_dec_1/pinv_0/nmos_m1_w0_420_sli_dli_da_p_0/a_54_0# vdd bank_0/port_address_0/hierarchical_decoder_0/hierarchical_predecode2x4_1/and2_dec_1/pinv_0/nmos_m1_w0_420_sli_dli_da_p_0/a_0_0# vdd sky130_fd_pr__nfet_01v8 ad=1.597n pd=0.161m as=1.639n ps=0.163m w=42 l=15
X539 bank_0/port_address_0/hierarchical_decoder_0/hierarchical_predecode2x4_1/and2_dec_1/pnand2_0/pmos_m1_w0_840_sli_dli_0/a_54_0# bank_0/addr0_1 bank_0/port_address_0/hierarchical_decoder_0/hierarchical_predecode2x4_1/and2_dec_1/pnand2_0/pmos_m1_w0_840_sli_dli_0/a_0_0# bank_0/port_address_0/hierarchical_decoder_0/hierarchical_predecode2x4_1/and2_dec_1/pinv_0/w_n127_244# sky130_fd_pr__pfet_01v8 ad=3.193n pd=0.245m as=3.699n ps=0.259m w=84 l=15
X540 bank_0/port_address_0/hierarchical_decoder_0/hierarchical_predecode2x4_1/and2_dec_1/pnand2_0/pmos_m1_w0_840_sli_dli_0/a_0_0# bank_0/port_address_0/hierarchical_decoder_0/hierarchical_predecode2x4_1/pinv_1/Z bank_0/port_address_0/hierarchical_decoder_0/hierarchical_predecode2x4_1/and2_dec_1/pnand2_0/pmos_m1_w0_840_sli_dli_1/a_0_0# bank_0/port_address_0/hierarchical_decoder_0/hierarchical_predecode2x4_1/and2_dec_1/pinv_0/w_n127_244# sky130_fd_pr__pfet_01v8 ad=0 pd=0 as=3.277n ps=0.247m w=84 l=15
X541 bank_0/port_address_0/hierarchical_decoder_0/hierarchical_predecode2x4_1/and2_dec_1/pnand2_0/nmos_m1_w0_840_sli_dactive_0/D bank_0/port_address_0/hierarchical_decoder_0/hierarchical_predecode2x4_1/pinv_1/Z bank_0/port_address_0/hierarchical_decoder_0/hierarchical_predecode2x4_1/and2_dec_1/pnand2_0/nmos_m1_w0_840_sli_dactive_0/a_0_0# vdd sky130_fd_pr__nfet_01v8 ad=3.697n pd=0.257m as=3.277n ps=0.247m w=84 l=15
X542 bank_0/port_address_0/hierarchical_decoder_0/hierarchical_predecode2x4_1/and2_dec_1/pnand2_0/nmos_m1_w0_840_sactive_dli_0/a_54_0# bank_0/addr0_1 bank_0/port_address_0/hierarchical_decoder_0/hierarchical_predecode2x4_1/and2_dec_1/pnand2_0/nmos_m1_w0_840_sli_dactive_0/D vdd sky130_fd_pr__nfet_01v8 ad=3.193n pd=0.245m as=0 ps=0 w=84 l=15
X543 bank_0/port_address_0/hierarchical_decoder_0/hierarchical_predecode2x4_1/pinv_0/pmos_m1_w0_840_sli_dli_da_p_0/a_54_0# bank_0/addr0_1 bank_0/port_address_0/hierarchical_decoder_0/hierarchical_predecode2x4_1/pinv_0/pmos_m1_w0_840_sli_dli_da_p_0/a_0_0# bank_0/port_address_0/hierarchical_decoder_0/hierarchical_predecode2x4_1/pinv_1/w_n127_244# sky130_fd_pr__pfet_01v8 ad=3.193n pd=0.245m as=3.277n ps=0.247m w=84 l=15
X544 bank_0/port_address_0/hierarchical_decoder_0/hierarchical_predecode2x4_1/pinv_0/nmos_m1_w0_420_sli_dli_da_p_0/a_54_0# bank_0/addr0_1 bank_0/port_address_0/hierarchical_decoder_0/hierarchical_predecode2x4_1/pinv_0/nmos_m1_w0_420_sli_dli_da_p_0/a_0_0# vdd sky130_fd_pr__nfet_01v8 ad=1.597n pd=0.161m as=1.639n ps=0.163m w=42 l=15
X545 bank_0/port_address_0/hierarchical_decoder_0/hierarchical_predecode2x4_1/and2_dec_2/pinv_0/pmos_m1_w0_840_sli_dli_da_p_0/a_54_0# vdd bank_0/port_address_0/hierarchical_decoder_0/hierarchical_predecode2x4_1/and2_dec_2/pinv_0/pmos_m1_w0_840_sli_dli_da_p_0/a_0_0# bank_0/port_address_0/hierarchical_decoder_0/hierarchical_predecode2x4_1/and2_dec_3/pinv_0/w_n127_244# sky130_fd_pr__pfet_01v8 ad=3.193n pd=0.245m as=3.277n ps=0.247m w=84 l=15
X546 bank_0/port_address_0/hierarchical_decoder_0/hierarchical_predecode2x4_1/and2_dec_2/pinv_0/nmos_m1_w0_420_sli_dli_da_p_0/a_54_0# vdd bank_0/port_address_0/hierarchical_decoder_0/hierarchical_predecode2x4_1/and2_dec_2/pinv_0/nmos_m1_w0_420_sli_dli_da_p_0/a_0_0# vdd sky130_fd_pr__nfet_01v8 ad=1.597n pd=0.161m as=1.639n ps=0.163m w=42 l=15
X547 bank_0/port_address_0/hierarchical_decoder_0/hierarchical_predecode2x4_1/and2_dec_2/pnand2_0/pmos_m1_w0_840_sli_dli_0/a_54_0# bank_0/port_address_0/hierarchical_decoder_0/hierarchical_predecode2x4_1/pinv_0/Z bank_0/port_address_0/hierarchical_decoder_0/hierarchical_predecode2x4_1/and2_dec_2/pnand2_0/pmos_m1_w0_840_sli_dli_0/a_0_0# bank_0/port_address_0/hierarchical_decoder_0/hierarchical_predecode2x4_1/and2_dec_3/pinv_0/w_n127_244# sky130_fd_pr__pfet_01v8 ad=3.193n pd=0.245m as=3.699n ps=0.259m w=84 l=15
X548 bank_0/port_address_0/hierarchical_decoder_0/hierarchical_predecode2x4_1/and2_dec_2/pnand2_0/pmos_m1_w0_840_sli_dli_0/a_0_0# vdd bank_0/port_address_0/hierarchical_decoder_0/hierarchical_predecode2x4_1/and2_dec_2/pnand2_0/pmos_m1_w0_840_sli_dli_1/a_0_0# bank_0/port_address_0/hierarchical_decoder_0/hierarchical_predecode2x4_1/and2_dec_3/pinv_0/w_n127_244# sky130_fd_pr__pfet_01v8 ad=0 pd=0 as=3.277n ps=0.247m w=84 l=15
X549 bank_0/port_address_0/hierarchical_decoder_0/hierarchical_predecode2x4_1/and2_dec_2/pnand2_0/nmos_m1_w0_840_sli_dactive_0/D vdd bank_0/port_address_0/hierarchical_decoder_0/hierarchical_predecode2x4_1/and2_dec_2/pnand2_0/nmos_m1_w0_840_sli_dactive_0/a_0_0# vdd sky130_fd_pr__nfet_01v8 ad=3.697n pd=0.257m as=3.277n ps=0.247m w=84 l=15
X550 bank_0/port_address_0/hierarchical_decoder_0/hierarchical_predecode2x4_1/and2_dec_2/pnand2_0/nmos_m1_w0_840_sactive_dli_0/a_54_0# bank_0/port_address_0/hierarchical_decoder_0/hierarchical_predecode2x4_1/pinv_0/Z bank_0/port_address_0/hierarchical_decoder_0/hierarchical_predecode2x4_1/and2_dec_2/pnand2_0/nmos_m1_w0_840_sli_dactive_0/D vdd sky130_fd_pr__nfet_01v8 ad=3.193n pd=0.245m as=0 ps=0 w=84 l=15
X551 bank_0/port_address_0/hierarchical_decoder_0/hierarchical_predecode2x4_1/pinv_1/pmos_m1_w0_840_sli_dli_da_p_0/a_54_0# vdd bank_0/port_address_0/hierarchical_decoder_0/hierarchical_predecode2x4_1/pinv_1/pmos_m1_w0_840_sli_dli_da_p_0/a_0_0# bank_0/port_address_0/hierarchical_decoder_0/hierarchical_predecode2x4_1/pinv_1/w_n127_244# sky130_fd_pr__pfet_01v8 ad=3.193n pd=0.245m as=3.277n ps=0.247m w=84 l=15
X552 bank_0/port_address_0/hierarchical_decoder_0/hierarchical_predecode2x4_1/pinv_1/nmos_m1_w0_420_sli_dli_da_p_0/a_54_0# vdd bank_0/port_address_0/hierarchical_decoder_0/hierarchical_predecode2x4_1/pinv_1/nmos_m1_w0_420_sli_dli_da_p_0/a_0_0# vdd sky130_fd_pr__nfet_01v8 ad=1.597n pd=0.161m as=1.639n ps=0.163m w=42 l=15
X553 bank_0/port_address_0/hierarchical_decoder_0/hierarchical_predecode2x4_1/and2_dec_3/pinv_0/pmos_m1_w0_840_sli_dli_da_p_0/a_54_0# vdd bank_0/port_address_0/hierarchical_decoder_0/hierarchical_predecode2x4_1/and2_dec_3/pinv_0/pmos_m1_w0_840_sli_dli_da_p_0/a_0_0# bank_0/port_address_0/hierarchical_decoder_0/hierarchical_predecode2x4_1/and2_dec_3/pinv_0/w_n127_244# sky130_fd_pr__pfet_01v8 ad=3.193n pd=0.245m as=3.277n ps=0.247m w=84 l=15
X554 bank_0/port_address_0/hierarchical_decoder_0/hierarchical_predecode2x4_1/and2_dec_3/pinv_0/nmos_m1_w0_420_sli_dli_da_p_0/a_54_0# vdd bank_0/port_address_0/hierarchical_decoder_0/hierarchical_predecode2x4_1/and2_dec_3/pinv_0/nmos_m1_w0_420_sli_dli_da_p_0/a_0_0# vdd sky130_fd_pr__nfet_01v8 ad=1.597n pd=0.161m as=1.639n ps=0.163m w=42 l=15
X555 bank_0/port_address_0/hierarchical_decoder_0/hierarchical_predecode2x4_1/and2_dec_3/pnand2_0/pmos_m1_w0_840_sli_dli_0/a_54_0# bank_0/port_address_0/hierarchical_decoder_0/hierarchical_predecode2x4_1/pinv_0/Z bank_0/port_address_0/hierarchical_decoder_0/hierarchical_predecode2x4_1/and2_dec_3/pnand2_0/pmos_m1_w0_840_sli_dli_0/a_0_0# bank_0/port_address_0/hierarchical_decoder_0/hierarchical_predecode2x4_1/and2_dec_3/pinv_0/w_n127_244# sky130_fd_pr__pfet_01v8 ad=3.193n pd=0.245m as=3.699n ps=0.259m w=84 l=15
X556 bank_0/port_address_0/hierarchical_decoder_0/hierarchical_predecode2x4_1/and2_dec_3/pnand2_0/pmos_m1_w0_840_sli_dli_0/a_0_0# bank_0/port_address_0/hierarchical_decoder_0/hierarchical_predecode2x4_1/pinv_1/Z bank_0/port_address_0/hierarchical_decoder_0/hierarchical_predecode2x4_1/and2_dec_3/pnand2_0/pmos_m1_w0_840_sli_dli_1/a_0_0# bank_0/port_address_0/hierarchical_decoder_0/hierarchical_predecode2x4_1/and2_dec_3/pinv_0/w_n127_244# sky130_fd_pr__pfet_01v8 ad=0 pd=0 as=3.277n ps=0.247m w=84 l=15
X557 bank_0/port_address_0/hierarchical_decoder_0/hierarchical_predecode2x4_1/and2_dec_3/pnand2_0/nmos_m1_w0_840_sli_dactive_0/D bank_0/port_address_0/hierarchical_decoder_0/hierarchical_predecode2x4_1/pinv_1/Z bank_0/port_address_0/hierarchical_decoder_0/hierarchical_predecode2x4_1/and2_dec_3/pnand2_0/nmos_m1_w0_840_sli_dactive_0/a_0_0# vdd sky130_fd_pr__nfet_01v8 ad=3.697n pd=0.257m as=3.277n ps=0.247m w=84 l=15
X558 bank_0/port_address_0/hierarchical_decoder_0/hierarchical_predecode2x4_1/and2_dec_3/pnand2_0/nmos_m1_w0_840_sactive_dli_0/a_54_0# bank_0/port_address_0/hierarchical_decoder_0/hierarchical_predecode2x4_1/pinv_0/Z bank_0/port_address_0/hierarchical_decoder_0/hierarchical_predecode2x4_1/and2_dec_3/pnand2_0/nmos_m1_w0_840_sli_dactive_0/D vdd sky130_fd_pr__nfet_01v8 ad=3.193n pd=0.245m as=0 ps=0 w=84 l=15
X559 bank_0/port_address_0/hierarchical_decoder_0/and2_dec_9/pinv_0/pmos_m1_w0_840_sli_dli_da_p_0/a_54_0# vdd bank_0/port_address_0/hierarchical_decoder_0/and2_dec_9/pinv_0/pmos_m1_w0_840_sli_dli_da_p_0/a_0_0# bank_0/port_address_0/hierarchical_decoder_0/and2_dec_9/pinv_0/w_n127_244# sky130_fd_pr__pfet_01v8 ad=3.193n pd=0.245m as=3.277n ps=0.247m w=84 l=15
X560 bank_0/port_address_0/hierarchical_decoder_0/and2_dec_9/pinv_0/nmos_m1_w0_420_sli_dli_da_p_0/a_54_0# vdd bank_0/port_address_0/hierarchical_decoder_0/and2_dec_9/pinv_0/nmos_m1_w0_420_sli_dli_da_p_0/a_0_0# vdd sky130_fd_pr__nfet_01v8 ad=1.597n pd=0.161m as=1.639n ps=0.163m w=42 l=15
X561 bank_0/port_address_0/hierarchical_decoder_0/and2_dec_9/pnand2_0/pmos_m1_w0_840_sli_dli_0/a_54_0# bank_0/port_address_0/hierarchical_decoder_0/predecode_5 bank_0/port_address_0/hierarchical_decoder_0/and2_dec_9/pnand2_0/pmos_m1_w0_840_sli_dli_0/a_0_0# bank_0/port_address_0/hierarchical_decoder_0/and2_dec_9/pinv_0/w_n127_244# sky130_fd_pr__pfet_01v8 ad=3.193n pd=0.245m as=3.699n ps=0.259m w=84 l=15
X562 bank_0/port_address_0/hierarchical_decoder_0/and2_dec_9/pnand2_0/pmos_m1_w0_840_sli_dli_0/a_0_0# bank_0/port_address_0/hierarchical_decoder_0/predecode_2 bank_0/port_address_0/hierarchical_decoder_0/and2_dec_9/pnand2_0/pmos_m1_w0_840_sli_dli_1/a_0_0# bank_0/port_address_0/hierarchical_decoder_0/and2_dec_9/pinv_0/w_n127_244# sky130_fd_pr__pfet_01v8 ad=0 pd=0 as=3.277n ps=0.247m w=84 l=15
X563 bank_0/port_address_0/hierarchical_decoder_0/and2_dec_9/pnand2_0/nmos_m1_w0_840_sli_dactive_0/D bank_0/port_address_0/hierarchical_decoder_0/predecode_2 bank_0/port_address_0/hierarchical_decoder_0/and2_dec_9/pnand2_0/nmos_m1_w0_840_sli_dactive_0/a_0_0# vdd sky130_fd_pr__nfet_01v8 ad=3.697n pd=0.257m as=3.277n ps=0.247m w=84 l=15
X564 bank_0/port_address_0/hierarchical_decoder_0/and2_dec_9/pnand2_0/nmos_m1_w0_840_sactive_dli_0/a_54_0# bank_0/port_address_0/hierarchical_decoder_0/predecode_5 bank_0/port_address_0/hierarchical_decoder_0/and2_dec_9/pnand2_0/nmos_m1_w0_840_sli_dactive_0/D vdd sky130_fd_pr__nfet_01v8 ad=3.193n pd=0.245m as=0 ps=0 w=84 l=15
X565 bank_0/port_address_0/hierarchical_decoder_0/and2_dec_10/pinv_0/pmos_m1_w0_840_sli_dli_da_p_0/a_54_0# vdd bank_0/port_address_0/hierarchical_decoder_0/and2_dec_10/pinv_0/pmos_m1_w0_840_sli_dli_da_p_0/a_0_0# bank_0/port_address_0/hierarchical_decoder_0/and2_dec_11/pinv_0/w_n127_244# sky130_fd_pr__pfet_01v8 ad=3.193n pd=0.245m as=3.277n ps=0.247m w=84 l=15
X566 bank_0/port_address_0/hierarchical_decoder_0/and2_dec_10/pinv_0/nmos_m1_w0_420_sli_dli_da_p_0/a_54_0# vdd bank_0/port_address_0/hierarchical_decoder_0/and2_dec_10/pinv_0/nmos_m1_w0_420_sli_dli_da_p_0/a_0_0# vdd sky130_fd_pr__nfet_01v8 ad=1.597n pd=0.161m as=1.639n ps=0.163m w=42 l=15
X567 bank_0/port_address_0/hierarchical_decoder_0/and2_dec_10/pnand2_0/pmos_m1_w0_840_sli_dli_0/a_54_0# bank_0/port_address_0/hierarchical_decoder_0/predecode_5 bank_0/port_address_0/hierarchical_decoder_0/and2_dec_10/pnand2_0/pmos_m1_w0_840_sli_dli_0/a_0_0# bank_0/port_address_0/hierarchical_decoder_0/and2_dec_11/pinv_0/w_n127_244# sky130_fd_pr__pfet_01v8 ad=3.193n pd=0.245m as=3.699n ps=0.259m w=84 l=15
X568 bank_0/port_address_0/hierarchical_decoder_0/and2_dec_10/pnand2_0/pmos_m1_w0_840_sli_dli_0/a_0_0# bank_0/port_address_0/hierarchical_decoder_0/predecode_1 bank_0/port_address_0/hierarchical_decoder_0/and2_dec_10/pnand2_0/pmos_m1_w0_840_sli_dli_1/a_0_0# bank_0/port_address_0/hierarchical_decoder_0/and2_dec_11/pinv_0/w_n127_244# sky130_fd_pr__pfet_01v8 ad=0 pd=0 as=3.277n ps=0.247m w=84 l=15
X569 bank_0/port_address_0/hierarchical_decoder_0/and2_dec_10/pnand2_0/nmos_m1_w0_840_sli_dactive_0/D bank_0/port_address_0/hierarchical_decoder_0/predecode_1 bank_0/port_address_0/hierarchical_decoder_0/and2_dec_10/pnand2_0/nmos_m1_w0_840_sli_dactive_0/a_0_0# vdd sky130_fd_pr__nfet_01v8 ad=3.697n pd=0.257m as=3.277n ps=0.247m w=84 l=15
X570 bank_0/port_address_0/hierarchical_decoder_0/and2_dec_10/pnand2_0/nmos_m1_w0_840_sactive_dli_0/a_54_0# bank_0/port_address_0/hierarchical_decoder_0/predecode_5 bank_0/port_address_0/hierarchical_decoder_0/and2_dec_10/pnand2_0/nmos_m1_w0_840_sli_dactive_0/D vdd sky130_fd_pr__nfet_01v8 ad=3.193n pd=0.245m as=0 ps=0 w=84 l=15
X571 bank_0/port_address_0/hierarchical_decoder_0/and2_dec_11/pinv_0/pmos_m1_w0_840_sli_dli_da_p_0/a_54_0# vdd bank_0/port_address_0/hierarchical_decoder_0/and2_dec_11/pinv_0/pmos_m1_w0_840_sli_dli_da_p_0/a_0_0# bank_0/port_address_0/hierarchical_decoder_0/and2_dec_11/pinv_0/w_n127_244# sky130_fd_pr__pfet_01v8 ad=3.193n pd=0.245m as=3.277n ps=0.247m w=84 l=15
X572 bank_0/port_address_0/hierarchical_decoder_0/and2_dec_11/pinv_0/nmos_m1_w0_420_sli_dli_da_p_0/a_54_0# vdd bank_0/port_address_0/hierarchical_decoder_0/and2_dec_11/pinv_0/nmos_m1_w0_420_sli_dli_da_p_0/a_0_0# vdd sky130_fd_pr__nfet_01v8 ad=1.597n pd=0.161m as=1.639n ps=0.163m w=42 l=15
X573 bank_0/port_address_0/hierarchical_decoder_0/and2_dec_11/pnand2_0/pmos_m1_w0_840_sli_dli_0/a_54_0# bank_0/port_address_0/hierarchical_decoder_0/predecode_5 bank_0/port_address_0/hierarchical_decoder_0/and2_dec_11/pnand2_0/pmos_m1_w0_840_sli_dli_0/a_0_0# bank_0/port_address_0/hierarchical_decoder_0/and2_dec_11/pinv_0/w_n127_244# sky130_fd_pr__pfet_01v8 ad=3.193n pd=0.245m as=3.699n ps=0.259m w=84 l=15
X574 bank_0/port_address_0/hierarchical_decoder_0/and2_dec_11/pnand2_0/pmos_m1_w0_840_sli_dli_0/a_0_0# bank_0/port_address_0/hierarchical_decoder_0/predecode_0 bank_0/port_address_0/hierarchical_decoder_0/and2_dec_11/pnand2_0/pmos_m1_w0_840_sli_dli_1/a_0_0# bank_0/port_address_0/hierarchical_decoder_0/and2_dec_11/pinv_0/w_n127_244# sky130_fd_pr__pfet_01v8 ad=0 pd=0 as=3.277n ps=0.247m w=84 l=15
X575 bank_0/port_address_0/hierarchical_decoder_0/and2_dec_11/pnand2_0/nmos_m1_w0_840_sli_dactive_0/D bank_0/port_address_0/hierarchical_decoder_0/predecode_0 bank_0/port_address_0/hierarchical_decoder_0/and2_dec_11/pnand2_0/nmos_m1_w0_840_sli_dactive_0/a_0_0# vdd sky130_fd_pr__nfet_01v8 ad=3.697n pd=0.257m as=3.277n ps=0.247m w=84 l=15
X576 bank_0/port_address_0/hierarchical_decoder_0/and2_dec_11/pnand2_0/nmos_m1_w0_840_sactive_dli_0/a_54_0# bank_0/port_address_0/hierarchical_decoder_0/predecode_5 bank_0/port_address_0/hierarchical_decoder_0/and2_dec_11/pnand2_0/nmos_m1_w0_840_sli_dactive_0/D vdd sky130_fd_pr__nfet_01v8 ad=3.193n pd=0.245m as=0 ps=0 w=84 l=15
X577 bank_0/port_address_0/hierarchical_decoder_0/and2_dec_12/pinv_0/pmos_m1_w0_840_sli_dli_da_p_0/a_54_0# vdd bank_0/port_address_0/hierarchical_decoder_0/and2_dec_12/pinv_0/pmos_m1_w0_840_sli_dli_da_p_0/a_0_0# bank_0/port_address_0/hierarchical_decoder_0/and2_dec_13/pinv_0/w_n127_244# sky130_fd_pr__pfet_01v8 ad=3.193n pd=0.245m as=3.277n ps=0.247m w=84 l=15
X578 bank_0/port_address_0/hierarchical_decoder_0/and2_dec_12/pinv_0/nmos_m1_w0_420_sli_dli_da_p_0/a_54_0# vdd bank_0/port_address_0/hierarchical_decoder_0/and2_dec_12/pinv_0/nmos_m1_w0_420_sli_dli_da_p_0/a_0_0# vdd sky130_fd_pr__nfet_01v8 ad=1.597n pd=0.161m as=1.639n ps=0.163m w=42 l=15
X579 bank_0/port_address_0/hierarchical_decoder_0/and2_dec_12/pnand2_0/pmos_m1_w0_840_sli_dli_0/a_54_0# bank_0/port_address_0/hierarchical_decoder_0/predecode_4 bank_0/port_address_0/hierarchical_decoder_0/and2_dec_12/pnand2_0/pmos_m1_w0_840_sli_dli_0/a_0_0# bank_0/port_address_0/hierarchical_decoder_0/and2_dec_13/pinv_0/w_n127_244# sky130_fd_pr__pfet_01v8 ad=3.193n pd=0.245m as=3.699n ps=0.259m w=84 l=15
X580 bank_0/port_address_0/hierarchical_decoder_0/and2_dec_12/pnand2_0/pmos_m1_w0_840_sli_dli_0/a_0_0# bank_0/port_address_0/hierarchical_decoder_0/predecode_3 bank_0/port_address_0/hierarchical_decoder_0/and2_dec_12/pnand2_0/pmos_m1_w0_840_sli_dli_1/a_0_0# bank_0/port_address_0/hierarchical_decoder_0/and2_dec_13/pinv_0/w_n127_244# sky130_fd_pr__pfet_01v8 ad=0 pd=0 as=3.277n ps=0.247m w=84 l=15
X581 bank_0/port_address_0/hierarchical_decoder_0/and2_dec_12/pnand2_0/nmos_m1_w0_840_sli_dactive_0/D bank_0/port_address_0/hierarchical_decoder_0/predecode_3 bank_0/port_address_0/hierarchical_decoder_0/and2_dec_12/pnand2_0/nmos_m1_w0_840_sli_dactive_0/a_0_0# vdd sky130_fd_pr__nfet_01v8 ad=3.697n pd=0.257m as=3.277n ps=0.247m w=84 l=15
X582 bank_0/port_address_0/hierarchical_decoder_0/and2_dec_12/pnand2_0/nmos_m1_w0_840_sactive_dli_0/a_54_0# bank_0/port_address_0/hierarchical_decoder_0/predecode_4 bank_0/port_address_0/hierarchical_decoder_0/and2_dec_12/pnand2_0/nmos_m1_w0_840_sli_dactive_0/D vdd sky130_fd_pr__nfet_01v8 ad=3.193n pd=0.245m as=0 ps=0 w=84 l=15
X583 bank_0/port_address_0/hierarchical_decoder_0/and2_dec_13/pinv_0/pmos_m1_w0_840_sli_dli_da_p_0/a_54_0# vdd bank_0/port_address_0/hierarchical_decoder_0/and2_dec_13/pinv_0/pmos_m1_w0_840_sli_dli_da_p_0/a_0_0# bank_0/port_address_0/hierarchical_decoder_0/and2_dec_13/pinv_0/w_n127_244# sky130_fd_pr__pfet_01v8 ad=3.193n pd=0.245m as=3.277n ps=0.247m w=84 l=15
X584 bank_0/port_address_0/hierarchical_decoder_0/and2_dec_13/pinv_0/nmos_m1_w0_420_sli_dli_da_p_0/a_54_0# vdd bank_0/port_address_0/hierarchical_decoder_0/and2_dec_13/pinv_0/nmos_m1_w0_420_sli_dli_da_p_0/a_0_0# vdd sky130_fd_pr__nfet_01v8 ad=1.597n pd=0.161m as=1.639n ps=0.163m w=42 l=15
X585 bank_0/port_address_0/hierarchical_decoder_0/and2_dec_13/pnand2_0/pmos_m1_w0_840_sli_dli_0/a_54_0# bank_0/port_address_0/hierarchical_decoder_0/predecode_4 bank_0/port_address_0/hierarchical_decoder_0/and2_dec_13/pnand2_0/pmos_m1_w0_840_sli_dli_0/a_0_0# bank_0/port_address_0/hierarchical_decoder_0/and2_dec_13/pinv_0/w_n127_244# sky130_fd_pr__pfet_01v8 ad=3.193n pd=0.245m as=3.699n ps=0.259m w=84 l=15
X586 bank_0/port_address_0/hierarchical_decoder_0/and2_dec_13/pnand2_0/pmos_m1_w0_840_sli_dli_0/a_0_0# bank_0/port_address_0/hierarchical_decoder_0/predecode_2 bank_0/port_address_0/hierarchical_decoder_0/and2_dec_13/pnand2_0/pmos_m1_w0_840_sli_dli_1/a_0_0# bank_0/port_address_0/hierarchical_decoder_0/and2_dec_13/pinv_0/w_n127_244# sky130_fd_pr__pfet_01v8 ad=0 pd=0 as=3.277n ps=0.247m w=84 l=15
X587 bank_0/port_address_0/hierarchical_decoder_0/and2_dec_13/pnand2_0/nmos_m1_w0_840_sli_dactive_0/D bank_0/port_address_0/hierarchical_decoder_0/predecode_2 bank_0/port_address_0/hierarchical_decoder_0/and2_dec_13/pnand2_0/nmos_m1_w0_840_sli_dactive_0/a_0_0# vdd sky130_fd_pr__nfet_01v8 ad=3.697n pd=0.257m as=3.277n ps=0.247m w=84 l=15
X588 bank_0/port_address_0/hierarchical_decoder_0/and2_dec_13/pnand2_0/nmos_m1_w0_840_sactive_dli_0/a_54_0# bank_0/port_address_0/hierarchical_decoder_0/predecode_4 bank_0/port_address_0/hierarchical_decoder_0/and2_dec_13/pnand2_0/nmos_m1_w0_840_sli_dactive_0/D vdd sky130_fd_pr__nfet_01v8 ad=3.193n pd=0.245m as=0 ps=0 w=84 l=15
X589 bank_0/port_address_0/hierarchical_decoder_0/and2_dec_14/pinv_0/pmos_m1_w0_840_sli_dli_da_p_0/a_54_0# vdd bank_0/port_address_0/hierarchical_decoder_0/and2_dec_14/pinv_0/pmos_m1_w0_840_sli_dli_da_p_0/a_0_0# bank_0/port_address_0/hierarchical_decoder_0/and2_dec_15/pinv_0/w_n127_244# sky130_fd_pr__pfet_01v8 ad=3.193n pd=0.245m as=3.277n ps=0.247m w=84 l=15
X590 bank_0/port_address_0/hierarchical_decoder_0/and2_dec_14/pinv_0/nmos_m1_w0_420_sli_dli_da_p_0/a_54_0# vdd bank_0/port_address_0/hierarchical_decoder_0/and2_dec_14/pinv_0/nmos_m1_w0_420_sli_dli_da_p_0/a_0_0# vdd sky130_fd_pr__nfet_01v8 ad=1.597n pd=0.161m as=1.639n ps=0.163m w=42 l=15
X591 bank_0/port_address_0/hierarchical_decoder_0/and2_dec_14/pnand2_0/pmos_m1_w0_840_sli_dli_0/a_54_0# bank_0/port_address_0/hierarchical_decoder_0/predecode_4 bank_0/port_address_0/hierarchical_decoder_0/and2_dec_14/pnand2_0/pmos_m1_w0_840_sli_dli_0/a_0_0# bank_0/port_address_0/hierarchical_decoder_0/and2_dec_15/pinv_0/w_n127_244# sky130_fd_pr__pfet_01v8 ad=3.193n pd=0.245m as=3.699n ps=0.259m w=84 l=15
X592 bank_0/port_address_0/hierarchical_decoder_0/and2_dec_14/pnand2_0/pmos_m1_w0_840_sli_dli_0/a_0_0# bank_0/port_address_0/hierarchical_decoder_0/predecode_1 bank_0/port_address_0/hierarchical_decoder_0/and2_dec_14/pnand2_0/pmos_m1_w0_840_sli_dli_1/a_0_0# bank_0/port_address_0/hierarchical_decoder_0/and2_dec_15/pinv_0/w_n127_244# sky130_fd_pr__pfet_01v8 ad=0 pd=0 as=3.277n ps=0.247m w=84 l=15
X593 bank_0/port_address_0/hierarchical_decoder_0/and2_dec_14/pnand2_0/nmos_m1_w0_840_sli_dactive_0/D bank_0/port_address_0/hierarchical_decoder_0/predecode_1 bank_0/port_address_0/hierarchical_decoder_0/and2_dec_14/pnand2_0/nmos_m1_w0_840_sli_dactive_0/a_0_0# vdd sky130_fd_pr__nfet_01v8 ad=3.697n pd=0.257m as=3.277n ps=0.247m w=84 l=15
X594 bank_0/port_address_0/hierarchical_decoder_0/and2_dec_14/pnand2_0/nmos_m1_w0_840_sactive_dli_0/a_54_0# bank_0/port_address_0/hierarchical_decoder_0/predecode_4 bank_0/port_address_0/hierarchical_decoder_0/and2_dec_14/pnand2_0/nmos_m1_w0_840_sli_dactive_0/D vdd sky130_fd_pr__nfet_01v8 ad=3.193n pd=0.245m as=0 ps=0 w=84 l=15
X595 bank_0/port_address_0/hierarchical_decoder_0/and2_dec_15/pinv_0/pmos_m1_w0_840_sli_dli_da_p_0/a_54_0# vdd bank_0/port_address_0/hierarchical_decoder_0/and2_dec_15/pinv_0/pmos_m1_w0_840_sli_dli_da_p_0/a_0_0# bank_0/port_address_0/hierarchical_decoder_0/and2_dec_15/pinv_0/w_n127_244# sky130_fd_pr__pfet_01v8 ad=3.193n pd=0.245m as=3.277n ps=0.247m w=84 l=15
X596 bank_0/port_address_0/hierarchical_decoder_0/and2_dec_15/pinv_0/nmos_m1_w0_420_sli_dli_da_p_0/a_54_0# vdd bank_0/port_address_0/hierarchical_decoder_0/and2_dec_15/pinv_0/nmos_m1_w0_420_sli_dli_da_p_0/a_0_0# vdd sky130_fd_pr__nfet_01v8 ad=1.597n pd=0.161m as=1.639n ps=0.163m w=42 l=15
X597 bank_0/port_address_0/hierarchical_decoder_0/and2_dec_15/pnand2_0/pmos_m1_w0_840_sli_dli_0/a_54_0# bank_0/port_address_0/hierarchical_decoder_0/predecode_4 bank_0/port_address_0/hierarchical_decoder_0/and2_dec_15/pnand2_0/pmos_m1_w0_840_sli_dli_0/a_0_0# bank_0/port_address_0/hierarchical_decoder_0/and2_dec_15/pinv_0/w_n127_244# sky130_fd_pr__pfet_01v8 ad=3.193n pd=0.245m as=3.699n ps=0.259m w=84 l=15
X598 bank_0/port_address_0/hierarchical_decoder_0/and2_dec_15/pnand2_0/pmos_m1_w0_840_sli_dli_0/a_0_0# bank_0/port_address_0/hierarchical_decoder_0/predecode_0 bank_0/port_address_0/hierarchical_decoder_0/and2_dec_15/pnand2_0/pmos_m1_w0_840_sli_dli_1/a_0_0# bank_0/port_address_0/hierarchical_decoder_0/and2_dec_15/pinv_0/w_n127_244# sky130_fd_pr__pfet_01v8 ad=0 pd=0 as=3.277n ps=0.247m w=84 l=15
X599 bank_0/port_address_0/hierarchical_decoder_0/and2_dec_15/pnand2_0/nmos_m1_w0_840_sli_dactive_0/D bank_0/port_address_0/hierarchical_decoder_0/predecode_0 bank_0/port_address_0/hierarchical_decoder_0/and2_dec_15/pnand2_0/nmos_m1_w0_840_sli_dactive_0/a_0_0# vdd sky130_fd_pr__nfet_01v8 ad=3.697n pd=0.257m as=3.277n ps=0.247m w=84 l=15
X600 bank_0/port_address_0/hierarchical_decoder_0/and2_dec_15/pnand2_0/nmos_m1_w0_840_sactive_dli_0/a_54_0# bank_0/port_address_0/hierarchical_decoder_0/predecode_4 bank_0/port_address_0/hierarchical_decoder_0/and2_dec_15/pnand2_0/nmos_m1_w0_840_sli_dactive_0/D vdd sky130_fd_pr__nfet_01v8 ad=3.193n pd=0.245m as=0 ps=0 w=84 l=15
X601 bank_0/port_address_0/wordline_driver_array_0/wordline_driver_10/pinv_0/pmos_m1_w0_840_sli_dli_da_p_0/a_54_0# vdd bank_0/port_address_0/wordline_driver_array_0/wordline_driver_10/pinv_0/pmos_m1_w0_840_sli_dli_da_p_0/a_0_0# bank_0/port_address_0/hierarchical_decoder_0/and2_dec_11/pinv_0/w_n127_244# sky130_fd_pr__pfet_01v8 ad=3.193n pd=0.245m as=3.277n ps=0.247m w=84 l=15
X602 bank_0/port_address_0/wordline_driver_array_0/wordline_driver_10/pinv_0/nmos_m1_w0_420_sli_dli_da_p_0/a_54_0# vdd bank_0/port_address_0/wordline_driver_array_0/wordline_driver_10/pinv_0/nmos_m1_w0_420_sli_dli_da_p_0/a_0_0# vdd sky130_fd_pr__nfet_01v8 ad=1.597n pd=0.161m as=1.639n ps=0.163m w=42 l=15
X603 bank_0/port_address_0/wordline_driver_array_0/wordline_driver_10/pnand2_0/pmos_m1_w0_840_sli_dli_0/a_54_0# bank_0/wl_en0 bank_0/port_address_0/wordline_driver_array_0/wordline_driver_10/pnand2_0/pmos_m1_w0_840_sli_dli_0/a_0_0# bank_0/port_address_0/hierarchical_decoder_0/and2_dec_11/pinv_0/w_n127_244# sky130_fd_pr__pfet_01v8 ad=3.193n pd=0.245m as=3.699n ps=0.259m w=84 l=15
X604 bank_0/port_address_0/wordline_driver_array_0/wordline_driver_10/pnand2_0/pmos_m1_w0_840_sli_dli_0/a_0_0# bank_0/port_address_0/wordline_driver_array_0/in_5 bank_0/port_address_0/wordline_driver_array_0/wordline_driver_10/pnand2_0/pmos_m1_w0_840_sli_dli_1/a_0_0# bank_0/port_address_0/hierarchical_decoder_0/and2_dec_11/pinv_0/w_n127_244# sky130_fd_pr__pfet_01v8 ad=0 pd=0 as=3.277n ps=0.247m w=84 l=15
X605 bank_0/port_address_0/wordline_driver_array_0/wordline_driver_10/pnand2_0/nmos_m1_w0_840_sli_dactive_0/D bank_0/port_address_0/wordline_driver_array_0/in_5 bank_0/port_address_0/wordline_driver_array_0/wordline_driver_10/pnand2_0/nmos_m1_w0_840_sli_dactive_0/a_0_0# vdd sky130_fd_pr__nfet_01v8 ad=3.697n pd=0.257m as=3.277n ps=0.247m w=84 l=15
X606 bank_0/port_address_0/wordline_driver_array_0/wordline_driver_10/pnand2_0/nmos_m1_w0_840_sactive_dli_0/a_54_0# bank_0/wl_en0 bank_0/port_address_0/wordline_driver_array_0/wordline_driver_10/pnand2_0/nmos_m1_w0_840_sli_dactive_0/D vdd sky130_fd_pr__nfet_01v8 ad=3.193n pd=0.245m as=0 ps=0 w=84 l=15
X607 bank_0/port_address_0/wordline_driver_array_0/wordline_driver_11/pinv_0/pmos_m1_w0_840_sli_dli_da_p_0/a_54_0# vdd bank_0/port_address_0/wordline_driver_array_0/wordline_driver_11/pinv_0/pmos_m1_w0_840_sli_dli_da_p_0/a_0_0# bank_0/port_address_0/hierarchical_decoder_0/and2_dec_11/pinv_0/w_n127_244# sky130_fd_pr__pfet_01v8 ad=3.193n pd=0.245m as=3.277n ps=0.247m w=84 l=15
X608 bank_0/port_address_0/wordline_driver_array_0/wordline_driver_11/pinv_0/nmos_m1_w0_420_sli_dli_da_p_0/a_54_0# vdd bank_0/port_address_0/wordline_driver_array_0/wordline_driver_11/pinv_0/nmos_m1_w0_420_sli_dli_da_p_0/a_0_0# vdd sky130_fd_pr__nfet_01v8 ad=1.597n pd=0.161m as=1.639n ps=0.163m w=42 l=15
X609 bank_0/port_address_0/wordline_driver_array_0/wordline_driver_11/pnand2_0/pmos_m1_w0_840_sli_dli_0/a_54_0# bank_0/wl_en0 bank_0/port_address_0/wordline_driver_array_0/wordline_driver_11/pnand2_0/pmos_m1_w0_840_sli_dli_0/a_0_0# bank_0/port_address_0/hierarchical_decoder_0/and2_dec_11/pinv_0/w_n127_244# sky130_fd_pr__pfet_01v8 ad=3.193n pd=0.245m as=3.699n ps=0.259m w=84 l=15
X610 bank_0/port_address_0/wordline_driver_array_0/wordline_driver_11/pnand2_0/pmos_m1_w0_840_sli_dli_0/a_0_0# bank_0/port_address_0/wordline_driver_array_0/in_4 bank_0/port_address_0/wordline_driver_array_0/wordline_driver_11/pnand2_0/pmos_m1_w0_840_sli_dli_1/a_0_0# bank_0/port_address_0/hierarchical_decoder_0/and2_dec_11/pinv_0/w_n127_244# sky130_fd_pr__pfet_01v8 ad=0 pd=0 as=3.277n ps=0.247m w=84 l=15
X611 bank_0/port_address_0/wordline_driver_array_0/wordline_driver_11/pnand2_0/nmos_m1_w0_840_sli_dactive_0/D bank_0/port_address_0/wordline_driver_array_0/in_4 bank_0/port_address_0/wordline_driver_array_0/wordline_driver_11/pnand2_0/nmos_m1_w0_840_sli_dactive_0/a_0_0# vdd sky130_fd_pr__nfet_01v8 ad=3.697n pd=0.257m as=3.277n ps=0.247m w=84 l=15
X612 bank_0/port_address_0/wordline_driver_array_0/wordline_driver_11/pnand2_0/nmos_m1_w0_840_sactive_dli_0/a_54_0# bank_0/wl_en0 bank_0/port_address_0/wordline_driver_array_0/wordline_driver_11/pnand2_0/nmos_m1_w0_840_sli_dactive_0/D vdd sky130_fd_pr__nfet_01v8 ad=3.193n pd=0.245m as=0 ps=0 w=84 l=15
X613 bank_0/port_address_0/wordline_driver_array_0/wordline_driver_12/pinv_0/pmos_m1_w0_840_sli_dli_da_p_0/a_54_0# vdd bank_0/port_address_0/wordline_driver_array_0/wordline_driver_12/pinv_0/pmos_m1_w0_840_sli_dli_da_p_0/a_0_0# bank_0/port_address_0/hierarchical_decoder_0/and2_dec_13/pinv_0/w_n127_244# sky130_fd_pr__pfet_01v8 ad=3.193n pd=0.245m as=3.277n ps=0.247m w=84 l=15
X614 bank_0/port_address_0/wordline_driver_array_0/wordline_driver_12/pinv_0/nmos_m1_w0_420_sli_dli_da_p_0/a_54_0# vdd bank_0/port_address_0/wordline_driver_array_0/wordline_driver_12/pinv_0/nmos_m1_w0_420_sli_dli_da_p_0/a_0_0# vdd sky130_fd_pr__nfet_01v8 ad=1.597n pd=0.161m as=1.639n ps=0.163m w=42 l=15
X615 bank_0/port_address_0/wordline_driver_array_0/wordline_driver_12/pnand2_0/pmos_m1_w0_840_sli_dli_0/a_54_0# bank_0/wl_en0 bank_0/port_address_0/wordline_driver_array_0/wordline_driver_12/pnand2_0/pmos_m1_w0_840_sli_dli_0/a_0_0# bank_0/port_address_0/hierarchical_decoder_0/and2_dec_13/pinv_0/w_n127_244# sky130_fd_pr__pfet_01v8 ad=3.193n pd=0.245m as=3.699n ps=0.259m w=84 l=15
X616 bank_0/port_address_0/wordline_driver_array_0/wordline_driver_12/pnand2_0/pmos_m1_w0_840_sli_dli_0/a_0_0# bank_0/port_address_0/wordline_driver_array_0/in_3 bank_0/port_address_0/wordline_driver_array_0/wordline_driver_12/pnand2_0/pmos_m1_w0_840_sli_dli_1/a_0_0# bank_0/port_address_0/hierarchical_decoder_0/and2_dec_13/pinv_0/w_n127_244# sky130_fd_pr__pfet_01v8 ad=0 pd=0 as=3.277n ps=0.247m w=84 l=15
X617 bank_0/port_address_0/wordline_driver_array_0/wordline_driver_12/pnand2_0/nmos_m1_w0_840_sli_dactive_0/D bank_0/port_address_0/wordline_driver_array_0/in_3 bank_0/port_address_0/wordline_driver_array_0/wordline_driver_12/pnand2_0/nmos_m1_w0_840_sli_dactive_0/a_0_0# vdd sky130_fd_pr__nfet_01v8 ad=3.697n pd=0.257m as=3.277n ps=0.247m w=84 l=15
X618 bank_0/port_address_0/wordline_driver_array_0/wordline_driver_12/pnand2_0/nmos_m1_w0_840_sactive_dli_0/a_54_0# bank_0/wl_en0 bank_0/port_address_0/wordline_driver_array_0/wordline_driver_12/pnand2_0/nmos_m1_w0_840_sli_dactive_0/D vdd sky130_fd_pr__nfet_01v8 ad=3.193n pd=0.245m as=0 ps=0 w=84 l=15
X619 bank_0/port_address_0/wordline_driver_array_0/wordline_driver_13/pinv_0/pmos_m1_w0_840_sli_dli_da_p_0/a_54_0# vdd bank_0/port_address_0/wordline_driver_array_0/wordline_driver_13/pinv_0/pmos_m1_w0_840_sli_dli_da_p_0/a_0_0# bank_0/port_address_0/hierarchical_decoder_0/and2_dec_13/pinv_0/w_n127_244# sky130_fd_pr__pfet_01v8 ad=3.193n pd=0.245m as=3.277n ps=0.247m w=84 l=15
X620 bank_0/port_address_0/wordline_driver_array_0/wordline_driver_13/pinv_0/nmos_m1_w0_420_sli_dli_da_p_0/a_54_0# vdd bank_0/port_address_0/wordline_driver_array_0/wordline_driver_13/pinv_0/nmos_m1_w0_420_sli_dli_da_p_0/a_0_0# vdd sky130_fd_pr__nfet_01v8 ad=1.597n pd=0.161m as=1.639n ps=0.163m w=42 l=15
X621 bank_0/port_address_0/wordline_driver_array_0/wordline_driver_13/pnand2_0/pmos_m1_w0_840_sli_dli_0/a_54_0# bank_0/wl_en0 bank_0/port_address_0/wordline_driver_array_0/wordline_driver_13/pnand2_0/pmos_m1_w0_840_sli_dli_0/a_0_0# bank_0/port_address_0/hierarchical_decoder_0/and2_dec_13/pinv_0/w_n127_244# sky130_fd_pr__pfet_01v8 ad=3.193n pd=0.245m as=3.699n ps=0.259m w=84 l=15
X622 bank_0/port_address_0/wordline_driver_array_0/wordline_driver_13/pnand2_0/pmos_m1_w0_840_sli_dli_0/a_0_0# bank_0/port_address_0/wordline_driver_array_0/in_2 bank_0/port_address_0/wordline_driver_array_0/wordline_driver_13/pnand2_0/pmos_m1_w0_840_sli_dli_1/a_0_0# bank_0/port_address_0/hierarchical_decoder_0/and2_dec_13/pinv_0/w_n127_244# sky130_fd_pr__pfet_01v8 ad=0 pd=0 as=3.277n ps=0.247m w=84 l=15
X623 bank_0/port_address_0/wordline_driver_array_0/wordline_driver_13/pnand2_0/nmos_m1_w0_840_sli_dactive_0/D bank_0/port_address_0/wordline_driver_array_0/in_2 bank_0/port_address_0/wordline_driver_array_0/wordline_driver_13/pnand2_0/nmos_m1_w0_840_sli_dactive_0/a_0_0# vdd sky130_fd_pr__nfet_01v8 ad=3.697n pd=0.257m as=3.277n ps=0.247m w=84 l=15
X624 bank_0/port_address_0/wordline_driver_array_0/wordline_driver_13/pnand2_0/nmos_m1_w0_840_sactive_dli_0/a_54_0# bank_0/wl_en0 bank_0/port_address_0/wordline_driver_array_0/wordline_driver_13/pnand2_0/nmos_m1_w0_840_sli_dactive_0/D vdd sky130_fd_pr__nfet_01v8 ad=3.193n pd=0.245m as=0 ps=0 w=84 l=15
X625 bank_0/port_address_0/wordline_driver_array_0/wordline_driver_14/pinv_0/pmos_m1_w0_840_sli_dli_da_p_0/a_54_0# vdd bank_0/port_address_0/wordline_driver_array_0/wordline_driver_14/pinv_0/pmos_m1_w0_840_sli_dli_da_p_0/a_0_0# bank_0/port_address_0/hierarchical_decoder_0/and2_dec_15/pinv_0/w_n127_244# sky130_fd_pr__pfet_01v8 ad=3.193n pd=0.245m as=3.277n ps=0.247m w=84 l=15
X626 bank_0/port_address_0/wordline_driver_array_0/wordline_driver_14/pinv_0/nmos_m1_w0_420_sli_dli_da_p_0/a_54_0# vdd bank_0/port_address_0/wordline_driver_array_0/wordline_driver_14/pinv_0/nmos_m1_w0_420_sli_dli_da_p_0/a_0_0# vdd sky130_fd_pr__nfet_01v8 ad=1.597n pd=0.161m as=1.639n ps=0.163m w=42 l=15
X627 bank_0/port_address_0/wordline_driver_array_0/wordline_driver_14/pnand2_0/pmos_m1_w0_840_sli_dli_0/a_54_0# bank_0/wl_en0 bank_0/port_address_0/wordline_driver_array_0/wordline_driver_14/pnand2_0/pmos_m1_w0_840_sli_dli_0/a_0_0# bank_0/port_address_0/hierarchical_decoder_0/and2_dec_15/pinv_0/w_n127_244# sky130_fd_pr__pfet_01v8 ad=3.193n pd=0.245m as=3.699n ps=0.259m w=84 l=15
X628 bank_0/port_address_0/wordline_driver_array_0/wordline_driver_14/pnand2_0/pmos_m1_w0_840_sli_dli_0/a_0_0# bank_0/port_address_0/wordline_driver_array_0/in_1 bank_0/port_address_0/wordline_driver_array_0/wordline_driver_14/pnand2_0/pmos_m1_w0_840_sli_dli_1/a_0_0# bank_0/port_address_0/hierarchical_decoder_0/and2_dec_15/pinv_0/w_n127_244# sky130_fd_pr__pfet_01v8 ad=0 pd=0 as=3.277n ps=0.247m w=84 l=15
X629 bank_0/port_address_0/wordline_driver_array_0/wordline_driver_14/pnand2_0/nmos_m1_w0_840_sli_dactive_0/D bank_0/port_address_0/wordline_driver_array_0/in_1 bank_0/port_address_0/wordline_driver_array_0/wordline_driver_14/pnand2_0/nmos_m1_w0_840_sli_dactive_0/a_0_0# vdd sky130_fd_pr__nfet_01v8 ad=3.697n pd=0.257m as=3.277n ps=0.247m w=84 l=15
X630 bank_0/port_address_0/wordline_driver_array_0/wordline_driver_14/pnand2_0/nmos_m1_w0_840_sactive_dli_0/a_54_0# bank_0/wl_en0 bank_0/port_address_0/wordline_driver_array_0/wordline_driver_14/pnand2_0/nmos_m1_w0_840_sli_dactive_0/D vdd sky130_fd_pr__nfet_01v8 ad=3.193n pd=0.245m as=0 ps=0 w=84 l=15
X631 bank_0/port_address_0/wordline_driver_array_0/wordline_driver_15/pinv_0/pmos_m1_w0_840_sli_dli_da_p_0/a_54_0# vdd bank_0/port_address_0/wordline_driver_array_0/wordline_driver_15/pinv_0/pmos_m1_w0_840_sli_dli_da_p_0/a_0_0# bank_0/port_address_0/hierarchical_decoder_0/and2_dec_15/pinv_0/w_n127_244# sky130_fd_pr__pfet_01v8 ad=3.193n pd=0.245m as=3.277n ps=0.247m w=84 l=15
X632 bank_0/port_address_0/wordline_driver_array_0/wordline_driver_15/pinv_0/nmos_m1_w0_420_sli_dli_da_p_0/a_54_0# vdd bank_0/port_address_0/wordline_driver_array_0/wordline_driver_15/pinv_0/nmos_m1_w0_420_sli_dli_da_p_0/a_0_0# vdd sky130_fd_pr__nfet_01v8 ad=1.597n pd=0.161m as=1.639n ps=0.163m w=42 l=15
X633 bank_0/port_address_0/wordline_driver_array_0/wordline_driver_15/pnand2_0/pmos_m1_w0_840_sli_dli_0/a_54_0# bank_0/wl_en0 bank_0/port_address_0/wordline_driver_array_0/wordline_driver_15/pnand2_0/pmos_m1_w0_840_sli_dli_0/a_0_0# bank_0/port_address_0/hierarchical_decoder_0/and2_dec_15/pinv_0/w_n127_244# sky130_fd_pr__pfet_01v8 ad=3.193n pd=0.245m as=3.699n ps=0.259m w=84 l=15
X634 bank_0/port_address_0/wordline_driver_array_0/wordline_driver_15/pnand2_0/pmos_m1_w0_840_sli_dli_0/a_0_0# bank_0/port_address_0/wordline_driver_array_0/in_0 bank_0/port_address_0/wordline_driver_array_0/wordline_driver_15/pnand2_0/pmos_m1_w0_840_sli_dli_1/a_0_0# bank_0/port_address_0/hierarchical_decoder_0/and2_dec_15/pinv_0/w_n127_244# sky130_fd_pr__pfet_01v8 ad=0 pd=0 as=3.277n ps=0.247m w=84 l=15
X635 bank_0/port_address_0/wordline_driver_array_0/wordline_driver_15/pnand2_0/nmos_m1_w0_840_sli_dactive_0/D bank_0/port_address_0/wordline_driver_array_0/in_0 bank_0/port_address_0/wordline_driver_array_0/wordline_driver_15/pnand2_0/nmos_m1_w0_840_sli_dactive_0/a_0_0# vdd sky130_fd_pr__nfet_01v8 ad=3.697n pd=0.257m as=3.277n ps=0.247m w=84 l=15
X636 bank_0/port_address_0/wordline_driver_array_0/wordline_driver_15/pnand2_0/nmos_m1_w0_840_sactive_dli_0/a_54_0# bank_0/wl_en0 bank_0/port_address_0/wordline_driver_array_0/wordline_driver_15/pnand2_0/nmos_m1_w0_840_sli_dactive_0/D vdd sky130_fd_pr__nfet_01v8 ad=3.193n pd=0.245m as=0 ps=0 w=84 l=15
X637 bank_0/port_address_0/wordline_driver_array_0/wordline_driver_0/pinv_0/pmos_m1_w0_840_sli_dli_da_p_0/a_54_0# vdd bank_0/port_address_0/wordline_driver_array_0/wordline_driver_0/pinv_0/pmos_m1_w0_840_sli_dli_da_p_0/a_0_0# bank_0/port_address_0/hierarchical_decoder_0/and2_dec_1/pinv_0/w_n127_244# sky130_fd_pr__pfet_01v8 ad=3.193n pd=0.245m as=3.277n ps=0.247m w=84 l=15
X638 bank_0/port_address_0/wordline_driver_array_0/wordline_driver_0/pinv_0/nmos_m1_w0_420_sli_dli_da_p_0/a_54_0# vdd bank_0/port_address_0/wordline_driver_array_0/wordline_driver_0/pinv_0/nmos_m1_w0_420_sli_dli_da_p_0/a_0_0# vdd sky130_fd_pr__nfet_01v8 ad=1.597n pd=0.161m as=1.639n ps=0.163m w=42 l=15
X639 bank_0/port_address_0/wordline_driver_array_0/wordline_driver_0/pnand2_0/pmos_m1_w0_840_sli_dli_0/a_54_0# bank_0/wl_en0 bank_0/port_address_0/wordline_driver_array_0/wordline_driver_0/pnand2_0/pmos_m1_w0_840_sli_dli_0/a_0_0# bank_0/port_address_0/hierarchical_decoder_0/and2_dec_1/pinv_0/w_n127_244# sky130_fd_pr__pfet_01v8 ad=3.193n pd=0.245m as=3.699n ps=0.259m w=84 l=15
X640 bank_0/port_address_0/wordline_driver_array_0/wordline_driver_0/pnand2_0/pmos_m1_w0_840_sli_dli_0/a_0_0# bank_0/port_address_0/wordline_driver_array_0/in_15 bank_0/port_address_0/wordline_driver_array_0/wordline_driver_0/pnand2_0/pmos_m1_w0_840_sli_dli_1/a_0_0# bank_0/port_address_0/hierarchical_decoder_0/and2_dec_1/pinv_0/w_n127_244# sky130_fd_pr__pfet_01v8 ad=0 pd=0 as=3.277n ps=0.247m w=84 l=15
X641 bank_0/port_address_0/wordline_driver_array_0/wordline_driver_0/pnand2_0/nmos_m1_w0_840_sli_dactive_0/D bank_0/port_address_0/wordline_driver_array_0/in_15 bank_0/port_address_0/wordline_driver_array_0/wordline_driver_0/pnand2_0/nmos_m1_w0_840_sli_dactive_0/a_0_0# vdd sky130_fd_pr__nfet_01v8 ad=3.697n pd=0.257m as=3.277n ps=0.247m w=84 l=15
X642 bank_0/port_address_0/wordline_driver_array_0/wordline_driver_0/pnand2_0/nmos_m1_w0_840_sactive_dli_0/a_54_0# bank_0/wl_en0 bank_0/port_address_0/wordline_driver_array_0/wordline_driver_0/pnand2_0/nmos_m1_w0_840_sli_dactive_0/D vdd sky130_fd_pr__nfet_01v8 ad=3.193n pd=0.245m as=0 ps=0 w=84 l=15
X643 bank_0/port_address_0/wordline_driver_array_0/wordline_driver_1/pinv_0/pmos_m1_w0_840_sli_dli_da_p_0/a_54_0# vdd bank_0/port_address_0/wordline_driver_array_0/wordline_driver_1/pinv_0/pmos_m1_w0_840_sli_dli_da_p_0/a_0_0# bank_0/port_address_0/hierarchical_decoder_0/and2_dec_1/pinv_0/w_n127_244# sky130_fd_pr__pfet_01v8 ad=3.193n pd=0.245m as=3.277n ps=0.247m w=84 l=15
X644 bank_0/port_address_0/wordline_driver_array_0/wordline_driver_1/pinv_0/nmos_m1_w0_420_sli_dli_da_p_0/a_54_0# vdd bank_0/port_address_0/wordline_driver_array_0/wordline_driver_1/pinv_0/nmos_m1_w0_420_sli_dli_da_p_0/a_0_0# vdd sky130_fd_pr__nfet_01v8 ad=1.597n pd=0.161m as=1.639n ps=0.163m w=42 l=15
X645 bank_0/port_address_0/wordline_driver_array_0/wordline_driver_1/pnand2_0/pmos_m1_w0_840_sli_dli_0/a_54_0# bank_0/wl_en0 bank_0/port_address_0/wordline_driver_array_0/wordline_driver_1/pnand2_0/pmos_m1_w0_840_sli_dli_0/a_0_0# bank_0/port_address_0/hierarchical_decoder_0/and2_dec_1/pinv_0/w_n127_244# sky130_fd_pr__pfet_01v8 ad=3.193n pd=0.245m as=3.699n ps=0.259m w=84 l=15
X646 bank_0/port_address_0/wordline_driver_array_0/wordline_driver_1/pnand2_0/pmos_m1_w0_840_sli_dli_0/a_0_0# bank_0/port_address_0/wordline_driver_array_0/in_14 bank_0/port_address_0/wordline_driver_array_0/wordline_driver_1/pnand2_0/pmos_m1_w0_840_sli_dli_1/a_0_0# bank_0/port_address_0/hierarchical_decoder_0/and2_dec_1/pinv_0/w_n127_244# sky130_fd_pr__pfet_01v8 ad=0 pd=0 as=3.277n ps=0.247m w=84 l=15
X647 bank_0/port_address_0/wordline_driver_array_0/wordline_driver_1/pnand2_0/nmos_m1_w0_840_sli_dactive_0/D bank_0/port_address_0/wordline_driver_array_0/in_14 bank_0/port_address_0/wordline_driver_array_0/wordline_driver_1/pnand2_0/nmos_m1_w0_840_sli_dactive_0/a_0_0# vdd sky130_fd_pr__nfet_01v8 ad=3.697n pd=0.257m as=3.277n ps=0.247m w=84 l=15
X648 bank_0/port_address_0/wordline_driver_array_0/wordline_driver_1/pnand2_0/nmos_m1_w0_840_sactive_dli_0/a_54_0# bank_0/wl_en0 bank_0/port_address_0/wordline_driver_array_0/wordline_driver_1/pnand2_0/nmos_m1_w0_840_sli_dactive_0/D vdd sky130_fd_pr__nfet_01v8 ad=3.193n pd=0.245m as=0 ps=0 w=84 l=15
X649 bank_0/port_address_0/wordline_driver_array_0/wordline_driver_2/pinv_0/pmos_m1_w0_840_sli_dli_da_p_0/a_54_0# vdd bank_0/port_address_0/wordline_driver_array_0/wordline_driver_2/pinv_0/pmos_m1_w0_840_sli_dli_da_p_0/a_0_0# bank_0/port_address_0/hierarchical_decoder_0/and2_dec_3/pinv_0/w_n127_244# sky130_fd_pr__pfet_01v8 ad=3.193n pd=0.245m as=3.277n ps=0.247m w=84 l=15
X650 bank_0/port_address_0/wordline_driver_array_0/wordline_driver_2/pinv_0/nmos_m1_w0_420_sli_dli_da_p_0/a_54_0# vdd bank_0/port_address_0/wordline_driver_array_0/wordline_driver_2/pinv_0/nmos_m1_w0_420_sli_dli_da_p_0/a_0_0# vdd sky130_fd_pr__nfet_01v8 ad=1.597n pd=0.161m as=1.639n ps=0.163m w=42 l=15
X651 bank_0/port_address_0/wordline_driver_array_0/wordline_driver_2/pnand2_0/pmos_m1_w0_840_sli_dli_0/a_54_0# bank_0/wl_en0 bank_0/port_address_0/wordline_driver_array_0/wordline_driver_2/pnand2_0/pmos_m1_w0_840_sli_dli_0/a_0_0# bank_0/port_address_0/hierarchical_decoder_0/and2_dec_3/pinv_0/w_n127_244# sky130_fd_pr__pfet_01v8 ad=3.193n pd=0.245m as=3.699n ps=0.259m w=84 l=15
X652 bank_0/port_address_0/wordline_driver_array_0/wordline_driver_2/pnand2_0/pmos_m1_w0_840_sli_dli_0/a_0_0# bank_0/port_address_0/wordline_driver_array_0/in_13 bank_0/port_address_0/wordline_driver_array_0/wordline_driver_2/pnand2_0/pmos_m1_w0_840_sli_dli_1/a_0_0# bank_0/port_address_0/hierarchical_decoder_0/and2_dec_3/pinv_0/w_n127_244# sky130_fd_pr__pfet_01v8 ad=0 pd=0 as=3.277n ps=0.247m w=84 l=15
X653 bank_0/port_address_0/wordline_driver_array_0/wordline_driver_2/pnand2_0/nmos_m1_w0_840_sli_dactive_0/D bank_0/port_address_0/wordline_driver_array_0/in_13 bank_0/port_address_0/wordline_driver_array_0/wordline_driver_2/pnand2_0/nmos_m1_w0_840_sli_dactive_0/a_0_0# vdd sky130_fd_pr__nfet_01v8 ad=3.697n pd=0.257m as=3.277n ps=0.247m w=84 l=15
X654 bank_0/port_address_0/wordline_driver_array_0/wordline_driver_2/pnand2_0/nmos_m1_w0_840_sactive_dli_0/a_54_0# bank_0/wl_en0 bank_0/port_address_0/wordline_driver_array_0/wordline_driver_2/pnand2_0/nmos_m1_w0_840_sli_dactive_0/D vdd sky130_fd_pr__nfet_01v8 ad=3.193n pd=0.245m as=0 ps=0 w=84 l=15
X655 bank_0/port_address_0/wordline_driver_array_0/wordline_driver_3/pinv_0/pmos_m1_w0_840_sli_dli_da_p_0/a_54_0# vdd bank_0/port_address_0/wordline_driver_array_0/wordline_driver_3/pinv_0/pmos_m1_w0_840_sli_dli_da_p_0/a_0_0# bank_0/port_address_0/hierarchical_decoder_0/and2_dec_3/pinv_0/w_n127_244# sky130_fd_pr__pfet_01v8 ad=3.193n pd=0.245m as=3.277n ps=0.247m w=84 l=15
X656 bank_0/port_address_0/wordline_driver_array_0/wordline_driver_3/pinv_0/nmos_m1_w0_420_sli_dli_da_p_0/a_54_0# vdd bank_0/port_address_0/wordline_driver_array_0/wordline_driver_3/pinv_0/nmos_m1_w0_420_sli_dli_da_p_0/a_0_0# vdd sky130_fd_pr__nfet_01v8 ad=1.597n pd=0.161m as=1.639n ps=0.163m w=42 l=15
X657 bank_0/port_address_0/wordline_driver_array_0/wordline_driver_3/pnand2_0/pmos_m1_w0_840_sli_dli_0/a_54_0# bank_0/wl_en0 bank_0/port_address_0/wordline_driver_array_0/wordline_driver_3/pnand2_0/pmos_m1_w0_840_sli_dli_0/a_0_0# bank_0/port_address_0/hierarchical_decoder_0/and2_dec_3/pinv_0/w_n127_244# sky130_fd_pr__pfet_01v8 ad=3.193n pd=0.245m as=3.699n ps=0.259m w=84 l=15
X658 bank_0/port_address_0/wordline_driver_array_0/wordline_driver_3/pnand2_0/pmos_m1_w0_840_sli_dli_0/a_0_0# bank_0/port_address_0/wordline_driver_array_0/in_12 bank_0/port_address_0/wordline_driver_array_0/wordline_driver_3/pnand2_0/pmos_m1_w0_840_sli_dli_1/a_0_0# bank_0/port_address_0/hierarchical_decoder_0/and2_dec_3/pinv_0/w_n127_244# sky130_fd_pr__pfet_01v8 ad=0 pd=0 as=3.277n ps=0.247m w=84 l=15
X659 bank_0/port_address_0/wordline_driver_array_0/wordline_driver_3/pnand2_0/nmos_m1_w0_840_sli_dactive_0/D bank_0/port_address_0/wordline_driver_array_0/in_12 bank_0/port_address_0/wordline_driver_array_0/wordline_driver_3/pnand2_0/nmos_m1_w0_840_sli_dactive_0/a_0_0# vdd sky130_fd_pr__nfet_01v8 ad=3.697n pd=0.257m as=3.277n ps=0.247m w=84 l=15
X660 bank_0/port_address_0/wordline_driver_array_0/wordline_driver_3/pnand2_0/nmos_m1_w0_840_sactive_dli_0/a_54_0# bank_0/wl_en0 bank_0/port_address_0/wordline_driver_array_0/wordline_driver_3/pnand2_0/nmos_m1_w0_840_sli_dactive_0/D vdd sky130_fd_pr__nfet_01v8 ad=3.193n pd=0.245m as=0 ps=0 w=84 l=15
X661 bank_0/port_address_0/wordline_driver_array_0/wordline_driver_4/pinv_0/pmos_m1_w0_840_sli_dli_da_p_0/a_54_0# vdd bank_0/port_address_0/wordline_driver_array_0/wordline_driver_4/pinv_0/pmos_m1_w0_840_sli_dli_da_p_0/a_0_0# bank_0/port_address_0/hierarchical_decoder_0/and2_dec_5/pinv_0/w_n127_244# sky130_fd_pr__pfet_01v8 ad=3.193n pd=0.245m as=3.277n ps=0.247m w=84 l=15
X662 bank_0/port_address_0/wordline_driver_array_0/wordline_driver_4/pinv_0/nmos_m1_w0_420_sli_dli_da_p_0/a_54_0# vdd bank_0/port_address_0/wordline_driver_array_0/wordline_driver_4/pinv_0/nmos_m1_w0_420_sli_dli_da_p_0/a_0_0# vdd sky130_fd_pr__nfet_01v8 ad=1.597n pd=0.161m as=1.639n ps=0.163m w=42 l=15
X663 bank_0/port_address_0/wordline_driver_array_0/wordline_driver_4/pnand2_0/pmos_m1_w0_840_sli_dli_0/a_54_0# bank_0/wl_en0 bank_0/port_address_0/wordline_driver_array_0/wordline_driver_4/pnand2_0/pmos_m1_w0_840_sli_dli_0/a_0_0# bank_0/port_address_0/hierarchical_decoder_0/and2_dec_5/pinv_0/w_n127_244# sky130_fd_pr__pfet_01v8 ad=3.193n pd=0.245m as=3.699n ps=0.259m w=84 l=15
X664 bank_0/port_address_0/wordline_driver_array_0/wordline_driver_4/pnand2_0/pmos_m1_w0_840_sli_dli_0/a_0_0# bank_0/port_address_0/wordline_driver_array_0/in_11 bank_0/port_address_0/wordline_driver_array_0/wordline_driver_4/pnand2_0/pmos_m1_w0_840_sli_dli_1/a_0_0# bank_0/port_address_0/hierarchical_decoder_0/and2_dec_5/pinv_0/w_n127_244# sky130_fd_pr__pfet_01v8 ad=0 pd=0 as=3.277n ps=0.247m w=84 l=15
X665 bank_0/port_address_0/wordline_driver_array_0/wordline_driver_4/pnand2_0/nmos_m1_w0_840_sli_dactive_0/D bank_0/port_address_0/wordline_driver_array_0/in_11 bank_0/port_address_0/wordline_driver_array_0/wordline_driver_4/pnand2_0/nmos_m1_w0_840_sli_dactive_0/a_0_0# vdd sky130_fd_pr__nfet_01v8 ad=3.697n pd=0.257m as=3.277n ps=0.247m w=84 l=15
X666 bank_0/port_address_0/wordline_driver_array_0/wordline_driver_4/pnand2_0/nmos_m1_w0_840_sactive_dli_0/a_54_0# bank_0/wl_en0 bank_0/port_address_0/wordline_driver_array_0/wordline_driver_4/pnand2_0/nmos_m1_w0_840_sli_dactive_0/D vdd sky130_fd_pr__nfet_01v8 ad=3.193n pd=0.245m as=0 ps=0 w=84 l=15
X667 bank_0/port_address_0/wordline_driver_array_0/wordline_driver_5/pinv_0/pmos_m1_w0_840_sli_dli_da_p_0/a_54_0# vdd bank_0/port_address_0/wordline_driver_array_0/wordline_driver_5/pinv_0/pmos_m1_w0_840_sli_dli_da_p_0/a_0_0# bank_0/port_address_0/hierarchical_decoder_0/and2_dec_5/pinv_0/w_n127_244# sky130_fd_pr__pfet_01v8 ad=3.193n pd=0.245m as=3.277n ps=0.247m w=84 l=15
X668 bank_0/port_address_0/wordline_driver_array_0/wordline_driver_5/pinv_0/nmos_m1_w0_420_sli_dli_da_p_0/a_54_0# vdd bank_0/port_address_0/wordline_driver_array_0/wordline_driver_5/pinv_0/nmos_m1_w0_420_sli_dli_da_p_0/a_0_0# vdd sky130_fd_pr__nfet_01v8 ad=1.597n pd=0.161m as=1.639n ps=0.163m w=42 l=15
X669 bank_0/port_address_0/wordline_driver_array_0/wordline_driver_5/pnand2_0/pmos_m1_w0_840_sli_dli_0/a_54_0# bank_0/wl_en0 bank_0/port_address_0/wordline_driver_array_0/wordline_driver_5/pnand2_0/pmos_m1_w0_840_sli_dli_0/a_0_0# bank_0/port_address_0/hierarchical_decoder_0/and2_dec_5/pinv_0/w_n127_244# sky130_fd_pr__pfet_01v8 ad=3.193n pd=0.245m as=3.699n ps=0.259m w=84 l=15
X670 bank_0/port_address_0/wordline_driver_array_0/wordline_driver_5/pnand2_0/pmos_m1_w0_840_sli_dli_0/a_0_0# bank_0/port_address_0/wordline_driver_array_0/in_10 bank_0/port_address_0/wordline_driver_array_0/wordline_driver_5/pnand2_0/pmos_m1_w0_840_sli_dli_1/a_0_0# bank_0/port_address_0/hierarchical_decoder_0/and2_dec_5/pinv_0/w_n127_244# sky130_fd_pr__pfet_01v8 ad=0 pd=0 as=3.277n ps=0.247m w=84 l=15
X671 bank_0/port_address_0/wordline_driver_array_0/wordline_driver_5/pnand2_0/nmos_m1_w0_840_sli_dactive_0/D bank_0/port_address_0/wordline_driver_array_0/in_10 bank_0/port_address_0/wordline_driver_array_0/wordline_driver_5/pnand2_0/nmos_m1_w0_840_sli_dactive_0/a_0_0# vdd sky130_fd_pr__nfet_01v8 ad=3.697n pd=0.257m as=3.277n ps=0.247m w=84 l=15
X672 bank_0/port_address_0/wordline_driver_array_0/wordline_driver_5/pnand2_0/nmos_m1_w0_840_sactive_dli_0/a_54_0# bank_0/wl_en0 bank_0/port_address_0/wordline_driver_array_0/wordline_driver_5/pnand2_0/nmos_m1_w0_840_sli_dactive_0/D vdd sky130_fd_pr__nfet_01v8 ad=3.193n pd=0.245m as=0 ps=0 w=84 l=15
X673 bank_0/port_address_0/wordline_driver_array_0/wordline_driver_6/pinv_0/pmos_m1_w0_840_sli_dli_da_p_0/a_54_0# vdd bank_0/port_address_0/wordline_driver_array_0/wordline_driver_6/pinv_0/pmos_m1_w0_840_sli_dli_da_p_0/a_0_0# bank_0/port_address_0/hierarchical_decoder_0/and2_dec_7/pinv_0/w_n127_244# sky130_fd_pr__pfet_01v8 ad=3.193n pd=0.245m as=3.277n ps=0.247m w=84 l=15
X674 bank_0/port_address_0/wordline_driver_array_0/wordline_driver_6/pinv_0/nmos_m1_w0_420_sli_dli_da_p_0/a_54_0# vdd bank_0/port_address_0/wordline_driver_array_0/wordline_driver_6/pinv_0/nmos_m1_w0_420_sli_dli_da_p_0/a_0_0# vdd sky130_fd_pr__nfet_01v8 ad=1.597n pd=0.161m as=1.639n ps=0.163m w=42 l=15
X675 bank_0/port_address_0/wordline_driver_array_0/wordline_driver_6/pnand2_0/pmos_m1_w0_840_sli_dli_0/a_54_0# bank_0/wl_en0 bank_0/port_address_0/wordline_driver_array_0/wordline_driver_6/pnand2_0/pmos_m1_w0_840_sli_dli_0/a_0_0# bank_0/port_address_0/hierarchical_decoder_0/and2_dec_7/pinv_0/w_n127_244# sky130_fd_pr__pfet_01v8 ad=3.193n pd=0.245m as=3.699n ps=0.259m w=84 l=15
X676 bank_0/port_address_0/wordline_driver_array_0/wordline_driver_6/pnand2_0/pmos_m1_w0_840_sli_dli_0/a_0_0# bank_0/port_address_0/wordline_driver_array_0/in_9 bank_0/port_address_0/wordline_driver_array_0/wordline_driver_6/pnand2_0/pmos_m1_w0_840_sli_dli_1/a_0_0# bank_0/port_address_0/hierarchical_decoder_0/and2_dec_7/pinv_0/w_n127_244# sky130_fd_pr__pfet_01v8 ad=0 pd=0 as=3.277n ps=0.247m w=84 l=15
X677 bank_0/port_address_0/wordline_driver_array_0/wordline_driver_6/pnand2_0/nmos_m1_w0_840_sli_dactive_0/D bank_0/port_address_0/wordline_driver_array_0/in_9 bank_0/port_address_0/wordline_driver_array_0/wordline_driver_6/pnand2_0/nmos_m1_w0_840_sli_dactive_0/a_0_0# vdd sky130_fd_pr__nfet_01v8 ad=3.697n pd=0.257m as=3.277n ps=0.247m w=84 l=15
X678 bank_0/port_address_0/wordline_driver_array_0/wordline_driver_6/pnand2_0/nmos_m1_w0_840_sactive_dli_0/a_54_0# bank_0/wl_en0 bank_0/port_address_0/wordline_driver_array_0/wordline_driver_6/pnand2_0/nmos_m1_w0_840_sli_dactive_0/D vdd sky130_fd_pr__nfet_01v8 ad=3.193n pd=0.245m as=0 ps=0 w=84 l=15
X679 bank_0/port_address_0/wordline_driver_array_0/wordline_driver_7/pinv_0/pmos_m1_w0_840_sli_dli_da_p_0/a_54_0# vdd bank_0/port_address_0/wordline_driver_array_0/wordline_driver_7/pinv_0/pmos_m1_w0_840_sli_dli_da_p_0/a_0_0# bank_0/port_address_0/hierarchical_decoder_0/and2_dec_7/pinv_0/w_n127_244# sky130_fd_pr__pfet_01v8 ad=3.193n pd=0.245m as=3.277n ps=0.247m w=84 l=15
X680 bank_0/port_address_0/wordline_driver_array_0/wordline_driver_7/pinv_0/nmos_m1_w0_420_sli_dli_da_p_0/a_54_0# vdd bank_0/port_address_0/wordline_driver_array_0/wordline_driver_7/pinv_0/nmos_m1_w0_420_sli_dli_da_p_0/a_0_0# vdd sky130_fd_pr__nfet_01v8 ad=1.597n pd=0.161m as=1.639n ps=0.163m w=42 l=15
X681 bank_0/port_address_0/wordline_driver_array_0/wordline_driver_7/pnand2_0/pmos_m1_w0_840_sli_dli_0/a_54_0# bank_0/wl_en0 bank_0/port_address_0/wordline_driver_array_0/wordline_driver_7/pnand2_0/pmos_m1_w0_840_sli_dli_0/a_0_0# bank_0/port_address_0/hierarchical_decoder_0/and2_dec_7/pinv_0/w_n127_244# sky130_fd_pr__pfet_01v8 ad=3.193n pd=0.245m as=3.699n ps=0.259m w=84 l=15
X682 bank_0/port_address_0/wordline_driver_array_0/wordline_driver_7/pnand2_0/pmos_m1_w0_840_sli_dli_0/a_0_0# bank_0/port_address_0/wordline_driver_array_0/in_8 bank_0/port_address_0/wordline_driver_array_0/wordline_driver_7/pnand2_0/pmos_m1_w0_840_sli_dli_1/a_0_0# bank_0/port_address_0/hierarchical_decoder_0/and2_dec_7/pinv_0/w_n127_244# sky130_fd_pr__pfet_01v8 ad=0 pd=0 as=3.277n ps=0.247m w=84 l=15
X683 bank_0/port_address_0/wordline_driver_array_0/wordline_driver_7/pnand2_0/nmos_m1_w0_840_sli_dactive_0/D bank_0/port_address_0/wordline_driver_array_0/in_8 bank_0/port_address_0/wordline_driver_array_0/wordline_driver_7/pnand2_0/nmos_m1_w0_840_sli_dactive_0/a_0_0# vdd sky130_fd_pr__nfet_01v8 ad=3.697n pd=0.257m as=3.277n ps=0.247m w=84 l=15
X684 bank_0/port_address_0/wordline_driver_array_0/wordline_driver_7/pnand2_0/nmos_m1_w0_840_sactive_dli_0/a_54_0# bank_0/wl_en0 bank_0/port_address_0/wordline_driver_array_0/wordline_driver_7/pnand2_0/nmos_m1_w0_840_sli_dactive_0/D vdd sky130_fd_pr__nfet_01v8 ad=3.193n pd=0.245m as=0 ps=0 w=84 l=15
X685 bank_0/port_address_0/wordline_driver_array_0/wordline_driver_8/pinv_0/pmos_m1_w0_840_sli_dli_da_p_0/a_54_0# vdd bank_0/port_address_0/wordline_driver_array_0/wordline_driver_8/pinv_0/pmos_m1_w0_840_sli_dli_da_p_0/a_0_0# bank_0/port_address_0/hierarchical_decoder_0/and2_dec_9/pinv_0/w_n127_244# sky130_fd_pr__pfet_01v8 ad=3.193n pd=0.245m as=3.277n ps=0.247m w=84 l=15
X686 bank_0/port_address_0/wordline_driver_array_0/wordline_driver_8/pinv_0/nmos_m1_w0_420_sli_dli_da_p_0/a_54_0# vdd bank_0/port_address_0/wordline_driver_array_0/wordline_driver_8/pinv_0/nmos_m1_w0_420_sli_dli_da_p_0/a_0_0# vdd sky130_fd_pr__nfet_01v8 ad=1.597n pd=0.161m as=1.639n ps=0.163m w=42 l=15
X687 bank_0/port_address_0/wordline_driver_array_0/wordline_driver_8/pnand2_0/pmos_m1_w0_840_sli_dli_0/a_54_0# bank_0/wl_en0 bank_0/port_address_0/wordline_driver_array_0/wordline_driver_8/pnand2_0/pmos_m1_w0_840_sli_dli_0/a_0_0# bank_0/port_address_0/hierarchical_decoder_0/and2_dec_9/pinv_0/w_n127_244# sky130_fd_pr__pfet_01v8 ad=3.193n pd=0.245m as=3.699n ps=0.259m w=84 l=15
X688 bank_0/port_address_0/wordline_driver_array_0/wordline_driver_8/pnand2_0/pmos_m1_w0_840_sli_dli_0/a_0_0# bank_0/port_address_0/wordline_driver_array_0/in_7 bank_0/port_address_0/wordline_driver_array_0/wordline_driver_8/pnand2_0/pmos_m1_w0_840_sli_dli_1/a_0_0# bank_0/port_address_0/hierarchical_decoder_0/and2_dec_9/pinv_0/w_n127_244# sky130_fd_pr__pfet_01v8 ad=0 pd=0 as=3.277n ps=0.247m w=84 l=15
X689 bank_0/port_address_0/wordline_driver_array_0/wordline_driver_8/pnand2_0/nmos_m1_w0_840_sli_dactive_0/D bank_0/port_address_0/wordline_driver_array_0/in_7 bank_0/port_address_0/wordline_driver_array_0/wordline_driver_8/pnand2_0/nmos_m1_w0_840_sli_dactive_0/a_0_0# vdd sky130_fd_pr__nfet_01v8 ad=3.697n pd=0.257m as=3.277n ps=0.247m w=84 l=15
X690 bank_0/port_address_0/wordline_driver_array_0/wordline_driver_8/pnand2_0/nmos_m1_w0_840_sactive_dli_0/a_54_0# bank_0/wl_en0 bank_0/port_address_0/wordline_driver_array_0/wordline_driver_8/pnand2_0/nmos_m1_w0_840_sli_dactive_0/D vdd sky130_fd_pr__nfet_01v8 ad=3.193n pd=0.245m as=0 ps=0 w=84 l=15
X691 bank_0/port_address_0/wordline_driver_array_0/wordline_driver_9/pinv_0/pmos_m1_w0_840_sli_dli_da_p_0/a_54_0# vdd bank_0/port_address_0/wordline_driver_array_0/wordline_driver_9/pinv_0/pmos_m1_w0_840_sli_dli_da_p_0/a_0_0# bank_0/port_address_0/hierarchical_decoder_0/and2_dec_9/pinv_0/w_n127_244# sky130_fd_pr__pfet_01v8 ad=3.193n pd=0.245m as=3.277n ps=0.247m w=84 l=15
X692 bank_0/port_address_0/wordline_driver_array_0/wordline_driver_9/pinv_0/nmos_m1_w0_420_sli_dli_da_p_0/a_54_0# vdd bank_0/port_address_0/wordline_driver_array_0/wordline_driver_9/pinv_0/nmos_m1_w0_420_sli_dli_da_p_0/a_0_0# vdd sky130_fd_pr__nfet_01v8 ad=1.597n pd=0.161m as=1.639n ps=0.163m w=42 l=15
X693 bank_0/port_address_0/wordline_driver_array_0/wordline_driver_9/pnand2_0/pmos_m1_w0_840_sli_dli_0/a_54_0# bank_0/wl_en0 bank_0/port_address_0/wordline_driver_array_0/wordline_driver_9/pnand2_0/pmos_m1_w0_840_sli_dli_0/a_0_0# bank_0/port_address_0/hierarchical_decoder_0/and2_dec_9/pinv_0/w_n127_244# sky130_fd_pr__pfet_01v8 ad=3.193n pd=0.245m as=3.699n ps=0.259m w=84 l=15
X694 bank_0/port_address_0/wordline_driver_array_0/wordline_driver_9/pnand2_0/pmos_m1_w0_840_sli_dli_0/a_0_0# bank_0/port_address_0/wordline_driver_array_0/in_6 bank_0/port_address_0/wordline_driver_array_0/wordline_driver_9/pnand2_0/pmos_m1_w0_840_sli_dli_1/a_0_0# bank_0/port_address_0/hierarchical_decoder_0/and2_dec_9/pinv_0/w_n127_244# sky130_fd_pr__pfet_01v8 ad=0 pd=0 as=3.277n ps=0.247m w=84 l=15
X695 bank_0/port_address_0/wordline_driver_array_0/wordline_driver_9/pnand2_0/nmos_m1_w0_840_sli_dactive_0/D bank_0/port_address_0/wordline_driver_array_0/in_6 bank_0/port_address_0/wordline_driver_array_0/wordline_driver_9/pnand2_0/nmos_m1_w0_840_sli_dactive_0/a_0_0# vdd sky130_fd_pr__nfet_01v8 ad=3.697n pd=0.257m as=3.277n ps=0.247m w=84 l=15
X696 bank_0/port_address_0/wordline_driver_array_0/wordline_driver_9/pnand2_0/nmos_m1_w0_840_sactive_dli_0/a_54_0# bank_0/wl_en0 bank_0/port_address_0/wordline_driver_array_0/wordline_driver_9/pnand2_0/nmos_m1_w0_840_sli_dactive_0/D vdd sky130_fd_pr__nfet_01v8 ad=3.193n pd=0.245m as=0 ps=0 w=84 l=15
X697 bank_0/replica_bitcell_array_0/dummy_array_0/dummy_cell_1rw_0/q bank_0/replica_bitcell_array_0/dummy_array_0/dummy_cell_1rw_0/qb vdd vdd sky130_fd_pr__pfet_01v8 ad=1.925n pd=0.18m as=1.925n ps=0.18m w=55 l=15
X698 vdd bank_0/replica_bitcell_array_0/dummy_array_0/dummy_cell_1rw_0/q bank_0/replica_bitcell_array_0/dummy_array_0/dummy_cell_1rw_0/qb vdd sky130_fd_pr__nfet_01v8 ad=4.41n pd=0.322m as=3.864n ps=0.21m w=126 l=15
X699 bank_0/replica_bitcell_array_0/dummy_array_0/dummy_cell_1rw_0/q bank_0/replica_bitcell_array_0/dummy_array_0/dummy_cell_1rw_0/qb vdd vdd sky130_fd_pr__nfet_01v8 ad=3.864n pd=0.21m as=4.41n ps=0.322m w=126 l=15
X700 bank_0/replica_bitcell_array_0/dummy_array_0/dummy_cell_1rw_0/qb bank_0/port_address_0/rbl_wl bank_0/replica_bitcell_array_0/dummy_array_0/dummy_cell_1rw_0/a_145_76# vdd sky130_fd_pr__nfet_01v8 ad=3.864n pd=0.21m as=1.428n ps=0.152m w=42 l=15
X701 vdd bank_0/replica_bitcell_array_0/dummy_array_0/dummy_cell_1rw_0/q bank_0/replica_bitcell_array_0/dummy_array_0/dummy_cell_1rw_0/qb vdd sky130_fd_pr__pfet_01v8 ad=1.925n pd=0.18m as=1.925n ps=0.18m w=55 l=15
X702 bank_0/replica_bitcell_array_0/dummy_array_0/dummy_cell_1rw_0/q bank_0/port_address_0/rbl_wl bank_0/replica_bitcell_array_0/dummy_array_0/dummy_cell_1rw_0/a_76_76# vdd sky130_fd_pr__nfet_01v8 ad=3.864n pd=0.21m as=1.428n ps=0.152m w=42 l=15
X703 bank_0/replica_bitcell_array_0/dummy_array_0/dummy_cell_1rw_1/q bank_0/replica_bitcell_array_0/dummy_array_0/dummy_cell_1rw_1/qb vdd vdd sky130_fd_pr__pfet_01v8 ad=1.925n pd=0.18m as=0 ps=0 w=55 l=15
X704 vdd bank_0/replica_bitcell_array_0/dummy_array_0/dummy_cell_1rw_1/q bank_0/replica_bitcell_array_0/dummy_array_0/dummy_cell_1rw_1/qb vdd sky130_fd_pr__nfet_01v8 ad=0 pd=0 as=7.728n ps=0.42m w=126 l=15
X705 bank_0/replica_bitcell_array_0/dummy_array_0/dummy_cell_1rw_1/q bank_0/replica_bitcell_array_0/dummy_array_0/dummy_cell_1rw_1/qb vdd vdd sky130_fd_pr__nfet_01v8 ad=7.728n pd=0.42m as=0 ps=0 w=126 l=15
X706 bank_0/replica_bitcell_array_0/dummy_array_0/dummy_cell_1rw_1/qb bank_0/port_address_0/rbl_wl bank_0/replica_bitcell_array_0/dummy_array_0/dummy_cell_1rw_1/a_145_76# vdd sky130_fd_pr__nfet_01v8 ad=0 pd=0 as=1.428n ps=0.152m w=42 l=15
X707 vdd bank_0/replica_bitcell_array_0/dummy_array_0/dummy_cell_1rw_1/q bank_0/replica_bitcell_array_0/dummy_array_0/dummy_cell_1rw_1/qb vdd sky130_fd_pr__pfet_01v8 ad=0 pd=0 as=1.925n ps=0.18m w=55 l=15
X708 bank_0/replica_bitcell_array_0/dummy_array_0/dummy_cell_1rw_1/q bank_0/port_address_0/rbl_wl bank_0/replica_bitcell_array_0/dummy_array_0/dummy_cell_1rw_1/a_76_76# vdd sky130_fd_pr__nfet_01v8 ad=0 pd=0 as=1.428n ps=0.152m w=42 l=15
X709 bank_0/replica_bitcell_array_0/replica_column_0/replica_cell_1rw_1/q vdd vdd vdd sky130_fd_pr__pfet_01v8 ad=1.925n pd=0.18m as=1.925n ps=0.18m w=55 l=15
X710 vdd bank_0/replica_bitcell_array_0/replica_column_0/replica_cell_1rw_1/q vdd vdd sky130_fd_pr__nfet_01v8 ad=4.41n pd=0.322m as=3.864n ps=0.21m w=126 l=15
X711 bank_0/replica_bitcell_array_0/replica_column_0/replica_cell_1rw_1/q vdd vdd vdd sky130_fd_pr__nfet_01v8 ad=3.864n pd=0.21m as=4.41n ps=0.322m w=126 l=15
X712 vdd bank_0/port_address_0/wl_14 vdd vdd sky130_fd_pr__nfet_01v8 ad=3.864n pd=0.21m as=1.428n ps=0.152m w=42 l=15
X713 vdd bank_0/replica_bitcell_array_0/replica_column_0/replica_cell_1rw_1/q vdd vdd sky130_fd_pr__pfet_01v8 ad=1.925n pd=0.18m as=0 ps=0 w=55 l=15
X714 bank_0/replica_bitcell_array_0/replica_column_0/replica_cell_1rw_1/q bank_0/port_address_0/wl_14 vdd vdd sky130_fd_pr__nfet_01v8 ad=3.864n pd=0.21m as=1.428n ps=0.152m w=42 l=15
X715 bank_0/replica_bitcell_array_0/replica_column_0/replica_cell_1rw_13/q vdd vdd vdd sky130_fd_pr__pfet_01v8 ad=1.925n pd=0.18m as=0 ps=0 w=55 l=15
X716 vdd bank_0/replica_bitcell_array_0/replica_column_0/replica_cell_1rw_13/q vdd vdd sky130_fd_pr__nfet_01v8 ad=0 pd=0 as=0 ps=0 w=126 l=15
X717 bank_0/replica_bitcell_array_0/replica_column_0/replica_cell_1rw_13/q vdd vdd vdd sky130_fd_pr__nfet_01v8 ad=7.728n pd=0.42m as=0 ps=0 w=126 l=15
X718 vdd bank_0/port_address_0/wl_2 vdd vdd sky130_fd_pr__nfet_01v8 ad=0 pd=0 as=0 ps=0 w=42 l=15
X719 vdd bank_0/replica_bitcell_array_0/replica_column_0/replica_cell_1rw_13/q vdd vdd sky130_fd_pr__pfet_01v8 ad=0 pd=0 as=0 ps=0 w=55 l=15
X720 bank_0/replica_bitcell_array_0/replica_column_0/replica_cell_1rw_13/q bank_0/port_address_0/wl_2 vdd vdd sky130_fd_pr__nfet_01v8 ad=0 pd=0 as=0 ps=0 w=42 l=15
X721 bank_0/replica_bitcell_array_0/replica_column_0/replica_cell_1rw_2/q vdd vdd vdd sky130_fd_pr__pfet_01v8 ad=1.925n pd=0.18m as=0 ps=0 w=55 l=15
X722 vdd bank_0/replica_bitcell_array_0/replica_column_0/replica_cell_1rw_2/q vdd vdd sky130_fd_pr__nfet_01v8 ad=0 pd=0 as=0 ps=0 w=126 l=15
X723 bank_0/replica_bitcell_array_0/replica_column_0/replica_cell_1rw_2/q vdd vdd vdd sky130_fd_pr__nfet_01v8 ad=7.728n pd=0.42m as=0 ps=0 w=126 l=15
X724 vdd bank_0/port_address_0/wl_13 vdd vdd sky130_fd_pr__nfet_01v8 ad=0 pd=0 as=0 ps=0 w=42 l=15
X725 vdd bank_0/replica_bitcell_array_0/replica_column_0/replica_cell_1rw_2/q vdd vdd sky130_fd_pr__pfet_01v8 ad=0 pd=0 as=0 ps=0 w=55 l=15
X726 bank_0/replica_bitcell_array_0/replica_column_0/replica_cell_1rw_2/q bank_0/port_address_0/wl_13 vdd vdd sky130_fd_pr__nfet_01v8 ad=0 pd=0 as=0 ps=0 w=42 l=15
X727 bank_0/replica_bitcell_array_0/replica_column_0/replica_cell_1rw_14/q vdd vdd vdd sky130_fd_pr__pfet_01v8 ad=1.925n pd=0.18m as=0 ps=0 w=55 l=15
X728 vdd bank_0/replica_bitcell_array_0/replica_column_0/replica_cell_1rw_14/q vdd vdd sky130_fd_pr__nfet_01v8 ad=0 pd=0 as=0 ps=0 w=126 l=15
X729 bank_0/replica_bitcell_array_0/replica_column_0/replica_cell_1rw_14/q vdd vdd vdd sky130_fd_pr__nfet_01v8 ad=7.728n pd=0.42m as=0 ps=0 w=126 l=15
X730 vdd bank_0/port_address_0/wl_1 vdd vdd sky130_fd_pr__nfet_01v8 ad=0 pd=0 as=0 ps=0 w=42 l=15
X731 vdd bank_0/replica_bitcell_array_0/replica_column_0/replica_cell_1rw_14/q vdd vdd sky130_fd_pr__pfet_01v8 ad=0 pd=0 as=0 ps=0 w=55 l=15
X732 bank_0/replica_bitcell_array_0/replica_column_0/replica_cell_1rw_14/q bank_0/port_address_0/wl_1 vdd vdd sky130_fd_pr__nfet_01v8 ad=0 pd=0 as=0 ps=0 w=42 l=15
X733 bank_0/replica_bitcell_array_0/replica_column_0/replica_cell_1rw_3/q vdd vdd vdd sky130_fd_pr__pfet_01v8 ad=1.925n pd=0.18m as=0 ps=0 w=55 l=15
X734 vdd bank_0/replica_bitcell_array_0/replica_column_0/replica_cell_1rw_3/q vdd vdd sky130_fd_pr__nfet_01v8 ad=0 pd=0 as=0 ps=0 w=126 l=15
X735 bank_0/replica_bitcell_array_0/replica_column_0/replica_cell_1rw_3/q vdd vdd vdd sky130_fd_pr__nfet_01v8 ad=7.728n pd=0.42m as=0 ps=0 w=126 l=15
X736 vdd bank_0/port_address_0/wl_12 vdd vdd sky130_fd_pr__nfet_01v8 ad=0 pd=0 as=0 ps=0 w=42 l=15
X737 vdd bank_0/replica_bitcell_array_0/replica_column_0/replica_cell_1rw_3/q vdd vdd sky130_fd_pr__pfet_01v8 ad=0 pd=0 as=0 ps=0 w=55 l=15
X738 bank_0/replica_bitcell_array_0/replica_column_0/replica_cell_1rw_3/q bank_0/port_address_0/wl_12 vdd vdd sky130_fd_pr__nfet_01v8 ad=0 pd=0 as=0 ps=0 w=42 l=15
X739 bank_0/replica_bitcell_array_0/replica_column_0/replica_cell_1rw_15/q vdd vdd vdd sky130_fd_pr__pfet_01v8 ad=1.925n pd=0.18m as=0 ps=0 w=55 l=15
X740 vdd bank_0/replica_bitcell_array_0/replica_column_0/replica_cell_1rw_15/q vdd vdd sky130_fd_pr__nfet_01v8 ad=0 pd=0 as=0 ps=0 w=126 l=15
X741 bank_0/replica_bitcell_array_0/replica_column_0/replica_cell_1rw_15/q vdd vdd vdd sky130_fd_pr__nfet_01v8 ad=7.728n pd=0.42m as=0 ps=0 w=126 l=15
X742 vdd bank_0/port_address_0/wl_0 vdd vdd sky130_fd_pr__nfet_01v8 ad=0 pd=0 as=0 ps=0 w=42 l=15
X743 vdd bank_0/replica_bitcell_array_0/replica_column_0/replica_cell_1rw_15/q vdd vdd sky130_fd_pr__pfet_01v8 ad=0 pd=0 as=0 ps=0 w=55 l=15
X744 bank_0/replica_bitcell_array_0/replica_column_0/replica_cell_1rw_15/q bank_0/port_address_0/wl_0 vdd vdd sky130_fd_pr__nfet_01v8 ad=0 pd=0 as=0 ps=0 w=42 l=15
X745 bank_0/replica_bitcell_array_0/replica_column_0/replica_cell_1rw_16/q vdd vdd vdd sky130_fd_pr__pfet_01v8 ad=1.925n pd=0.18m as=0 ps=0 w=55 l=15
X746 vdd bank_0/replica_bitcell_array_0/replica_column_0/replica_cell_1rw_16/q vdd vdd sky130_fd_pr__nfet_01v8 ad=0 pd=0 as=0 ps=0 w=126 l=15
X747 bank_0/replica_bitcell_array_0/replica_column_0/replica_cell_1rw_16/q vdd vdd vdd sky130_fd_pr__nfet_01v8 ad=7.728n pd=0.42m as=0 ps=0 w=126 l=15
X748 vdd bank_0/port_address_0/rbl_wl vdd vdd sky130_fd_pr__nfet_01v8 ad=0 pd=0 as=0 ps=0 w=42 l=15
X749 vdd bank_0/replica_bitcell_array_0/replica_column_0/replica_cell_1rw_16/q vdd vdd sky130_fd_pr__pfet_01v8 ad=0 pd=0 as=0 ps=0 w=55 l=15
X750 bank_0/replica_bitcell_array_0/replica_column_0/replica_cell_1rw_16/q bank_0/port_address_0/rbl_wl vdd vdd sky130_fd_pr__nfet_01v8 ad=0 pd=0 as=0 ps=0 w=42 l=15
X751 bank_0/replica_bitcell_array_0/replica_column_0/replica_cell_1rw_4/q vdd vdd vdd sky130_fd_pr__pfet_01v8 ad=1.925n pd=0.18m as=0 ps=0 w=55 l=15
X752 vdd bank_0/replica_bitcell_array_0/replica_column_0/replica_cell_1rw_4/q vdd vdd sky130_fd_pr__nfet_01v8 ad=0 pd=0 as=0 ps=0 w=126 l=15
X753 bank_0/replica_bitcell_array_0/replica_column_0/replica_cell_1rw_4/q vdd vdd vdd sky130_fd_pr__nfet_01v8 ad=7.728n pd=0.42m as=0 ps=0 w=126 l=15
X754 vdd bank_0/port_address_0/wl_11 vdd vdd sky130_fd_pr__nfet_01v8 ad=0 pd=0 as=0 ps=0 w=42 l=15
X755 vdd bank_0/replica_bitcell_array_0/replica_column_0/replica_cell_1rw_4/q vdd vdd sky130_fd_pr__pfet_01v8 ad=0 pd=0 as=0 ps=0 w=55 l=15
X756 bank_0/replica_bitcell_array_0/replica_column_0/replica_cell_1rw_4/q bank_0/port_address_0/wl_11 vdd vdd sky130_fd_pr__nfet_01v8 ad=0 pd=0 as=0 ps=0 w=42 l=15
X757 bank_0/replica_bitcell_array_0/replica_column_0/dummy_cell_1rw_0/q bank_0/replica_bitcell_array_0/replica_column_0/dummy_cell_1rw_0/qb vdd vdd sky130_fd_pr__pfet_01v8 ad=1.925n pd=0.18m as=0 ps=0 w=55 l=15
X758 vdd bank_0/replica_bitcell_array_0/replica_column_0/dummy_cell_1rw_0/q bank_0/replica_bitcell_array_0/replica_column_0/dummy_cell_1rw_0/qb vdd sky130_fd_pr__nfet_01v8 ad=0 pd=0 as=7.728n ps=0.42m w=126 l=15
X759 bank_0/replica_bitcell_array_0/replica_column_0/dummy_cell_1rw_0/q bank_0/replica_bitcell_array_0/replica_column_0/dummy_cell_1rw_0/qb vdd vdd sky130_fd_pr__nfet_01v8 ad=7.728n pd=0.42m as=0 ps=0 w=126 l=15
X760 bank_0/replica_bitcell_array_0/replica_column_0/dummy_cell_1rw_0/qb vdd bank_0/replica_bitcell_array_0/replica_column_0/dummy_cell_1rw_0/a_145_76# vdd sky130_fd_pr__nfet_01v8 ad=0 pd=0 as=1.428n ps=0.152m w=42 l=15
X761 vdd bank_0/replica_bitcell_array_0/replica_column_0/dummy_cell_1rw_0/q bank_0/replica_bitcell_array_0/replica_column_0/dummy_cell_1rw_0/qb vdd sky130_fd_pr__pfet_01v8 ad=0 pd=0 as=1.925n ps=0.18m w=55 l=15
X762 bank_0/replica_bitcell_array_0/replica_column_0/dummy_cell_1rw_0/q vdd bank_0/replica_bitcell_array_0/replica_column_0/dummy_cell_1rw_0/a_76_76# vdd sky130_fd_pr__nfet_01v8 ad=0 pd=0 as=1.428n ps=0.152m w=42 l=15
X763 bank_0/replica_bitcell_array_0/replica_column_0/replica_cell_1rw_5/q vdd vdd vdd sky130_fd_pr__pfet_01v8 ad=1.925n pd=0.18m as=0 ps=0 w=55 l=15
X764 vdd bank_0/replica_bitcell_array_0/replica_column_0/replica_cell_1rw_5/q vdd vdd sky130_fd_pr__nfet_01v8 ad=0 pd=0 as=0 ps=0 w=126 l=15
X765 bank_0/replica_bitcell_array_0/replica_column_0/replica_cell_1rw_5/q vdd vdd vdd sky130_fd_pr__nfet_01v8 ad=7.728n pd=0.42m as=0 ps=0 w=126 l=15
X766 vdd bank_0/port_address_0/wl_10 vdd vdd sky130_fd_pr__nfet_01v8 ad=0 pd=0 as=0 ps=0 w=42 l=15
X767 vdd bank_0/replica_bitcell_array_0/replica_column_0/replica_cell_1rw_5/q vdd vdd sky130_fd_pr__pfet_01v8 ad=0 pd=0 as=0 ps=0 w=55 l=15
X768 bank_0/replica_bitcell_array_0/replica_column_0/replica_cell_1rw_5/q bank_0/port_address_0/wl_10 vdd vdd sky130_fd_pr__nfet_01v8 ad=0 pd=0 as=0 ps=0 w=42 l=15
X769 bank_0/replica_bitcell_array_0/replica_column_0/replica_cell_1rw_6/q vdd vdd vdd sky130_fd_pr__pfet_01v8 ad=1.925n pd=0.18m as=0 ps=0 w=55 l=15
X770 vdd bank_0/replica_bitcell_array_0/replica_column_0/replica_cell_1rw_6/q vdd vdd sky130_fd_pr__nfet_01v8 ad=0 pd=0 as=0 ps=0 w=126 l=15
X771 bank_0/replica_bitcell_array_0/replica_column_0/replica_cell_1rw_6/q vdd vdd vdd sky130_fd_pr__nfet_01v8 ad=7.728n pd=0.42m as=0 ps=0 w=126 l=15
X772 vdd bank_0/port_address_0/wl_9 vdd vdd sky130_fd_pr__nfet_01v8 ad=0 pd=0 as=0 ps=0 w=42 l=15
X773 vdd bank_0/replica_bitcell_array_0/replica_column_0/replica_cell_1rw_6/q vdd vdd sky130_fd_pr__pfet_01v8 ad=0 pd=0 as=0 ps=0 w=55 l=15
X774 bank_0/replica_bitcell_array_0/replica_column_0/replica_cell_1rw_6/q bank_0/port_address_0/wl_9 vdd vdd sky130_fd_pr__nfet_01v8 ad=0 pd=0 as=0 ps=0 w=42 l=15
X775 bank_0/replica_bitcell_array_0/replica_column_0/dummy_cell_1rw_1/q bank_0/replica_bitcell_array_0/replica_column_0/dummy_cell_1rw_1/qb vdd vdd sky130_fd_pr__pfet_01v8 ad=1.925n pd=0.18m as=0 ps=0 w=55 l=15
X776 vdd bank_0/replica_bitcell_array_0/replica_column_0/dummy_cell_1rw_1/q bank_0/replica_bitcell_array_0/replica_column_0/dummy_cell_1rw_1/qb vdd sky130_fd_pr__nfet_01v8 ad=0 pd=0 as=7.728n ps=0.42m w=126 l=15
X777 bank_0/replica_bitcell_array_0/replica_column_0/dummy_cell_1rw_1/q bank_0/replica_bitcell_array_0/replica_column_0/dummy_cell_1rw_1/qb vdd vdd sky130_fd_pr__nfet_01v8 ad=7.728n pd=0.42m as=0 ps=0 w=126 l=15
X778 bank_0/replica_bitcell_array_0/replica_column_0/dummy_cell_1rw_1/qb vdd bank_0/replica_bitcell_array_0/replica_column_0/dummy_cell_1rw_1/a_145_76# vdd sky130_fd_pr__nfet_01v8 ad=0 pd=0 as=1.428n ps=0.152m w=42 l=15
X779 vdd bank_0/replica_bitcell_array_0/replica_column_0/dummy_cell_1rw_1/q bank_0/replica_bitcell_array_0/replica_column_0/dummy_cell_1rw_1/qb vdd sky130_fd_pr__pfet_01v8 ad=0 pd=0 as=1.925n ps=0.18m w=55 l=15
X780 bank_0/replica_bitcell_array_0/replica_column_0/dummy_cell_1rw_1/q vdd bank_0/replica_bitcell_array_0/replica_column_0/dummy_cell_1rw_1/a_76_76# vdd sky130_fd_pr__nfet_01v8 ad=0 pd=0 as=1.428n ps=0.152m w=42 l=15
X781 bank_0/replica_bitcell_array_0/replica_column_0/replica_cell_1rw_7/q vdd vdd vdd sky130_fd_pr__pfet_01v8 ad=1.925n pd=0.18m as=0 ps=0 w=55 l=15
X782 vdd bank_0/replica_bitcell_array_0/replica_column_0/replica_cell_1rw_7/q vdd vdd sky130_fd_pr__nfet_01v8 ad=0 pd=0 as=0 ps=0 w=126 l=15
X783 bank_0/replica_bitcell_array_0/replica_column_0/replica_cell_1rw_7/q vdd vdd vdd sky130_fd_pr__nfet_01v8 ad=7.728n pd=0.42m as=0 ps=0 w=126 l=15
X784 vdd bank_0/port_address_0/wl_8 vdd vdd sky130_fd_pr__nfet_01v8 ad=0 pd=0 as=0 ps=0 w=42 l=15
X785 vdd bank_0/replica_bitcell_array_0/replica_column_0/replica_cell_1rw_7/q vdd vdd sky130_fd_pr__pfet_01v8 ad=0 pd=0 as=0 ps=0 w=55 l=15
X786 bank_0/replica_bitcell_array_0/replica_column_0/replica_cell_1rw_7/q bank_0/port_address_0/wl_8 vdd vdd sky130_fd_pr__nfet_01v8 ad=0 pd=0 as=0 ps=0 w=42 l=15
X787 bank_0/replica_bitcell_array_0/replica_column_0/replica_cell_1rw_8/q vdd vdd vdd sky130_fd_pr__pfet_01v8 ad=1.925n pd=0.18m as=0 ps=0 w=55 l=15
X788 vdd bank_0/replica_bitcell_array_0/replica_column_0/replica_cell_1rw_8/q vdd vdd sky130_fd_pr__nfet_01v8 ad=0 pd=0 as=0 ps=0 w=126 l=15
X789 bank_0/replica_bitcell_array_0/replica_column_0/replica_cell_1rw_8/q vdd vdd vdd sky130_fd_pr__nfet_01v8 ad=7.728n pd=0.42m as=0 ps=0 w=126 l=15
X790 vdd bank_0/port_address_0/wl_7 vdd vdd sky130_fd_pr__nfet_01v8 ad=0 pd=0 as=0 ps=0 w=42 l=15
X791 vdd bank_0/replica_bitcell_array_0/replica_column_0/replica_cell_1rw_8/q vdd vdd sky130_fd_pr__pfet_01v8 ad=0 pd=0 as=0 ps=0 w=55 l=15
X792 bank_0/replica_bitcell_array_0/replica_column_0/replica_cell_1rw_8/q bank_0/port_address_0/wl_7 vdd vdd sky130_fd_pr__nfet_01v8 ad=0 pd=0 as=0 ps=0 w=42 l=15
X793 bank_0/replica_bitcell_array_0/replica_column_0/replica_cell_1rw_9/q vdd vdd vdd sky130_fd_pr__pfet_01v8 ad=1.925n pd=0.18m as=0 ps=0 w=55 l=15
X794 vdd bank_0/replica_bitcell_array_0/replica_column_0/replica_cell_1rw_9/q vdd vdd sky130_fd_pr__nfet_01v8 ad=0 pd=0 as=0 ps=0 w=126 l=15
X795 bank_0/replica_bitcell_array_0/replica_column_0/replica_cell_1rw_9/q vdd vdd vdd sky130_fd_pr__nfet_01v8 ad=7.728n pd=0.42m as=0 ps=0 w=126 l=15
X796 vdd bank_0/port_address_0/wl_6 vdd vdd sky130_fd_pr__nfet_01v8 ad=0 pd=0 as=0 ps=0 w=42 l=15
X797 vdd bank_0/replica_bitcell_array_0/replica_column_0/replica_cell_1rw_9/q vdd vdd sky130_fd_pr__pfet_01v8 ad=0 pd=0 as=0 ps=0 w=55 l=15
X798 bank_0/replica_bitcell_array_0/replica_column_0/replica_cell_1rw_9/q bank_0/port_address_0/wl_6 vdd vdd sky130_fd_pr__nfet_01v8 ad=0 pd=0 as=0 ps=0 w=42 l=15
X799 bank_0/replica_bitcell_array_0/replica_column_0/replica_cell_1rw_10/q vdd vdd vdd sky130_fd_pr__pfet_01v8 ad=1.925n pd=0.18m as=0 ps=0 w=55 l=15
X800 vdd bank_0/replica_bitcell_array_0/replica_column_0/replica_cell_1rw_10/q vdd vdd sky130_fd_pr__nfet_01v8 ad=0 pd=0 as=0 ps=0 w=126 l=15
X801 bank_0/replica_bitcell_array_0/replica_column_0/replica_cell_1rw_10/q vdd vdd vdd sky130_fd_pr__nfet_01v8 ad=7.728n pd=0.42m as=0 ps=0 w=126 l=15
X802 vdd bank_0/port_address_0/wl_5 vdd vdd sky130_fd_pr__nfet_01v8 ad=0 pd=0 as=0 ps=0 w=42 l=15
X803 vdd bank_0/replica_bitcell_array_0/replica_column_0/replica_cell_1rw_10/q vdd vdd sky130_fd_pr__pfet_01v8 ad=0 pd=0 as=0 ps=0 w=55 l=15
X804 bank_0/replica_bitcell_array_0/replica_column_0/replica_cell_1rw_10/q bank_0/port_address_0/wl_5 vdd vdd sky130_fd_pr__nfet_01v8 ad=0 pd=0 as=0 ps=0 w=42 l=15
X805 bank_0/replica_bitcell_array_0/replica_column_0/replica_cell_1rw_11/q vdd vdd vdd sky130_fd_pr__pfet_01v8 ad=1.925n pd=0.18m as=0 ps=0 w=55 l=15
X806 vdd bank_0/replica_bitcell_array_0/replica_column_0/replica_cell_1rw_11/q vdd vdd sky130_fd_pr__nfet_01v8 ad=0 pd=0 as=0 ps=0 w=126 l=15
X807 bank_0/replica_bitcell_array_0/replica_column_0/replica_cell_1rw_11/q vdd vdd vdd sky130_fd_pr__nfet_01v8 ad=7.728n pd=0.42m as=0 ps=0 w=126 l=15
X808 vdd bank_0/port_address_0/wl_4 vdd vdd sky130_fd_pr__nfet_01v8 ad=0 pd=0 as=0 ps=0 w=42 l=15
X809 vdd bank_0/replica_bitcell_array_0/replica_column_0/replica_cell_1rw_11/q vdd vdd sky130_fd_pr__pfet_01v8 ad=0 pd=0 as=0 ps=0 w=55 l=15
X810 bank_0/replica_bitcell_array_0/replica_column_0/replica_cell_1rw_11/q bank_0/port_address_0/wl_4 vdd vdd sky130_fd_pr__nfet_01v8 ad=0 pd=0 as=0 ps=0 w=42 l=15
X811 bank_0/replica_bitcell_array_0/replica_column_0/replica_cell_1rw_0/q vdd vdd vdd sky130_fd_pr__pfet_01v8 ad=1.925n pd=0.18m as=0 ps=0 w=55 l=15
X812 vdd bank_0/replica_bitcell_array_0/replica_column_0/replica_cell_1rw_0/q vdd vdd sky130_fd_pr__nfet_01v8 ad=0 pd=0 as=0 ps=0 w=126 l=15
X813 bank_0/replica_bitcell_array_0/replica_column_0/replica_cell_1rw_0/q vdd vdd vdd sky130_fd_pr__nfet_01v8 ad=7.728n pd=0.42m as=0 ps=0 w=126 l=15
X814 vdd bank_0/port_address_0/wl_15 vdd vdd sky130_fd_pr__nfet_01v8 ad=0 pd=0 as=0 ps=0 w=42 l=15
X815 vdd bank_0/replica_bitcell_array_0/replica_column_0/replica_cell_1rw_0/q vdd vdd sky130_fd_pr__pfet_01v8 ad=0 pd=0 as=0 ps=0 w=55 l=15
X816 bank_0/replica_bitcell_array_0/replica_column_0/replica_cell_1rw_0/q bank_0/port_address_0/wl_15 vdd vdd sky130_fd_pr__nfet_01v8 ad=0 pd=0 as=0 ps=0 w=42 l=15
X817 bank_0/replica_bitcell_array_0/replica_column_0/replica_cell_1rw_12/q vdd vdd vdd sky130_fd_pr__pfet_01v8 ad=1.925n pd=0.18m as=0 ps=0 w=55 l=15
X818 vdd bank_0/replica_bitcell_array_0/replica_column_0/replica_cell_1rw_12/q vdd vdd sky130_fd_pr__nfet_01v8 ad=0 pd=0 as=0 ps=0 w=126 l=15
X819 bank_0/replica_bitcell_array_0/replica_column_0/replica_cell_1rw_12/q vdd vdd vdd sky130_fd_pr__nfet_01v8 ad=7.728n pd=0.42m as=0 ps=0 w=126 l=15
X820 vdd bank_0/port_address_0/wl_3 vdd vdd sky130_fd_pr__nfet_01v8 ad=0 pd=0 as=0 ps=0 w=42 l=15
X821 vdd bank_0/replica_bitcell_array_0/replica_column_0/replica_cell_1rw_12/q vdd vdd sky130_fd_pr__pfet_01v8 ad=0 pd=0 as=0 ps=0 w=55 l=15
X822 bank_0/replica_bitcell_array_0/replica_column_0/replica_cell_1rw_12/q bank_0/port_address_0/wl_3 vdd vdd sky130_fd_pr__nfet_01v8 ad=0 pd=0 as=0 ps=0 w=42 l=15
X823 bank_0/replica_bitcell_array_0/bitcell_array_0/cell_1rw_0/q bank_0/replica_bitcell_array_0/bitcell_array_0/cell_1rw_0/qb vdd vdd sky130_fd_pr__pfet_01v8 ad=1.925n pd=0.18m as=1.925n ps=0.18m w=55 l=15
X824 vdd bank_0/replica_bitcell_array_0/bitcell_array_0/cell_1rw_0/q bank_0/replica_bitcell_array_0/bitcell_array_0/cell_1rw_0/qb vdd sky130_fd_pr__nfet_01v8 ad=4.41n pd=0.322m as=3.864n ps=0.21m w=126 l=15
X825 bank_0/replica_bitcell_array_0/bitcell_array_0/cell_1rw_0/q bank_0/replica_bitcell_array_0/bitcell_array_0/cell_1rw_0/qb vdd vdd sky130_fd_pr__nfet_01v8 ad=3.864n pd=0.21m as=4.41n ps=0.322m w=126 l=15
X826 bank_0/replica_bitcell_array_0/bitcell_array_0/cell_1rw_0/qb bank_0/port_address_0/wl_15 vdd vdd sky130_fd_pr__nfet_01v8 ad=3.864n pd=0.21m as=1.428n ps=0.152m w=42 l=15
X827 vdd bank_0/replica_bitcell_array_0/bitcell_array_0/cell_1rw_0/q bank_0/replica_bitcell_array_0/bitcell_array_0/cell_1rw_0/qb vdd sky130_fd_pr__pfet_01v8 ad=1.925n pd=0.18m as=1.925n ps=0.18m w=55 l=15
X828 bank_0/replica_bitcell_array_0/bitcell_array_0/cell_1rw_0/q bank_0/port_address_0/wl_15 vdd vdd sky130_fd_pr__nfet_01v8 ad=3.864n pd=0.21m as=1.428n ps=0.152m w=42 l=15
X829 bank_0/replica_bitcell_array_0/bitcell_array_0/cell_1rw_1/q bank_0/replica_bitcell_array_0/bitcell_array_0/cell_1rw_1/qb vdd vdd sky130_fd_pr__pfet_01v8 ad=1.925n pd=0.18m as=0 ps=0 w=55 l=15
X830 vdd bank_0/replica_bitcell_array_0/bitcell_array_0/cell_1rw_1/q bank_0/replica_bitcell_array_0/bitcell_array_0/cell_1rw_1/qb vdd sky130_fd_pr__nfet_01v8 ad=0 pd=0 as=7.728n ps=0.42m w=126 l=15
X831 bank_0/replica_bitcell_array_0/bitcell_array_0/cell_1rw_1/q bank_0/replica_bitcell_array_0/bitcell_array_0/cell_1rw_1/qb vdd vdd sky130_fd_pr__nfet_01v8 ad=7.728n pd=0.42m as=0 ps=0 w=126 l=15
X832 bank_0/replica_bitcell_array_0/bitcell_array_0/cell_1rw_1/qb bank_0/port_address_0/wl_14 vdd vdd sky130_fd_pr__nfet_01v8 ad=0 pd=0 as=0 ps=0 w=42 l=15
X833 vdd bank_0/replica_bitcell_array_0/bitcell_array_0/cell_1rw_1/q bank_0/replica_bitcell_array_0/bitcell_array_0/cell_1rw_1/qb vdd sky130_fd_pr__pfet_01v8 ad=0 pd=0 as=1.925n ps=0.18m w=55 l=15
X834 bank_0/replica_bitcell_array_0/bitcell_array_0/cell_1rw_1/q bank_0/port_address_0/wl_14 vdd vdd sky130_fd_pr__nfet_01v8 ad=0 pd=0 as=0 ps=0 w=42 l=15
X835 bank_0/replica_bitcell_array_0/bitcell_array_0/cell_1rw_2/q bank_0/replica_bitcell_array_0/bitcell_array_0/cell_1rw_2/qb vdd vdd sky130_fd_pr__pfet_01v8 ad=1.925n pd=0.18m as=0 ps=0 w=55 l=15
X836 vdd bank_0/replica_bitcell_array_0/bitcell_array_0/cell_1rw_2/q bank_0/replica_bitcell_array_0/bitcell_array_0/cell_1rw_2/qb vdd sky130_fd_pr__nfet_01v8 ad=0 pd=0 as=7.728n ps=0.42m w=126 l=15
X837 bank_0/replica_bitcell_array_0/bitcell_array_0/cell_1rw_2/q bank_0/replica_bitcell_array_0/bitcell_array_0/cell_1rw_2/qb vdd vdd sky130_fd_pr__nfet_01v8 ad=7.728n pd=0.42m as=0 ps=0 w=126 l=15
X838 bank_0/replica_bitcell_array_0/bitcell_array_0/cell_1rw_2/qb bank_0/port_address_0/wl_13 vdd vdd sky130_fd_pr__nfet_01v8 ad=0 pd=0 as=0 ps=0 w=42 l=15
X839 vdd bank_0/replica_bitcell_array_0/bitcell_array_0/cell_1rw_2/q bank_0/replica_bitcell_array_0/bitcell_array_0/cell_1rw_2/qb vdd sky130_fd_pr__pfet_01v8 ad=0 pd=0 as=1.925n ps=0.18m w=55 l=15
X840 bank_0/replica_bitcell_array_0/bitcell_array_0/cell_1rw_2/q bank_0/port_address_0/wl_13 vdd vdd sky130_fd_pr__nfet_01v8 ad=0 pd=0 as=0 ps=0 w=42 l=15
X841 bank_0/replica_bitcell_array_0/bitcell_array_0/cell_1rw_3/q bank_0/replica_bitcell_array_0/bitcell_array_0/cell_1rw_3/qb vdd vdd sky130_fd_pr__pfet_01v8 ad=1.925n pd=0.18m as=0 ps=0 w=55 l=15
X842 vdd bank_0/replica_bitcell_array_0/bitcell_array_0/cell_1rw_3/q bank_0/replica_bitcell_array_0/bitcell_array_0/cell_1rw_3/qb vdd sky130_fd_pr__nfet_01v8 ad=0 pd=0 as=7.728n ps=0.42m w=126 l=15
X843 bank_0/replica_bitcell_array_0/bitcell_array_0/cell_1rw_3/q bank_0/replica_bitcell_array_0/bitcell_array_0/cell_1rw_3/qb vdd vdd sky130_fd_pr__nfet_01v8 ad=7.728n pd=0.42m as=0 ps=0 w=126 l=15
X844 bank_0/replica_bitcell_array_0/bitcell_array_0/cell_1rw_3/qb bank_0/port_address_0/wl_12 vdd vdd sky130_fd_pr__nfet_01v8 ad=0 pd=0 as=0 ps=0 w=42 l=15
X845 vdd bank_0/replica_bitcell_array_0/bitcell_array_0/cell_1rw_3/q bank_0/replica_bitcell_array_0/bitcell_array_0/cell_1rw_3/qb vdd sky130_fd_pr__pfet_01v8 ad=0 pd=0 as=1.925n ps=0.18m w=55 l=15
X846 bank_0/replica_bitcell_array_0/bitcell_array_0/cell_1rw_3/q bank_0/port_address_0/wl_12 vdd vdd sky130_fd_pr__nfet_01v8 ad=0 pd=0 as=0 ps=0 w=42 l=15
X847 bank_0/replica_bitcell_array_0/bitcell_array_0/cell_1rw_4/q bank_0/replica_bitcell_array_0/bitcell_array_0/cell_1rw_4/qb vdd vdd sky130_fd_pr__pfet_01v8 ad=1.925n pd=0.18m as=0 ps=0 w=55 l=15
X848 vdd bank_0/replica_bitcell_array_0/bitcell_array_0/cell_1rw_4/q bank_0/replica_bitcell_array_0/bitcell_array_0/cell_1rw_4/qb vdd sky130_fd_pr__nfet_01v8 ad=0 pd=0 as=7.728n ps=0.42m w=126 l=15
X849 bank_0/replica_bitcell_array_0/bitcell_array_0/cell_1rw_4/q bank_0/replica_bitcell_array_0/bitcell_array_0/cell_1rw_4/qb vdd vdd sky130_fd_pr__nfet_01v8 ad=7.728n pd=0.42m as=0 ps=0 w=126 l=15
X850 bank_0/replica_bitcell_array_0/bitcell_array_0/cell_1rw_4/qb bank_0/port_address_0/wl_11 vdd vdd sky130_fd_pr__nfet_01v8 ad=0 pd=0 as=0 ps=0 w=42 l=15
X851 vdd bank_0/replica_bitcell_array_0/bitcell_array_0/cell_1rw_4/q bank_0/replica_bitcell_array_0/bitcell_array_0/cell_1rw_4/qb vdd sky130_fd_pr__pfet_01v8 ad=0 pd=0 as=1.925n ps=0.18m w=55 l=15
X852 bank_0/replica_bitcell_array_0/bitcell_array_0/cell_1rw_4/q bank_0/port_address_0/wl_11 vdd vdd sky130_fd_pr__nfet_01v8 ad=0 pd=0 as=0 ps=0 w=42 l=15
X853 bank_0/replica_bitcell_array_0/bitcell_array_0/cell_1rw_5/q bank_0/replica_bitcell_array_0/bitcell_array_0/cell_1rw_5/qb vdd vdd sky130_fd_pr__pfet_01v8 ad=1.925n pd=0.18m as=0 ps=0 w=55 l=15
X854 vdd bank_0/replica_bitcell_array_0/bitcell_array_0/cell_1rw_5/q bank_0/replica_bitcell_array_0/bitcell_array_0/cell_1rw_5/qb vdd sky130_fd_pr__nfet_01v8 ad=0 pd=0 as=7.728n ps=0.42m w=126 l=15
X855 bank_0/replica_bitcell_array_0/bitcell_array_0/cell_1rw_5/q bank_0/replica_bitcell_array_0/bitcell_array_0/cell_1rw_5/qb vdd vdd sky130_fd_pr__nfet_01v8 ad=7.728n pd=0.42m as=0 ps=0 w=126 l=15
X856 bank_0/replica_bitcell_array_0/bitcell_array_0/cell_1rw_5/qb bank_0/port_address_0/wl_10 vdd vdd sky130_fd_pr__nfet_01v8 ad=0 pd=0 as=0 ps=0 w=42 l=15
X857 vdd bank_0/replica_bitcell_array_0/bitcell_array_0/cell_1rw_5/q bank_0/replica_bitcell_array_0/bitcell_array_0/cell_1rw_5/qb vdd sky130_fd_pr__pfet_01v8 ad=0 pd=0 as=1.925n ps=0.18m w=55 l=15
X858 bank_0/replica_bitcell_array_0/bitcell_array_0/cell_1rw_5/q bank_0/port_address_0/wl_10 vdd vdd sky130_fd_pr__nfet_01v8 ad=0 pd=0 as=0 ps=0 w=42 l=15
X859 bank_0/replica_bitcell_array_0/bitcell_array_0/cell_1rw_6/q bank_0/replica_bitcell_array_0/bitcell_array_0/cell_1rw_6/qb vdd vdd sky130_fd_pr__pfet_01v8 ad=1.925n pd=0.18m as=0 ps=0 w=55 l=15
X860 vdd bank_0/replica_bitcell_array_0/bitcell_array_0/cell_1rw_6/q bank_0/replica_bitcell_array_0/bitcell_array_0/cell_1rw_6/qb vdd sky130_fd_pr__nfet_01v8 ad=0 pd=0 as=7.728n ps=0.42m w=126 l=15
X861 bank_0/replica_bitcell_array_0/bitcell_array_0/cell_1rw_6/q bank_0/replica_bitcell_array_0/bitcell_array_0/cell_1rw_6/qb vdd vdd sky130_fd_pr__nfet_01v8 ad=7.728n pd=0.42m as=0 ps=0 w=126 l=15
X862 bank_0/replica_bitcell_array_0/bitcell_array_0/cell_1rw_6/qb bank_0/port_address_0/wl_9 vdd vdd sky130_fd_pr__nfet_01v8 ad=0 pd=0 as=0 ps=0 w=42 l=15
X863 vdd bank_0/replica_bitcell_array_0/bitcell_array_0/cell_1rw_6/q bank_0/replica_bitcell_array_0/bitcell_array_0/cell_1rw_6/qb vdd sky130_fd_pr__pfet_01v8 ad=0 pd=0 as=1.925n ps=0.18m w=55 l=15
X864 bank_0/replica_bitcell_array_0/bitcell_array_0/cell_1rw_6/q bank_0/port_address_0/wl_9 vdd vdd sky130_fd_pr__nfet_01v8 ad=0 pd=0 as=0 ps=0 w=42 l=15
X865 bank_0/replica_bitcell_array_0/bitcell_array_0/cell_1rw_7/q bank_0/replica_bitcell_array_0/bitcell_array_0/cell_1rw_7/qb vdd vdd sky130_fd_pr__pfet_01v8 ad=1.925n pd=0.18m as=0 ps=0 w=55 l=15
X866 vdd bank_0/replica_bitcell_array_0/bitcell_array_0/cell_1rw_7/q bank_0/replica_bitcell_array_0/bitcell_array_0/cell_1rw_7/qb vdd sky130_fd_pr__nfet_01v8 ad=0 pd=0 as=7.728n ps=0.42m w=126 l=15
X867 bank_0/replica_bitcell_array_0/bitcell_array_0/cell_1rw_7/q bank_0/replica_bitcell_array_0/bitcell_array_0/cell_1rw_7/qb vdd vdd sky130_fd_pr__nfet_01v8 ad=7.728n pd=0.42m as=0 ps=0 w=126 l=15
X868 bank_0/replica_bitcell_array_0/bitcell_array_0/cell_1rw_7/qb bank_0/port_address_0/wl_8 vdd vdd sky130_fd_pr__nfet_01v8 ad=0 pd=0 as=0 ps=0 w=42 l=15
X869 vdd bank_0/replica_bitcell_array_0/bitcell_array_0/cell_1rw_7/q bank_0/replica_bitcell_array_0/bitcell_array_0/cell_1rw_7/qb vdd sky130_fd_pr__pfet_01v8 ad=0 pd=0 as=1.925n ps=0.18m w=55 l=15
X870 bank_0/replica_bitcell_array_0/bitcell_array_0/cell_1rw_7/q bank_0/port_address_0/wl_8 vdd vdd sky130_fd_pr__nfet_01v8 ad=0 pd=0 as=0 ps=0 w=42 l=15
X871 bank_0/replica_bitcell_array_0/bitcell_array_0/cell_1rw_8/q bank_0/replica_bitcell_array_0/bitcell_array_0/cell_1rw_8/qb vdd vdd sky130_fd_pr__pfet_01v8 ad=1.925n pd=0.18m as=0 ps=0 w=55 l=15
X872 vdd bank_0/replica_bitcell_array_0/bitcell_array_0/cell_1rw_8/q bank_0/replica_bitcell_array_0/bitcell_array_0/cell_1rw_8/qb vdd sky130_fd_pr__nfet_01v8 ad=0 pd=0 as=7.728n ps=0.42m w=126 l=15
X873 bank_0/replica_bitcell_array_0/bitcell_array_0/cell_1rw_8/q bank_0/replica_bitcell_array_0/bitcell_array_0/cell_1rw_8/qb vdd vdd sky130_fd_pr__nfet_01v8 ad=7.728n pd=0.42m as=0 ps=0 w=126 l=15
X874 bank_0/replica_bitcell_array_0/bitcell_array_0/cell_1rw_8/qb bank_0/port_address_0/wl_7 vdd vdd sky130_fd_pr__nfet_01v8 ad=0 pd=0 as=0 ps=0 w=42 l=15
X875 vdd bank_0/replica_bitcell_array_0/bitcell_array_0/cell_1rw_8/q bank_0/replica_bitcell_array_0/bitcell_array_0/cell_1rw_8/qb vdd sky130_fd_pr__pfet_01v8 ad=0 pd=0 as=1.925n ps=0.18m w=55 l=15
X876 bank_0/replica_bitcell_array_0/bitcell_array_0/cell_1rw_8/q bank_0/port_address_0/wl_7 vdd vdd sky130_fd_pr__nfet_01v8 ad=0 pd=0 as=0 ps=0 w=42 l=15
X877 bank_0/replica_bitcell_array_0/bitcell_array_0/cell_1rw_9/q bank_0/replica_bitcell_array_0/bitcell_array_0/cell_1rw_9/qb vdd vdd sky130_fd_pr__pfet_01v8 ad=1.925n pd=0.18m as=0 ps=0 w=55 l=15
X878 vdd bank_0/replica_bitcell_array_0/bitcell_array_0/cell_1rw_9/q bank_0/replica_bitcell_array_0/bitcell_array_0/cell_1rw_9/qb vdd sky130_fd_pr__nfet_01v8 ad=0 pd=0 as=7.728n ps=0.42m w=126 l=15
X879 bank_0/replica_bitcell_array_0/bitcell_array_0/cell_1rw_9/q bank_0/replica_bitcell_array_0/bitcell_array_0/cell_1rw_9/qb vdd vdd sky130_fd_pr__nfet_01v8 ad=7.728n pd=0.42m as=0 ps=0 w=126 l=15
X880 bank_0/replica_bitcell_array_0/bitcell_array_0/cell_1rw_9/qb bank_0/port_address_0/wl_6 vdd vdd sky130_fd_pr__nfet_01v8 ad=0 pd=0 as=0 ps=0 w=42 l=15
X881 vdd bank_0/replica_bitcell_array_0/bitcell_array_0/cell_1rw_9/q bank_0/replica_bitcell_array_0/bitcell_array_0/cell_1rw_9/qb vdd sky130_fd_pr__pfet_01v8 ad=0 pd=0 as=1.925n ps=0.18m w=55 l=15
X882 bank_0/replica_bitcell_array_0/bitcell_array_0/cell_1rw_9/q bank_0/port_address_0/wl_6 vdd vdd sky130_fd_pr__nfet_01v8 ad=0 pd=0 as=0 ps=0 w=42 l=15
X883 bank_0/replica_bitcell_array_0/bitcell_array_0/cell_1rw_30/q bank_0/replica_bitcell_array_0/bitcell_array_0/cell_1rw_30/qb vdd vdd sky130_fd_pr__pfet_01v8 ad=1.925n pd=0.18m as=0 ps=0 w=55 l=15
X884 vdd bank_0/replica_bitcell_array_0/bitcell_array_0/cell_1rw_30/q bank_0/replica_bitcell_array_0/bitcell_array_0/cell_1rw_30/qb vdd sky130_fd_pr__nfet_01v8 ad=0 pd=0 as=7.728n ps=0.42m w=126 l=15
X885 bank_0/replica_bitcell_array_0/bitcell_array_0/cell_1rw_30/q bank_0/replica_bitcell_array_0/bitcell_array_0/cell_1rw_30/qb vdd vdd sky130_fd_pr__nfet_01v8 ad=7.728n pd=0.42m as=0 ps=0 w=126 l=15
X886 bank_0/replica_bitcell_array_0/bitcell_array_0/cell_1rw_30/qb bank_0/port_address_0/wl_1 vdd vdd sky130_fd_pr__nfet_01v8 ad=0 pd=0 as=0 ps=0 w=42 l=15
X887 vdd bank_0/replica_bitcell_array_0/bitcell_array_0/cell_1rw_30/q bank_0/replica_bitcell_array_0/bitcell_array_0/cell_1rw_30/qb vdd sky130_fd_pr__pfet_01v8 ad=0 pd=0 as=1.925n ps=0.18m w=55 l=15
X888 bank_0/replica_bitcell_array_0/bitcell_array_0/cell_1rw_30/q bank_0/port_address_0/wl_1 vdd vdd sky130_fd_pr__nfet_01v8 ad=0 pd=0 as=0 ps=0 w=42 l=15
X889 bank_0/replica_bitcell_array_0/bitcell_array_0/cell_1rw_20/q bank_0/replica_bitcell_array_0/bitcell_array_0/cell_1rw_20/qb vdd vdd sky130_fd_pr__pfet_01v8 ad=1.925n pd=0.18m as=0 ps=0 w=55 l=15
X890 vdd bank_0/replica_bitcell_array_0/bitcell_array_0/cell_1rw_20/q bank_0/replica_bitcell_array_0/bitcell_array_0/cell_1rw_20/qb vdd sky130_fd_pr__nfet_01v8 ad=0 pd=0 as=7.728n ps=0.42m w=126 l=15
X891 bank_0/replica_bitcell_array_0/bitcell_array_0/cell_1rw_20/q bank_0/replica_bitcell_array_0/bitcell_array_0/cell_1rw_20/qb vdd vdd sky130_fd_pr__nfet_01v8 ad=7.728n pd=0.42m as=0 ps=0 w=126 l=15
X892 bank_0/replica_bitcell_array_0/bitcell_array_0/cell_1rw_20/qb bank_0/port_address_0/wl_11 vdd vdd sky130_fd_pr__nfet_01v8 ad=0 pd=0 as=0 ps=0 w=42 l=15
X893 vdd bank_0/replica_bitcell_array_0/bitcell_array_0/cell_1rw_20/q bank_0/replica_bitcell_array_0/bitcell_array_0/cell_1rw_20/qb vdd sky130_fd_pr__pfet_01v8 ad=0 pd=0 as=1.925n ps=0.18m w=55 l=15
X894 bank_0/replica_bitcell_array_0/bitcell_array_0/cell_1rw_20/q bank_0/port_address_0/wl_11 vdd vdd sky130_fd_pr__nfet_01v8 ad=0 pd=0 as=0 ps=0 w=42 l=15
X895 bank_0/replica_bitcell_array_0/bitcell_array_0/cell_1rw_21/q bank_0/replica_bitcell_array_0/bitcell_array_0/cell_1rw_21/qb vdd vdd sky130_fd_pr__pfet_01v8 ad=1.925n pd=0.18m as=0 ps=0 w=55 l=15
X896 vdd bank_0/replica_bitcell_array_0/bitcell_array_0/cell_1rw_21/q bank_0/replica_bitcell_array_0/bitcell_array_0/cell_1rw_21/qb vdd sky130_fd_pr__nfet_01v8 ad=0 pd=0 as=7.728n ps=0.42m w=126 l=15
X897 bank_0/replica_bitcell_array_0/bitcell_array_0/cell_1rw_21/q bank_0/replica_bitcell_array_0/bitcell_array_0/cell_1rw_21/qb vdd vdd sky130_fd_pr__nfet_01v8 ad=7.728n pd=0.42m as=0 ps=0 w=126 l=15
X898 bank_0/replica_bitcell_array_0/bitcell_array_0/cell_1rw_21/qb bank_0/port_address_0/wl_10 vdd vdd sky130_fd_pr__nfet_01v8 ad=0 pd=0 as=0 ps=0 w=42 l=15
X899 vdd bank_0/replica_bitcell_array_0/bitcell_array_0/cell_1rw_21/q bank_0/replica_bitcell_array_0/bitcell_array_0/cell_1rw_21/qb vdd sky130_fd_pr__pfet_01v8 ad=0 pd=0 as=1.925n ps=0.18m w=55 l=15
X900 bank_0/replica_bitcell_array_0/bitcell_array_0/cell_1rw_21/q bank_0/port_address_0/wl_10 vdd vdd sky130_fd_pr__nfet_01v8 ad=0 pd=0 as=0 ps=0 w=42 l=15
X901 bank_0/replica_bitcell_array_0/bitcell_array_0/cell_1rw_10/q bank_0/replica_bitcell_array_0/bitcell_array_0/cell_1rw_10/qb vdd vdd sky130_fd_pr__pfet_01v8 ad=1.925n pd=0.18m as=0 ps=0 w=55 l=15
X902 vdd bank_0/replica_bitcell_array_0/bitcell_array_0/cell_1rw_10/q bank_0/replica_bitcell_array_0/bitcell_array_0/cell_1rw_10/qb vdd sky130_fd_pr__nfet_01v8 ad=0 pd=0 as=7.728n ps=0.42m w=126 l=15
X903 bank_0/replica_bitcell_array_0/bitcell_array_0/cell_1rw_10/q bank_0/replica_bitcell_array_0/bitcell_array_0/cell_1rw_10/qb vdd vdd sky130_fd_pr__nfet_01v8 ad=7.728n pd=0.42m as=0 ps=0 w=126 l=15
X904 bank_0/replica_bitcell_array_0/bitcell_array_0/cell_1rw_10/qb bank_0/port_address_0/wl_5 vdd vdd sky130_fd_pr__nfet_01v8 ad=0 pd=0 as=0 ps=0 w=42 l=15
X905 vdd bank_0/replica_bitcell_array_0/bitcell_array_0/cell_1rw_10/q bank_0/replica_bitcell_array_0/bitcell_array_0/cell_1rw_10/qb vdd sky130_fd_pr__pfet_01v8 ad=0 pd=0 as=1.925n ps=0.18m w=55 l=15
X906 bank_0/replica_bitcell_array_0/bitcell_array_0/cell_1rw_10/q bank_0/port_address_0/wl_5 vdd vdd sky130_fd_pr__nfet_01v8 ad=0 pd=0 as=0 ps=0 w=42 l=15
X907 bank_0/replica_bitcell_array_0/bitcell_array_0/cell_1rw_31/q bank_0/replica_bitcell_array_0/bitcell_array_0/cell_1rw_31/qb vdd vdd sky130_fd_pr__pfet_01v8 ad=1.925n pd=0.18m as=0 ps=0 w=55 l=15
X908 vdd bank_0/replica_bitcell_array_0/bitcell_array_0/cell_1rw_31/q bank_0/replica_bitcell_array_0/bitcell_array_0/cell_1rw_31/qb vdd sky130_fd_pr__nfet_01v8 ad=0 pd=0 as=7.728n ps=0.42m w=126 l=15
X909 bank_0/replica_bitcell_array_0/bitcell_array_0/cell_1rw_31/q bank_0/replica_bitcell_array_0/bitcell_array_0/cell_1rw_31/qb vdd vdd sky130_fd_pr__nfet_01v8 ad=7.728n pd=0.42m as=0 ps=0 w=126 l=15
X910 bank_0/replica_bitcell_array_0/bitcell_array_0/cell_1rw_31/qb bank_0/port_address_0/wl_0 vdd vdd sky130_fd_pr__nfet_01v8 ad=0 pd=0 as=0 ps=0 w=42 l=15
X911 vdd bank_0/replica_bitcell_array_0/bitcell_array_0/cell_1rw_31/q bank_0/replica_bitcell_array_0/bitcell_array_0/cell_1rw_31/qb vdd sky130_fd_pr__pfet_01v8 ad=0 pd=0 as=1.925n ps=0.18m w=55 l=15
X912 bank_0/replica_bitcell_array_0/bitcell_array_0/cell_1rw_31/q bank_0/port_address_0/wl_0 vdd vdd sky130_fd_pr__nfet_01v8 ad=0 pd=0 as=0 ps=0 w=42 l=15
X913 bank_0/replica_bitcell_array_0/bitcell_array_0/cell_1rw_22/q bank_0/replica_bitcell_array_0/bitcell_array_0/cell_1rw_22/qb vdd vdd sky130_fd_pr__pfet_01v8 ad=1.925n pd=0.18m as=0 ps=0 w=55 l=15
X914 vdd bank_0/replica_bitcell_array_0/bitcell_array_0/cell_1rw_22/q bank_0/replica_bitcell_array_0/bitcell_array_0/cell_1rw_22/qb vdd sky130_fd_pr__nfet_01v8 ad=0 pd=0 as=7.728n ps=0.42m w=126 l=15
X915 bank_0/replica_bitcell_array_0/bitcell_array_0/cell_1rw_22/q bank_0/replica_bitcell_array_0/bitcell_array_0/cell_1rw_22/qb vdd vdd sky130_fd_pr__nfet_01v8 ad=7.728n pd=0.42m as=0 ps=0 w=126 l=15
X916 bank_0/replica_bitcell_array_0/bitcell_array_0/cell_1rw_22/qb bank_0/port_address_0/wl_9 vdd vdd sky130_fd_pr__nfet_01v8 ad=0 pd=0 as=0 ps=0 w=42 l=15
X917 vdd bank_0/replica_bitcell_array_0/bitcell_array_0/cell_1rw_22/q bank_0/replica_bitcell_array_0/bitcell_array_0/cell_1rw_22/qb vdd sky130_fd_pr__pfet_01v8 ad=0 pd=0 as=1.925n ps=0.18m w=55 l=15
X918 bank_0/replica_bitcell_array_0/bitcell_array_0/cell_1rw_22/q bank_0/port_address_0/wl_9 vdd vdd sky130_fd_pr__nfet_01v8 ad=0 pd=0 as=0 ps=0 w=42 l=15
X919 bank_0/replica_bitcell_array_0/bitcell_array_0/cell_1rw_11/q bank_0/replica_bitcell_array_0/bitcell_array_0/cell_1rw_11/qb vdd vdd sky130_fd_pr__pfet_01v8 ad=1.925n pd=0.18m as=0 ps=0 w=55 l=15
X920 vdd bank_0/replica_bitcell_array_0/bitcell_array_0/cell_1rw_11/q bank_0/replica_bitcell_array_0/bitcell_array_0/cell_1rw_11/qb vdd sky130_fd_pr__nfet_01v8 ad=0 pd=0 as=7.728n ps=0.42m w=126 l=15
X921 bank_0/replica_bitcell_array_0/bitcell_array_0/cell_1rw_11/q bank_0/replica_bitcell_array_0/bitcell_array_0/cell_1rw_11/qb vdd vdd sky130_fd_pr__nfet_01v8 ad=7.728n pd=0.42m as=0 ps=0 w=126 l=15
X922 bank_0/replica_bitcell_array_0/bitcell_array_0/cell_1rw_11/qb bank_0/port_address_0/wl_4 vdd vdd sky130_fd_pr__nfet_01v8 ad=0 pd=0 as=0 ps=0 w=42 l=15
X923 vdd bank_0/replica_bitcell_array_0/bitcell_array_0/cell_1rw_11/q bank_0/replica_bitcell_array_0/bitcell_array_0/cell_1rw_11/qb vdd sky130_fd_pr__pfet_01v8 ad=0 pd=0 as=1.925n ps=0.18m w=55 l=15
X924 bank_0/replica_bitcell_array_0/bitcell_array_0/cell_1rw_11/q bank_0/port_address_0/wl_4 vdd vdd sky130_fd_pr__nfet_01v8 ad=0 pd=0 as=0 ps=0 w=42 l=15
X925 bank_0/replica_bitcell_array_0/bitcell_array_0/cell_1rw_23/q bank_0/replica_bitcell_array_0/bitcell_array_0/cell_1rw_23/qb vdd vdd sky130_fd_pr__pfet_01v8 ad=1.925n pd=0.18m as=0 ps=0 w=55 l=15
X926 vdd bank_0/replica_bitcell_array_0/bitcell_array_0/cell_1rw_23/q bank_0/replica_bitcell_array_0/bitcell_array_0/cell_1rw_23/qb vdd sky130_fd_pr__nfet_01v8 ad=0 pd=0 as=7.728n ps=0.42m w=126 l=15
X927 bank_0/replica_bitcell_array_0/bitcell_array_0/cell_1rw_23/q bank_0/replica_bitcell_array_0/bitcell_array_0/cell_1rw_23/qb vdd vdd sky130_fd_pr__nfet_01v8 ad=7.728n pd=0.42m as=0 ps=0 w=126 l=15
X928 bank_0/replica_bitcell_array_0/bitcell_array_0/cell_1rw_23/qb bank_0/port_address_0/wl_8 vdd vdd sky130_fd_pr__nfet_01v8 ad=0 pd=0 as=0 ps=0 w=42 l=15
X929 vdd bank_0/replica_bitcell_array_0/bitcell_array_0/cell_1rw_23/q bank_0/replica_bitcell_array_0/bitcell_array_0/cell_1rw_23/qb vdd sky130_fd_pr__pfet_01v8 ad=0 pd=0 as=1.925n ps=0.18m w=55 l=15
X930 bank_0/replica_bitcell_array_0/bitcell_array_0/cell_1rw_23/q bank_0/port_address_0/wl_8 vdd vdd sky130_fd_pr__nfet_01v8 ad=0 pd=0 as=0 ps=0 w=42 l=15
X931 bank_0/replica_bitcell_array_0/bitcell_array_0/cell_1rw_12/q bank_0/replica_bitcell_array_0/bitcell_array_0/cell_1rw_12/qb vdd vdd sky130_fd_pr__pfet_01v8 ad=1.925n pd=0.18m as=0 ps=0 w=55 l=15
X932 vdd bank_0/replica_bitcell_array_0/bitcell_array_0/cell_1rw_12/q bank_0/replica_bitcell_array_0/bitcell_array_0/cell_1rw_12/qb vdd sky130_fd_pr__nfet_01v8 ad=0 pd=0 as=7.728n ps=0.42m w=126 l=15
X933 bank_0/replica_bitcell_array_0/bitcell_array_0/cell_1rw_12/q bank_0/replica_bitcell_array_0/bitcell_array_0/cell_1rw_12/qb vdd vdd sky130_fd_pr__nfet_01v8 ad=7.728n pd=0.42m as=0 ps=0 w=126 l=15
X934 bank_0/replica_bitcell_array_0/bitcell_array_0/cell_1rw_12/qb bank_0/port_address_0/wl_3 vdd vdd sky130_fd_pr__nfet_01v8 ad=0 pd=0 as=0 ps=0 w=42 l=15
X935 vdd bank_0/replica_bitcell_array_0/bitcell_array_0/cell_1rw_12/q bank_0/replica_bitcell_array_0/bitcell_array_0/cell_1rw_12/qb vdd sky130_fd_pr__pfet_01v8 ad=0 pd=0 as=1.925n ps=0.18m w=55 l=15
X936 bank_0/replica_bitcell_array_0/bitcell_array_0/cell_1rw_12/q bank_0/port_address_0/wl_3 vdd vdd sky130_fd_pr__nfet_01v8 ad=0 pd=0 as=0 ps=0 w=42 l=15
X937 bank_0/replica_bitcell_array_0/bitcell_array_0/cell_1rw_24/q bank_0/replica_bitcell_array_0/bitcell_array_0/cell_1rw_24/qb vdd vdd sky130_fd_pr__pfet_01v8 ad=1.925n pd=0.18m as=0 ps=0 w=55 l=15
X938 vdd bank_0/replica_bitcell_array_0/bitcell_array_0/cell_1rw_24/q bank_0/replica_bitcell_array_0/bitcell_array_0/cell_1rw_24/qb vdd sky130_fd_pr__nfet_01v8 ad=0 pd=0 as=7.728n ps=0.42m w=126 l=15
X939 bank_0/replica_bitcell_array_0/bitcell_array_0/cell_1rw_24/q bank_0/replica_bitcell_array_0/bitcell_array_0/cell_1rw_24/qb vdd vdd sky130_fd_pr__nfet_01v8 ad=7.728n pd=0.42m as=0 ps=0 w=126 l=15
X940 bank_0/replica_bitcell_array_0/bitcell_array_0/cell_1rw_24/qb bank_0/port_address_0/wl_7 vdd vdd sky130_fd_pr__nfet_01v8 ad=0 pd=0 as=0 ps=0 w=42 l=15
X941 vdd bank_0/replica_bitcell_array_0/bitcell_array_0/cell_1rw_24/q bank_0/replica_bitcell_array_0/bitcell_array_0/cell_1rw_24/qb vdd sky130_fd_pr__pfet_01v8 ad=0 pd=0 as=1.925n ps=0.18m w=55 l=15
X942 bank_0/replica_bitcell_array_0/bitcell_array_0/cell_1rw_24/q bank_0/port_address_0/wl_7 vdd vdd sky130_fd_pr__nfet_01v8 ad=0 pd=0 as=0 ps=0 w=42 l=15
X943 bank_0/replica_bitcell_array_0/bitcell_array_0/cell_1rw_13/q bank_0/replica_bitcell_array_0/bitcell_array_0/cell_1rw_13/qb vdd vdd sky130_fd_pr__pfet_01v8 ad=1.925n pd=0.18m as=0 ps=0 w=55 l=15
X944 vdd bank_0/replica_bitcell_array_0/bitcell_array_0/cell_1rw_13/q bank_0/replica_bitcell_array_0/bitcell_array_0/cell_1rw_13/qb vdd sky130_fd_pr__nfet_01v8 ad=0 pd=0 as=7.728n ps=0.42m w=126 l=15
X945 bank_0/replica_bitcell_array_0/bitcell_array_0/cell_1rw_13/q bank_0/replica_bitcell_array_0/bitcell_array_0/cell_1rw_13/qb vdd vdd sky130_fd_pr__nfet_01v8 ad=7.728n pd=0.42m as=0 ps=0 w=126 l=15
X946 bank_0/replica_bitcell_array_0/bitcell_array_0/cell_1rw_13/qb bank_0/port_address_0/wl_2 vdd vdd sky130_fd_pr__nfet_01v8 ad=0 pd=0 as=0 ps=0 w=42 l=15
X947 vdd bank_0/replica_bitcell_array_0/bitcell_array_0/cell_1rw_13/q bank_0/replica_bitcell_array_0/bitcell_array_0/cell_1rw_13/qb vdd sky130_fd_pr__pfet_01v8 ad=0 pd=0 as=1.925n ps=0.18m w=55 l=15
X948 bank_0/replica_bitcell_array_0/bitcell_array_0/cell_1rw_13/q bank_0/port_address_0/wl_2 vdd vdd sky130_fd_pr__nfet_01v8 ad=0 pd=0 as=0 ps=0 w=42 l=15
X949 bank_0/replica_bitcell_array_0/bitcell_array_0/cell_1rw_25/q bank_0/replica_bitcell_array_0/bitcell_array_0/cell_1rw_25/qb vdd vdd sky130_fd_pr__pfet_01v8 ad=1.925n pd=0.18m as=0 ps=0 w=55 l=15
X950 vdd bank_0/replica_bitcell_array_0/bitcell_array_0/cell_1rw_25/q bank_0/replica_bitcell_array_0/bitcell_array_0/cell_1rw_25/qb vdd sky130_fd_pr__nfet_01v8 ad=0 pd=0 as=7.728n ps=0.42m w=126 l=15
X951 bank_0/replica_bitcell_array_0/bitcell_array_0/cell_1rw_25/q bank_0/replica_bitcell_array_0/bitcell_array_0/cell_1rw_25/qb vdd vdd sky130_fd_pr__nfet_01v8 ad=7.728n pd=0.42m as=0 ps=0 w=126 l=15
X952 bank_0/replica_bitcell_array_0/bitcell_array_0/cell_1rw_25/qb bank_0/port_address_0/wl_6 vdd vdd sky130_fd_pr__nfet_01v8 ad=0 pd=0 as=0 ps=0 w=42 l=15
X953 vdd bank_0/replica_bitcell_array_0/bitcell_array_0/cell_1rw_25/q bank_0/replica_bitcell_array_0/bitcell_array_0/cell_1rw_25/qb vdd sky130_fd_pr__pfet_01v8 ad=0 pd=0 as=1.925n ps=0.18m w=55 l=15
X954 bank_0/replica_bitcell_array_0/bitcell_array_0/cell_1rw_25/q bank_0/port_address_0/wl_6 vdd vdd sky130_fd_pr__nfet_01v8 ad=0 pd=0 as=0 ps=0 w=42 l=15
X955 bank_0/replica_bitcell_array_0/bitcell_array_0/cell_1rw_14/q bank_0/replica_bitcell_array_0/bitcell_array_0/cell_1rw_14/qb vdd vdd sky130_fd_pr__pfet_01v8 ad=1.925n pd=0.18m as=0 ps=0 w=55 l=15
X956 vdd bank_0/replica_bitcell_array_0/bitcell_array_0/cell_1rw_14/q bank_0/replica_bitcell_array_0/bitcell_array_0/cell_1rw_14/qb vdd sky130_fd_pr__nfet_01v8 ad=0 pd=0 as=7.728n ps=0.42m w=126 l=15
X957 bank_0/replica_bitcell_array_0/bitcell_array_0/cell_1rw_14/q bank_0/replica_bitcell_array_0/bitcell_array_0/cell_1rw_14/qb vdd vdd sky130_fd_pr__nfet_01v8 ad=7.728n pd=0.42m as=0 ps=0 w=126 l=15
X958 bank_0/replica_bitcell_array_0/bitcell_array_0/cell_1rw_14/qb bank_0/port_address_0/wl_1 vdd vdd sky130_fd_pr__nfet_01v8 ad=0 pd=0 as=0 ps=0 w=42 l=15
X959 vdd bank_0/replica_bitcell_array_0/bitcell_array_0/cell_1rw_14/q bank_0/replica_bitcell_array_0/bitcell_array_0/cell_1rw_14/qb vdd sky130_fd_pr__pfet_01v8 ad=0 pd=0 as=1.925n ps=0.18m w=55 l=15
X960 bank_0/replica_bitcell_array_0/bitcell_array_0/cell_1rw_14/q bank_0/port_address_0/wl_1 vdd vdd sky130_fd_pr__nfet_01v8 ad=0 pd=0 as=0 ps=0 w=42 l=15
X961 bank_0/replica_bitcell_array_0/bitcell_array_0/cell_1rw_26/q bank_0/replica_bitcell_array_0/bitcell_array_0/cell_1rw_26/qb vdd vdd sky130_fd_pr__pfet_01v8 ad=1.925n pd=0.18m as=0 ps=0 w=55 l=15
X962 vdd bank_0/replica_bitcell_array_0/bitcell_array_0/cell_1rw_26/q bank_0/replica_bitcell_array_0/bitcell_array_0/cell_1rw_26/qb vdd sky130_fd_pr__nfet_01v8 ad=0 pd=0 as=7.728n ps=0.42m w=126 l=15
X963 bank_0/replica_bitcell_array_0/bitcell_array_0/cell_1rw_26/q bank_0/replica_bitcell_array_0/bitcell_array_0/cell_1rw_26/qb vdd vdd sky130_fd_pr__nfet_01v8 ad=7.728n pd=0.42m as=0 ps=0 w=126 l=15
X964 bank_0/replica_bitcell_array_0/bitcell_array_0/cell_1rw_26/qb bank_0/port_address_0/wl_5 vdd vdd sky130_fd_pr__nfet_01v8 ad=0 pd=0 as=0 ps=0 w=42 l=15
X965 vdd bank_0/replica_bitcell_array_0/bitcell_array_0/cell_1rw_26/q bank_0/replica_bitcell_array_0/bitcell_array_0/cell_1rw_26/qb vdd sky130_fd_pr__pfet_01v8 ad=0 pd=0 as=1.925n ps=0.18m w=55 l=15
X966 bank_0/replica_bitcell_array_0/bitcell_array_0/cell_1rw_26/q bank_0/port_address_0/wl_5 vdd vdd sky130_fd_pr__nfet_01v8 ad=0 pd=0 as=0 ps=0 w=42 l=15
X967 bank_0/replica_bitcell_array_0/bitcell_array_0/cell_1rw_15/q bank_0/replica_bitcell_array_0/bitcell_array_0/cell_1rw_15/qb vdd vdd sky130_fd_pr__pfet_01v8 ad=1.925n pd=0.18m as=0 ps=0 w=55 l=15
X968 vdd bank_0/replica_bitcell_array_0/bitcell_array_0/cell_1rw_15/q bank_0/replica_bitcell_array_0/bitcell_array_0/cell_1rw_15/qb vdd sky130_fd_pr__nfet_01v8 ad=0 pd=0 as=7.728n ps=0.42m w=126 l=15
X969 bank_0/replica_bitcell_array_0/bitcell_array_0/cell_1rw_15/q bank_0/replica_bitcell_array_0/bitcell_array_0/cell_1rw_15/qb vdd vdd sky130_fd_pr__nfet_01v8 ad=7.728n pd=0.42m as=0 ps=0 w=126 l=15
X970 bank_0/replica_bitcell_array_0/bitcell_array_0/cell_1rw_15/qb bank_0/port_address_0/wl_0 vdd vdd sky130_fd_pr__nfet_01v8 ad=0 pd=0 as=0 ps=0 w=42 l=15
X971 vdd bank_0/replica_bitcell_array_0/bitcell_array_0/cell_1rw_15/q bank_0/replica_bitcell_array_0/bitcell_array_0/cell_1rw_15/qb vdd sky130_fd_pr__pfet_01v8 ad=0 pd=0 as=1.925n ps=0.18m w=55 l=15
X972 bank_0/replica_bitcell_array_0/bitcell_array_0/cell_1rw_15/q bank_0/port_address_0/wl_0 vdd vdd sky130_fd_pr__nfet_01v8 ad=0 pd=0 as=0 ps=0 w=42 l=15
X973 bank_0/replica_bitcell_array_0/bitcell_array_0/cell_1rw_16/q bank_0/replica_bitcell_array_0/bitcell_array_0/cell_1rw_16/qb vdd vdd sky130_fd_pr__pfet_01v8 ad=1.925n pd=0.18m as=0 ps=0 w=55 l=15
X974 vdd bank_0/replica_bitcell_array_0/bitcell_array_0/cell_1rw_16/q bank_0/replica_bitcell_array_0/bitcell_array_0/cell_1rw_16/qb vdd sky130_fd_pr__nfet_01v8 ad=0 pd=0 as=7.728n ps=0.42m w=126 l=15
X975 bank_0/replica_bitcell_array_0/bitcell_array_0/cell_1rw_16/q bank_0/replica_bitcell_array_0/bitcell_array_0/cell_1rw_16/qb vdd vdd sky130_fd_pr__nfet_01v8 ad=7.728n pd=0.42m as=0 ps=0 w=126 l=15
X976 bank_0/replica_bitcell_array_0/bitcell_array_0/cell_1rw_16/qb bank_0/port_address_0/wl_15 vdd vdd sky130_fd_pr__nfet_01v8 ad=0 pd=0 as=0 ps=0 w=42 l=15
X977 vdd bank_0/replica_bitcell_array_0/bitcell_array_0/cell_1rw_16/q bank_0/replica_bitcell_array_0/bitcell_array_0/cell_1rw_16/qb vdd sky130_fd_pr__pfet_01v8 ad=0 pd=0 as=1.925n ps=0.18m w=55 l=15
X978 bank_0/replica_bitcell_array_0/bitcell_array_0/cell_1rw_16/q bank_0/port_address_0/wl_15 vdd vdd sky130_fd_pr__nfet_01v8 ad=0 pd=0 as=0 ps=0 w=42 l=15
X979 bank_0/replica_bitcell_array_0/bitcell_array_0/cell_1rw_27/q bank_0/replica_bitcell_array_0/bitcell_array_0/cell_1rw_27/qb vdd vdd sky130_fd_pr__pfet_01v8 ad=1.925n pd=0.18m as=0 ps=0 w=55 l=15
X980 vdd bank_0/replica_bitcell_array_0/bitcell_array_0/cell_1rw_27/q bank_0/replica_bitcell_array_0/bitcell_array_0/cell_1rw_27/qb vdd sky130_fd_pr__nfet_01v8 ad=0 pd=0 as=7.728n ps=0.42m w=126 l=15
X981 bank_0/replica_bitcell_array_0/bitcell_array_0/cell_1rw_27/q bank_0/replica_bitcell_array_0/bitcell_array_0/cell_1rw_27/qb vdd vdd sky130_fd_pr__nfet_01v8 ad=7.728n pd=0.42m as=0 ps=0 w=126 l=15
X982 bank_0/replica_bitcell_array_0/bitcell_array_0/cell_1rw_27/qb bank_0/port_address_0/wl_4 vdd vdd sky130_fd_pr__nfet_01v8 ad=0 pd=0 as=0 ps=0 w=42 l=15
X983 vdd bank_0/replica_bitcell_array_0/bitcell_array_0/cell_1rw_27/q bank_0/replica_bitcell_array_0/bitcell_array_0/cell_1rw_27/qb vdd sky130_fd_pr__pfet_01v8 ad=0 pd=0 as=1.925n ps=0.18m w=55 l=15
X984 bank_0/replica_bitcell_array_0/bitcell_array_0/cell_1rw_27/q bank_0/port_address_0/wl_4 vdd vdd sky130_fd_pr__nfet_01v8 ad=0 pd=0 as=0 ps=0 w=42 l=15
X985 bank_0/replica_bitcell_array_0/bitcell_array_0/cell_1rw_17/q bank_0/replica_bitcell_array_0/bitcell_array_0/cell_1rw_17/qb vdd vdd sky130_fd_pr__pfet_01v8 ad=1.925n pd=0.18m as=0 ps=0 w=55 l=15
X986 vdd bank_0/replica_bitcell_array_0/bitcell_array_0/cell_1rw_17/q bank_0/replica_bitcell_array_0/bitcell_array_0/cell_1rw_17/qb vdd sky130_fd_pr__nfet_01v8 ad=0 pd=0 as=7.728n ps=0.42m w=126 l=15
X987 bank_0/replica_bitcell_array_0/bitcell_array_0/cell_1rw_17/q bank_0/replica_bitcell_array_0/bitcell_array_0/cell_1rw_17/qb vdd vdd sky130_fd_pr__nfet_01v8 ad=7.728n pd=0.42m as=0 ps=0 w=126 l=15
X988 bank_0/replica_bitcell_array_0/bitcell_array_0/cell_1rw_17/qb bank_0/port_address_0/wl_14 vdd vdd sky130_fd_pr__nfet_01v8 ad=0 pd=0 as=0 ps=0 w=42 l=15
X989 vdd bank_0/replica_bitcell_array_0/bitcell_array_0/cell_1rw_17/q bank_0/replica_bitcell_array_0/bitcell_array_0/cell_1rw_17/qb vdd sky130_fd_pr__pfet_01v8 ad=0 pd=0 as=1.925n ps=0.18m w=55 l=15
X990 bank_0/replica_bitcell_array_0/bitcell_array_0/cell_1rw_17/q bank_0/port_address_0/wl_14 vdd vdd sky130_fd_pr__nfet_01v8 ad=0 pd=0 as=0 ps=0 w=42 l=15
X991 bank_0/replica_bitcell_array_0/bitcell_array_0/cell_1rw_28/q bank_0/replica_bitcell_array_0/bitcell_array_0/cell_1rw_28/qb vdd vdd sky130_fd_pr__pfet_01v8 ad=1.925n pd=0.18m as=0 ps=0 w=55 l=15
X992 vdd bank_0/replica_bitcell_array_0/bitcell_array_0/cell_1rw_28/q bank_0/replica_bitcell_array_0/bitcell_array_0/cell_1rw_28/qb vdd sky130_fd_pr__nfet_01v8 ad=0 pd=0 as=7.728n ps=0.42m w=126 l=15
X993 bank_0/replica_bitcell_array_0/bitcell_array_0/cell_1rw_28/q bank_0/replica_bitcell_array_0/bitcell_array_0/cell_1rw_28/qb vdd vdd sky130_fd_pr__nfet_01v8 ad=7.728n pd=0.42m as=0 ps=0 w=126 l=15
X994 bank_0/replica_bitcell_array_0/bitcell_array_0/cell_1rw_28/qb bank_0/port_address_0/wl_3 vdd vdd sky130_fd_pr__nfet_01v8 ad=0 pd=0 as=0 ps=0 w=42 l=15
X995 vdd bank_0/replica_bitcell_array_0/bitcell_array_0/cell_1rw_28/q bank_0/replica_bitcell_array_0/bitcell_array_0/cell_1rw_28/qb vdd sky130_fd_pr__pfet_01v8 ad=0 pd=0 as=1.925n ps=0.18m w=55 l=15
X996 bank_0/replica_bitcell_array_0/bitcell_array_0/cell_1rw_28/q bank_0/port_address_0/wl_3 vdd vdd sky130_fd_pr__nfet_01v8 ad=0 pd=0 as=0 ps=0 w=42 l=15
X997 bank_0/replica_bitcell_array_0/bitcell_array_0/cell_1rw_18/q bank_0/replica_bitcell_array_0/bitcell_array_0/cell_1rw_18/qb vdd vdd sky130_fd_pr__pfet_01v8 ad=1.925n pd=0.18m as=0 ps=0 w=55 l=15
X998 vdd bank_0/replica_bitcell_array_0/bitcell_array_0/cell_1rw_18/q bank_0/replica_bitcell_array_0/bitcell_array_0/cell_1rw_18/qb vdd sky130_fd_pr__nfet_01v8 ad=0 pd=0 as=7.728n ps=0.42m w=126 l=15
X999 bank_0/replica_bitcell_array_0/bitcell_array_0/cell_1rw_18/q bank_0/replica_bitcell_array_0/bitcell_array_0/cell_1rw_18/qb vdd vdd sky130_fd_pr__nfet_01v8 ad=7.728n pd=0.42m as=0 ps=0 w=126 l=15
X1000 bank_0/replica_bitcell_array_0/bitcell_array_0/cell_1rw_18/qb bank_0/port_address_0/wl_13 vdd vdd sky130_fd_pr__nfet_01v8 ad=0 pd=0 as=0 ps=0 w=42 l=15
X1001 vdd bank_0/replica_bitcell_array_0/bitcell_array_0/cell_1rw_18/q bank_0/replica_bitcell_array_0/bitcell_array_0/cell_1rw_18/qb vdd sky130_fd_pr__pfet_01v8 ad=0 pd=0 as=1.925n ps=0.18m w=55 l=15
X1002 bank_0/replica_bitcell_array_0/bitcell_array_0/cell_1rw_18/q bank_0/port_address_0/wl_13 vdd vdd sky130_fd_pr__nfet_01v8 ad=0 pd=0 as=0 ps=0 w=42 l=15
X1003 bank_0/replica_bitcell_array_0/bitcell_array_0/cell_1rw_19/q bank_0/replica_bitcell_array_0/bitcell_array_0/cell_1rw_19/qb vdd vdd sky130_fd_pr__pfet_01v8 ad=1.925n pd=0.18m as=0 ps=0 w=55 l=15
X1004 vdd bank_0/replica_bitcell_array_0/bitcell_array_0/cell_1rw_19/q bank_0/replica_bitcell_array_0/bitcell_array_0/cell_1rw_19/qb vdd sky130_fd_pr__nfet_01v8 ad=0 pd=0 as=7.728n ps=0.42m w=126 l=15
X1005 bank_0/replica_bitcell_array_0/bitcell_array_0/cell_1rw_19/q bank_0/replica_bitcell_array_0/bitcell_array_0/cell_1rw_19/qb vdd vdd sky130_fd_pr__nfet_01v8 ad=7.728n pd=0.42m as=0 ps=0 w=126 l=15
X1006 bank_0/replica_bitcell_array_0/bitcell_array_0/cell_1rw_19/qb bank_0/port_address_0/wl_12 vdd vdd sky130_fd_pr__nfet_01v8 ad=0 pd=0 as=0 ps=0 w=42 l=15
X1007 vdd bank_0/replica_bitcell_array_0/bitcell_array_0/cell_1rw_19/q bank_0/replica_bitcell_array_0/bitcell_array_0/cell_1rw_19/qb vdd sky130_fd_pr__pfet_01v8 ad=0 pd=0 as=1.925n ps=0.18m w=55 l=15
X1008 bank_0/replica_bitcell_array_0/bitcell_array_0/cell_1rw_19/q bank_0/port_address_0/wl_12 vdd vdd sky130_fd_pr__nfet_01v8 ad=0 pd=0 as=0 ps=0 w=42 l=15
X1009 bank_0/replica_bitcell_array_0/bitcell_array_0/cell_1rw_29/q bank_0/replica_bitcell_array_0/bitcell_array_0/cell_1rw_29/qb vdd vdd sky130_fd_pr__pfet_01v8 ad=1.925n pd=0.18m as=0 ps=0 w=55 l=15
X1010 vdd bank_0/replica_bitcell_array_0/bitcell_array_0/cell_1rw_29/q bank_0/replica_bitcell_array_0/bitcell_array_0/cell_1rw_29/qb vdd sky130_fd_pr__nfet_01v8 ad=0 pd=0 as=7.728n ps=0.42m w=126 l=15
X1011 bank_0/replica_bitcell_array_0/bitcell_array_0/cell_1rw_29/q bank_0/replica_bitcell_array_0/bitcell_array_0/cell_1rw_29/qb vdd vdd sky130_fd_pr__nfet_01v8 ad=7.728n pd=0.42m as=0 ps=0 w=126 l=15
X1012 bank_0/replica_bitcell_array_0/bitcell_array_0/cell_1rw_29/qb bank_0/port_address_0/wl_2 vdd vdd sky130_fd_pr__nfet_01v8 ad=0 pd=0 as=0 ps=0 w=42 l=15
X1013 vdd bank_0/replica_bitcell_array_0/bitcell_array_0/cell_1rw_29/q bank_0/replica_bitcell_array_0/bitcell_array_0/cell_1rw_29/qb vdd sky130_fd_pr__pfet_01v8 ad=0 pd=0 as=1.925n ps=0.18m w=55 l=15
X1014 bank_0/replica_bitcell_array_0/bitcell_array_0/cell_1rw_29/q bank_0/port_address_0/wl_2 vdd vdd sky130_fd_pr__nfet_01v8 ad=0 pd=0 as=0 ps=0 w=42 l=15
X1015 bank_0/replica_bitcell_array_0/dummy_array_3_0/dummy_cell_1rw_10/q bank_0/replica_bitcell_array_0/dummy_array_3_0/dummy_cell_1rw_10/qb vdd vdd sky130_fd_pr__pfet_01v8 ad=1.925n pd=0.18m as=0 ps=0 w=55 l=15
X1016 vdd bank_0/replica_bitcell_array_0/dummy_array_3_0/dummy_cell_1rw_10/q bank_0/replica_bitcell_array_0/dummy_array_3_0/dummy_cell_1rw_10/qb vdd sky130_fd_pr__nfet_01v8 ad=0 pd=0 as=7.728n ps=0.42m w=126 l=15
X1017 bank_0/replica_bitcell_array_0/dummy_array_3_0/dummy_cell_1rw_10/q bank_0/replica_bitcell_array_0/dummy_array_3_0/dummy_cell_1rw_10/qb vdd vdd sky130_fd_pr__nfet_01v8 ad=7.728n pd=0.42m as=0 ps=0 w=126 l=15
X1018 bank_0/replica_bitcell_array_0/dummy_array_3_0/dummy_cell_1rw_10/qb bank_0/port_address_0/wl_6 bank_0/replica_bitcell_array_0/dummy_array_3_0/dummy_cell_1rw_10/a_145_76# vdd sky130_fd_pr__nfet_01v8 ad=0 pd=0 as=1.428n ps=0.152m w=42 l=15
X1019 vdd bank_0/replica_bitcell_array_0/dummy_array_3_0/dummy_cell_1rw_10/q bank_0/replica_bitcell_array_0/dummy_array_3_0/dummy_cell_1rw_10/qb vdd sky130_fd_pr__pfet_01v8 ad=0 pd=0 as=1.925n ps=0.18m w=55 l=15
X1020 bank_0/replica_bitcell_array_0/dummy_array_3_0/dummy_cell_1rw_10/q bank_0/port_address_0/wl_6 bank_0/replica_bitcell_array_0/dummy_array_3_0/dummy_cell_1rw_10/a_76_76# vdd sky130_fd_pr__nfet_01v8 ad=0 pd=0 as=1.428n ps=0.152m w=42 l=15
X1021 bank_0/replica_bitcell_array_0/dummy_array_3_0/dummy_cell_1rw_11/q bank_0/replica_bitcell_array_0/dummy_array_3_0/dummy_cell_1rw_11/qb vdd vdd sky130_fd_pr__pfet_01v8 ad=1.925n pd=0.18m as=0 ps=0 w=55 l=15
X1022 vdd bank_0/replica_bitcell_array_0/dummy_array_3_0/dummy_cell_1rw_11/q bank_0/replica_bitcell_array_0/dummy_array_3_0/dummy_cell_1rw_11/qb vdd sky130_fd_pr__nfet_01v8 ad=0 pd=0 as=7.728n ps=0.42m w=126 l=15
X1023 bank_0/replica_bitcell_array_0/dummy_array_3_0/dummy_cell_1rw_11/q bank_0/replica_bitcell_array_0/dummy_array_3_0/dummy_cell_1rw_11/qb vdd vdd sky130_fd_pr__nfet_01v8 ad=7.728n pd=0.42m as=0 ps=0 w=126 l=15
X1024 bank_0/replica_bitcell_array_0/dummy_array_3_0/dummy_cell_1rw_11/qb bank_0/port_address_0/wl_5 bank_0/replica_bitcell_array_0/dummy_array_3_0/dummy_cell_1rw_11/a_145_76# vdd sky130_fd_pr__nfet_01v8 ad=0 pd=0 as=1.428n ps=0.152m w=42 l=15
X1025 vdd bank_0/replica_bitcell_array_0/dummy_array_3_0/dummy_cell_1rw_11/q bank_0/replica_bitcell_array_0/dummy_array_3_0/dummy_cell_1rw_11/qb vdd sky130_fd_pr__pfet_01v8 ad=0 pd=0 as=1.925n ps=0.18m w=55 l=15
X1026 bank_0/replica_bitcell_array_0/dummy_array_3_0/dummy_cell_1rw_11/q bank_0/port_address_0/wl_5 bank_0/replica_bitcell_array_0/dummy_array_3_0/dummy_cell_1rw_11/a_76_76# vdd sky130_fd_pr__nfet_01v8 ad=0 pd=0 as=1.428n ps=0.152m w=42 l=15
X1027 bank_0/replica_bitcell_array_0/dummy_array_3_0/dummy_cell_1rw_0/q bank_0/replica_bitcell_array_0/dummy_array_3_0/dummy_cell_1rw_0/qb vdd vdd sky130_fd_pr__pfet_01v8 ad=1.925n pd=0.18m as=0 ps=0 w=55 l=15
X1028 vdd bank_0/replica_bitcell_array_0/dummy_array_3_0/dummy_cell_1rw_0/q bank_0/replica_bitcell_array_0/dummy_array_3_0/dummy_cell_1rw_0/qb vdd sky130_fd_pr__nfet_01v8 ad=0 pd=0 as=7.728n ps=0.42m w=126 l=15
X1029 bank_0/replica_bitcell_array_0/dummy_array_3_0/dummy_cell_1rw_0/q bank_0/replica_bitcell_array_0/dummy_array_3_0/dummy_cell_1rw_0/qb vdd vdd sky130_fd_pr__nfet_01v8 ad=7.728n pd=0.42m as=0 ps=0 w=126 l=15
X1030 bank_0/replica_bitcell_array_0/dummy_array_3_0/dummy_cell_1rw_0/qb vdd bank_0/replica_bitcell_array_0/dummy_array_3_0/dummy_cell_1rw_0/a_145_76# vdd sky130_fd_pr__nfet_01v8 ad=0 pd=0 as=1.428n ps=0.152m w=42 l=15
X1031 vdd bank_0/replica_bitcell_array_0/dummy_array_3_0/dummy_cell_1rw_0/q bank_0/replica_bitcell_array_0/dummy_array_3_0/dummy_cell_1rw_0/qb vdd sky130_fd_pr__pfet_01v8 ad=0 pd=0 as=1.925n ps=0.18m w=55 l=15
X1032 bank_0/replica_bitcell_array_0/dummy_array_3_0/dummy_cell_1rw_0/q vdd bank_0/replica_bitcell_array_0/dummy_array_3_0/dummy_cell_1rw_0/a_76_76# vdd sky130_fd_pr__nfet_01v8 ad=0 pd=0 as=1.428n ps=0.152m w=42 l=15
X1033 bank_0/replica_bitcell_array_0/dummy_array_3_0/dummy_cell_1rw_12/q bank_0/replica_bitcell_array_0/dummy_array_3_0/dummy_cell_1rw_12/qb vdd vdd sky130_fd_pr__pfet_01v8 ad=1.925n pd=0.18m as=0 ps=0 w=55 l=15
X1034 vdd bank_0/replica_bitcell_array_0/dummy_array_3_0/dummy_cell_1rw_12/q bank_0/replica_bitcell_array_0/dummy_array_3_0/dummy_cell_1rw_12/qb vdd sky130_fd_pr__nfet_01v8 ad=0 pd=0 as=7.728n ps=0.42m w=126 l=15
X1035 bank_0/replica_bitcell_array_0/dummy_array_3_0/dummy_cell_1rw_12/q bank_0/replica_bitcell_array_0/dummy_array_3_0/dummy_cell_1rw_12/qb vdd vdd sky130_fd_pr__nfet_01v8 ad=7.728n pd=0.42m as=0 ps=0 w=126 l=15
X1036 bank_0/replica_bitcell_array_0/dummy_array_3_0/dummy_cell_1rw_12/qb bank_0/port_address_0/wl_4 bank_0/replica_bitcell_array_0/dummy_array_3_0/dummy_cell_1rw_12/a_145_76# vdd sky130_fd_pr__nfet_01v8 ad=0 pd=0 as=1.428n ps=0.152m w=42 l=15
X1037 vdd bank_0/replica_bitcell_array_0/dummy_array_3_0/dummy_cell_1rw_12/q bank_0/replica_bitcell_array_0/dummy_array_3_0/dummy_cell_1rw_12/qb vdd sky130_fd_pr__pfet_01v8 ad=0 pd=0 as=1.925n ps=0.18m w=55 l=15
X1038 bank_0/replica_bitcell_array_0/dummy_array_3_0/dummy_cell_1rw_12/q bank_0/port_address_0/wl_4 bank_0/replica_bitcell_array_0/dummy_array_3_0/dummy_cell_1rw_12/a_76_76# vdd sky130_fd_pr__nfet_01v8 ad=0 pd=0 as=1.428n ps=0.152m w=42 l=15
X1039 bank_0/replica_bitcell_array_0/dummy_array_3_0/dummy_cell_1rw_1/q bank_0/replica_bitcell_array_0/dummy_array_3_0/dummy_cell_1rw_1/qb vdd vdd sky130_fd_pr__pfet_01v8 ad=1.925n pd=0.18m as=0 ps=0 w=55 l=15
X1040 vdd bank_0/replica_bitcell_array_0/dummy_array_3_0/dummy_cell_1rw_1/q bank_0/replica_bitcell_array_0/dummy_array_3_0/dummy_cell_1rw_1/qb vdd sky130_fd_pr__nfet_01v8 ad=0 pd=0 as=7.728n ps=0.42m w=126 l=15
X1041 bank_0/replica_bitcell_array_0/dummy_array_3_0/dummy_cell_1rw_1/q bank_0/replica_bitcell_array_0/dummy_array_3_0/dummy_cell_1rw_1/qb vdd vdd sky130_fd_pr__nfet_01v8 ad=7.728n pd=0.42m as=0 ps=0 w=126 l=15
X1042 bank_0/replica_bitcell_array_0/dummy_array_3_0/dummy_cell_1rw_1/qb bank_0/port_address_0/wl_15 bank_0/replica_bitcell_array_0/dummy_array_3_0/dummy_cell_1rw_1/a_145_76# vdd sky130_fd_pr__nfet_01v8 ad=0 pd=0 as=1.428n ps=0.152m w=42 l=15
X1043 vdd bank_0/replica_bitcell_array_0/dummy_array_3_0/dummy_cell_1rw_1/q bank_0/replica_bitcell_array_0/dummy_array_3_0/dummy_cell_1rw_1/qb vdd sky130_fd_pr__pfet_01v8 ad=0 pd=0 as=1.925n ps=0.18m w=55 l=15
X1044 bank_0/replica_bitcell_array_0/dummy_array_3_0/dummy_cell_1rw_1/q bank_0/port_address_0/wl_15 bank_0/replica_bitcell_array_0/dummy_array_3_0/dummy_cell_1rw_1/a_76_76# vdd sky130_fd_pr__nfet_01v8 ad=0 pd=0 as=1.428n ps=0.152m w=42 l=15
X1045 bank_0/replica_bitcell_array_0/dummy_array_3_0/dummy_cell_1rw_13/q bank_0/replica_bitcell_array_0/dummy_array_3_0/dummy_cell_1rw_13/qb vdd vdd sky130_fd_pr__pfet_01v8 ad=1.925n pd=0.18m as=0 ps=0 w=55 l=15
X1046 vdd bank_0/replica_bitcell_array_0/dummy_array_3_0/dummy_cell_1rw_13/q bank_0/replica_bitcell_array_0/dummy_array_3_0/dummy_cell_1rw_13/qb vdd sky130_fd_pr__nfet_01v8 ad=0 pd=0 as=7.728n ps=0.42m w=126 l=15
X1047 bank_0/replica_bitcell_array_0/dummy_array_3_0/dummy_cell_1rw_13/q bank_0/replica_bitcell_array_0/dummy_array_3_0/dummy_cell_1rw_13/qb vdd vdd sky130_fd_pr__nfet_01v8 ad=7.728n pd=0.42m as=0 ps=0 w=126 l=15
X1048 bank_0/replica_bitcell_array_0/dummy_array_3_0/dummy_cell_1rw_13/qb bank_0/port_address_0/wl_3 bank_0/replica_bitcell_array_0/dummy_array_3_0/dummy_cell_1rw_13/a_145_76# vdd sky130_fd_pr__nfet_01v8 ad=0 pd=0 as=1.428n ps=0.152m w=42 l=15
X1049 vdd bank_0/replica_bitcell_array_0/dummy_array_3_0/dummy_cell_1rw_13/q bank_0/replica_bitcell_array_0/dummy_array_3_0/dummy_cell_1rw_13/qb vdd sky130_fd_pr__pfet_01v8 ad=0 pd=0 as=1.925n ps=0.18m w=55 l=15
X1050 bank_0/replica_bitcell_array_0/dummy_array_3_0/dummy_cell_1rw_13/q bank_0/port_address_0/wl_3 bank_0/replica_bitcell_array_0/dummy_array_3_0/dummy_cell_1rw_13/a_76_76# vdd sky130_fd_pr__nfet_01v8 ad=0 pd=0 as=1.428n ps=0.152m w=42 l=15
X1051 bank_0/replica_bitcell_array_0/dummy_array_3_0/dummy_cell_1rw_2/q bank_0/replica_bitcell_array_0/dummy_array_3_0/dummy_cell_1rw_2/qb vdd vdd sky130_fd_pr__pfet_01v8 ad=1.925n pd=0.18m as=0 ps=0 w=55 l=15
X1052 vdd bank_0/replica_bitcell_array_0/dummy_array_3_0/dummy_cell_1rw_2/q bank_0/replica_bitcell_array_0/dummy_array_3_0/dummy_cell_1rw_2/qb vdd sky130_fd_pr__nfet_01v8 ad=0 pd=0 as=7.728n ps=0.42m w=126 l=15
X1053 bank_0/replica_bitcell_array_0/dummy_array_3_0/dummy_cell_1rw_2/q bank_0/replica_bitcell_array_0/dummy_array_3_0/dummy_cell_1rw_2/qb vdd vdd sky130_fd_pr__nfet_01v8 ad=7.728n pd=0.42m as=0 ps=0 w=126 l=15
X1054 bank_0/replica_bitcell_array_0/dummy_array_3_0/dummy_cell_1rw_2/qb bank_0/port_address_0/wl_14 bank_0/replica_bitcell_array_0/dummy_array_3_0/dummy_cell_1rw_2/a_145_76# vdd sky130_fd_pr__nfet_01v8 ad=0 pd=0 as=1.428n ps=0.152m w=42 l=15
X1055 vdd bank_0/replica_bitcell_array_0/dummy_array_3_0/dummy_cell_1rw_2/q bank_0/replica_bitcell_array_0/dummy_array_3_0/dummy_cell_1rw_2/qb vdd sky130_fd_pr__pfet_01v8 ad=0 pd=0 as=1.925n ps=0.18m w=55 l=15
X1056 bank_0/replica_bitcell_array_0/dummy_array_3_0/dummy_cell_1rw_2/q bank_0/port_address_0/wl_14 bank_0/replica_bitcell_array_0/dummy_array_3_0/dummy_cell_1rw_2/a_76_76# vdd sky130_fd_pr__nfet_01v8 ad=0 pd=0 as=1.428n ps=0.152m w=42 l=15
X1057 bank_0/replica_bitcell_array_0/dummy_array_3_0/dummy_cell_1rw_3/q bank_0/replica_bitcell_array_0/dummy_array_3_0/dummy_cell_1rw_3/qb vdd vdd sky130_fd_pr__pfet_01v8 ad=1.925n pd=0.18m as=0 ps=0 w=55 l=15
X1058 vdd bank_0/replica_bitcell_array_0/dummy_array_3_0/dummy_cell_1rw_3/q bank_0/replica_bitcell_array_0/dummy_array_3_0/dummy_cell_1rw_3/qb vdd sky130_fd_pr__nfet_01v8 ad=0 pd=0 as=7.728n ps=0.42m w=126 l=15
X1059 bank_0/replica_bitcell_array_0/dummy_array_3_0/dummy_cell_1rw_3/q bank_0/replica_bitcell_array_0/dummy_array_3_0/dummy_cell_1rw_3/qb vdd vdd sky130_fd_pr__nfet_01v8 ad=7.728n pd=0.42m as=0 ps=0 w=126 l=15
X1060 bank_0/replica_bitcell_array_0/dummy_array_3_0/dummy_cell_1rw_3/qb bank_0/port_address_0/wl_13 bank_0/replica_bitcell_array_0/dummy_array_3_0/dummy_cell_1rw_3/a_145_76# vdd sky130_fd_pr__nfet_01v8 ad=0 pd=0 as=1.428n ps=0.152m w=42 l=15
X1061 vdd bank_0/replica_bitcell_array_0/dummy_array_3_0/dummy_cell_1rw_3/q bank_0/replica_bitcell_array_0/dummy_array_3_0/dummy_cell_1rw_3/qb vdd sky130_fd_pr__pfet_01v8 ad=0 pd=0 as=1.925n ps=0.18m w=55 l=15
X1062 bank_0/replica_bitcell_array_0/dummy_array_3_0/dummy_cell_1rw_3/q bank_0/port_address_0/wl_13 bank_0/replica_bitcell_array_0/dummy_array_3_0/dummy_cell_1rw_3/a_76_76# vdd sky130_fd_pr__nfet_01v8 ad=0 pd=0 as=1.428n ps=0.152m w=42 l=15
X1063 bank_0/replica_bitcell_array_0/dummy_array_3_0/dummy_cell_1rw_14/q bank_0/replica_bitcell_array_0/dummy_array_3_0/dummy_cell_1rw_14/qb vdd vdd sky130_fd_pr__pfet_01v8 ad=1.925n pd=0.18m as=0 ps=0 w=55 l=15
X1064 vdd bank_0/replica_bitcell_array_0/dummy_array_3_0/dummy_cell_1rw_14/q bank_0/replica_bitcell_array_0/dummy_array_3_0/dummy_cell_1rw_14/qb vdd sky130_fd_pr__nfet_01v8 ad=0 pd=0 as=7.728n ps=0.42m w=126 l=15
X1065 bank_0/replica_bitcell_array_0/dummy_array_3_0/dummy_cell_1rw_14/q bank_0/replica_bitcell_array_0/dummy_array_3_0/dummy_cell_1rw_14/qb vdd vdd sky130_fd_pr__nfet_01v8 ad=7.728n pd=0.42m as=0 ps=0 w=126 l=15
X1066 bank_0/replica_bitcell_array_0/dummy_array_3_0/dummy_cell_1rw_14/qb bank_0/port_address_0/wl_2 bank_0/replica_bitcell_array_0/dummy_array_3_0/dummy_cell_1rw_14/a_145_76# vdd sky130_fd_pr__nfet_01v8 ad=0 pd=0 as=1.428n ps=0.152m w=42 l=15
X1067 vdd bank_0/replica_bitcell_array_0/dummy_array_3_0/dummy_cell_1rw_14/q bank_0/replica_bitcell_array_0/dummy_array_3_0/dummy_cell_1rw_14/qb vdd sky130_fd_pr__pfet_01v8 ad=0 pd=0 as=1.925n ps=0.18m w=55 l=15
X1068 bank_0/replica_bitcell_array_0/dummy_array_3_0/dummy_cell_1rw_14/q bank_0/port_address_0/wl_2 bank_0/replica_bitcell_array_0/dummy_array_3_0/dummy_cell_1rw_14/a_76_76# vdd sky130_fd_pr__nfet_01v8 ad=0 pd=0 as=1.428n ps=0.152m w=42 l=15
X1069 bank_0/replica_bitcell_array_0/dummy_array_3_0/dummy_cell_1rw_4/q bank_0/replica_bitcell_array_0/dummy_array_3_0/dummy_cell_1rw_4/qb vdd vdd sky130_fd_pr__pfet_01v8 ad=1.925n pd=0.18m as=0 ps=0 w=55 l=15
X1070 vdd bank_0/replica_bitcell_array_0/dummy_array_3_0/dummy_cell_1rw_4/q bank_0/replica_bitcell_array_0/dummy_array_3_0/dummy_cell_1rw_4/qb vdd sky130_fd_pr__nfet_01v8 ad=0 pd=0 as=7.728n ps=0.42m w=126 l=15
X1071 bank_0/replica_bitcell_array_0/dummy_array_3_0/dummy_cell_1rw_4/q bank_0/replica_bitcell_array_0/dummy_array_3_0/dummy_cell_1rw_4/qb vdd vdd sky130_fd_pr__nfet_01v8 ad=7.728n pd=0.42m as=0 ps=0 w=126 l=15
X1072 bank_0/replica_bitcell_array_0/dummy_array_3_0/dummy_cell_1rw_4/qb bank_0/port_address_0/wl_12 bank_0/replica_bitcell_array_0/dummy_array_3_0/dummy_cell_1rw_4/a_145_76# vdd sky130_fd_pr__nfet_01v8 ad=0 pd=0 as=1.428n ps=0.152m w=42 l=15
X1073 vdd bank_0/replica_bitcell_array_0/dummy_array_3_0/dummy_cell_1rw_4/q bank_0/replica_bitcell_array_0/dummy_array_3_0/dummy_cell_1rw_4/qb vdd sky130_fd_pr__pfet_01v8 ad=0 pd=0 as=1.925n ps=0.18m w=55 l=15
X1074 bank_0/replica_bitcell_array_0/dummy_array_3_0/dummy_cell_1rw_4/q bank_0/port_address_0/wl_12 bank_0/replica_bitcell_array_0/dummy_array_3_0/dummy_cell_1rw_4/a_76_76# vdd sky130_fd_pr__nfet_01v8 ad=0 pd=0 as=1.428n ps=0.152m w=42 l=15
X1075 bank_0/replica_bitcell_array_0/dummy_array_3_0/dummy_cell_1rw_15/q bank_0/replica_bitcell_array_0/dummy_array_3_0/dummy_cell_1rw_15/qb vdd vdd sky130_fd_pr__pfet_01v8 ad=1.925n pd=0.18m as=0 ps=0 w=55 l=15
X1076 vdd bank_0/replica_bitcell_array_0/dummy_array_3_0/dummy_cell_1rw_15/q bank_0/replica_bitcell_array_0/dummy_array_3_0/dummy_cell_1rw_15/qb vdd sky130_fd_pr__nfet_01v8 ad=0 pd=0 as=7.728n ps=0.42m w=126 l=15
X1077 bank_0/replica_bitcell_array_0/dummy_array_3_0/dummy_cell_1rw_15/q bank_0/replica_bitcell_array_0/dummy_array_3_0/dummy_cell_1rw_15/qb vdd vdd sky130_fd_pr__nfet_01v8 ad=7.728n pd=0.42m as=0 ps=0 w=126 l=15
X1078 bank_0/replica_bitcell_array_0/dummy_array_3_0/dummy_cell_1rw_15/qb bank_0/port_address_0/wl_1 bank_0/replica_bitcell_array_0/dummy_array_3_0/dummy_cell_1rw_15/a_145_76# vdd sky130_fd_pr__nfet_01v8 ad=0 pd=0 as=1.428n ps=0.152m w=42 l=15
X1079 vdd bank_0/replica_bitcell_array_0/dummy_array_3_0/dummy_cell_1rw_15/q bank_0/replica_bitcell_array_0/dummy_array_3_0/dummy_cell_1rw_15/qb vdd sky130_fd_pr__pfet_01v8 ad=0 pd=0 as=1.925n ps=0.18m w=55 l=15
X1080 bank_0/replica_bitcell_array_0/dummy_array_3_0/dummy_cell_1rw_15/q bank_0/port_address_0/wl_1 bank_0/replica_bitcell_array_0/dummy_array_3_0/dummy_cell_1rw_15/a_76_76# vdd sky130_fd_pr__nfet_01v8 ad=0 pd=0 as=1.428n ps=0.152m w=42 l=15
X1081 bank_0/replica_bitcell_array_0/dummy_array_3_0/dummy_cell_1rw_5/q bank_0/replica_bitcell_array_0/dummy_array_3_0/dummy_cell_1rw_5/qb vdd vdd sky130_fd_pr__pfet_01v8 ad=1.925n pd=0.18m as=0 ps=0 w=55 l=15
X1082 vdd bank_0/replica_bitcell_array_0/dummy_array_3_0/dummy_cell_1rw_5/q bank_0/replica_bitcell_array_0/dummy_array_3_0/dummy_cell_1rw_5/qb vdd sky130_fd_pr__nfet_01v8 ad=0 pd=0 as=7.728n ps=0.42m w=126 l=15
X1083 bank_0/replica_bitcell_array_0/dummy_array_3_0/dummy_cell_1rw_5/q bank_0/replica_bitcell_array_0/dummy_array_3_0/dummy_cell_1rw_5/qb vdd vdd sky130_fd_pr__nfet_01v8 ad=7.728n pd=0.42m as=0 ps=0 w=126 l=15
X1084 bank_0/replica_bitcell_array_0/dummy_array_3_0/dummy_cell_1rw_5/qb bank_0/port_address_0/wl_11 bank_0/replica_bitcell_array_0/dummy_array_3_0/dummy_cell_1rw_5/a_145_76# vdd sky130_fd_pr__nfet_01v8 ad=0 pd=0 as=1.428n ps=0.152m w=42 l=15
X1085 vdd bank_0/replica_bitcell_array_0/dummy_array_3_0/dummy_cell_1rw_5/q bank_0/replica_bitcell_array_0/dummy_array_3_0/dummy_cell_1rw_5/qb vdd sky130_fd_pr__pfet_01v8 ad=0 pd=0 as=1.925n ps=0.18m w=55 l=15
X1086 bank_0/replica_bitcell_array_0/dummy_array_3_0/dummy_cell_1rw_5/q bank_0/port_address_0/wl_11 bank_0/replica_bitcell_array_0/dummy_array_3_0/dummy_cell_1rw_5/a_76_76# vdd sky130_fd_pr__nfet_01v8 ad=0 pd=0 as=1.428n ps=0.152m w=42 l=15
X1087 bank_0/replica_bitcell_array_0/dummy_array_3_0/dummy_cell_1rw_16/q bank_0/replica_bitcell_array_0/dummy_array_3_0/dummy_cell_1rw_16/qb vdd vdd sky130_fd_pr__pfet_01v8 ad=1.925n pd=0.18m as=0 ps=0 w=55 l=15
X1088 vdd bank_0/replica_bitcell_array_0/dummy_array_3_0/dummy_cell_1rw_16/q bank_0/replica_bitcell_array_0/dummy_array_3_0/dummy_cell_1rw_16/qb vdd sky130_fd_pr__nfet_01v8 ad=0 pd=0 as=7.728n ps=0.42m w=126 l=15
X1089 bank_0/replica_bitcell_array_0/dummy_array_3_0/dummy_cell_1rw_16/q bank_0/replica_bitcell_array_0/dummy_array_3_0/dummy_cell_1rw_16/qb vdd vdd sky130_fd_pr__nfet_01v8 ad=7.728n pd=0.42m as=0 ps=0 w=126 l=15
X1090 bank_0/replica_bitcell_array_0/dummy_array_3_0/dummy_cell_1rw_16/qb bank_0/port_address_0/wl_0 bank_0/replica_bitcell_array_0/dummy_array_3_0/dummy_cell_1rw_16/a_145_76# vdd sky130_fd_pr__nfet_01v8 ad=0 pd=0 as=1.428n ps=0.152m w=42 l=15
X1091 vdd bank_0/replica_bitcell_array_0/dummy_array_3_0/dummy_cell_1rw_16/q bank_0/replica_bitcell_array_0/dummy_array_3_0/dummy_cell_1rw_16/qb vdd sky130_fd_pr__pfet_01v8 ad=0 pd=0 as=1.925n ps=0.18m w=55 l=15
X1092 bank_0/replica_bitcell_array_0/dummy_array_3_0/dummy_cell_1rw_16/q bank_0/port_address_0/wl_0 bank_0/replica_bitcell_array_0/dummy_array_3_0/dummy_cell_1rw_16/a_76_76# vdd sky130_fd_pr__nfet_01v8 ad=0 pd=0 as=1.428n ps=0.152m w=42 l=15
X1093 bank_0/replica_bitcell_array_0/dummy_array_3_0/dummy_cell_1rw_6/q bank_0/replica_bitcell_array_0/dummy_array_3_0/dummy_cell_1rw_6/qb vdd vdd sky130_fd_pr__pfet_01v8 ad=1.925n pd=0.18m as=0 ps=0 w=55 l=15
X1094 vdd bank_0/replica_bitcell_array_0/dummy_array_3_0/dummy_cell_1rw_6/q bank_0/replica_bitcell_array_0/dummy_array_3_0/dummy_cell_1rw_6/qb vdd sky130_fd_pr__nfet_01v8 ad=0 pd=0 as=7.728n ps=0.42m w=126 l=15
X1095 bank_0/replica_bitcell_array_0/dummy_array_3_0/dummy_cell_1rw_6/q bank_0/replica_bitcell_array_0/dummy_array_3_0/dummy_cell_1rw_6/qb vdd vdd sky130_fd_pr__nfet_01v8 ad=7.728n pd=0.42m as=0 ps=0 w=126 l=15
X1096 bank_0/replica_bitcell_array_0/dummy_array_3_0/dummy_cell_1rw_6/qb bank_0/port_address_0/wl_10 bank_0/replica_bitcell_array_0/dummy_array_3_0/dummy_cell_1rw_6/a_145_76# vdd sky130_fd_pr__nfet_01v8 ad=0 pd=0 as=1.428n ps=0.152m w=42 l=15
X1097 vdd bank_0/replica_bitcell_array_0/dummy_array_3_0/dummy_cell_1rw_6/q bank_0/replica_bitcell_array_0/dummy_array_3_0/dummy_cell_1rw_6/qb vdd sky130_fd_pr__pfet_01v8 ad=0 pd=0 as=1.925n ps=0.18m w=55 l=15
X1098 bank_0/replica_bitcell_array_0/dummy_array_3_0/dummy_cell_1rw_6/q bank_0/port_address_0/wl_10 bank_0/replica_bitcell_array_0/dummy_array_3_0/dummy_cell_1rw_6/a_76_76# vdd sky130_fd_pr__nfet_01v8 ad=0 pd=0 as=1.428n ps=0.152m w=42 l=15
X1099 bank_0/replica_bitcell_array_0/dummy_array_3_0/dummy_cell_1rw_17/q bank_0/replica_bitcell_array_0/dummy_array_3_0/dummy_cell_1rw_17/qb vdd vdd sky130_fd_pr__pfet_01v8 ad=1.925n pd=0.18m as=0 ps=0 w=55 l=15
X1100 vdd bank_0/replica_bitcell_array_0/dummy_array_3_0/dummy_cell_1rw_17/q bank_0/replica_bitcell_array_0/dummy_array_3_0/dummy_cell_1rw_17/qb vdd sky130_fd_pr__nfet_01v8 ad=0 pd=0 as=7.728n ps=0.42m w=126 l=15
X1101 bank_0/replica_bitcell_array_0/dummy_array_3_0/dummy_cell_1rw_17/q bank_0/replica_bitcell_array_0/dummy_array_3_0/dummy_cell_1rw_17/qb vdd vdd sky130_fd_pr__nfet_01v8 ad=7.728n pd=0.42m as=0 ps=0 w=126 l=15
X1102 bank_0/replica_bitcell_array_0/dummy_array_3_0/dummy_cell_1rw_17/qb bank_0/port_address_0/rbl_wl bank_0/replica_bitcell_array_0/dummy_array_3_0/dummy_cell_1rw_17/a_145_76# vdd sky130_fd_pr__nfet_01v8 ad=0 pd=0 as=1.428n ps=0.152m w=42 l=15
X1103 vdd bank_0/replica_bitcell_array_0/dummy_array_3_0/dummy_cell_1rw_17/q bank_0/replica_bitcell_array_0/dummy_array_3_0/dummy_cell_1rw_17/qb vdd sky130_fd_pr__pfet_01v8 ad=0 pd=0 as=1.925n ps=0.18m w=55 l=15
X1104 bank_0/replica_bitcell_array_0/dummy_array_3_0/dummy_cell_1rw_17/q bank_0/port_address_0/rbl_wl bank_0/replica_bitcell_array_0/dummy_array_3_0/dummy_cell_1rw_17/a_76_76# vdd sky130_fd_pr__nfet_01v8 ad=0 pd=0 as=1.428n ps=0.152m w=42 l=15
X1105 bank_0/replica_bitcell_array_0/dummy_array_3_0/dummy_cell_1rw_18/q bank_0/replica_bitcell_array_0/dummy_array_3_0/dummy_cell_1rw_18/qb vdd vdd sky130_fd_pr__pfet_01v8 ad=1.925n pd=0.18m as=0 ps=0 w=55 l=15
X1106 vdd bank_0/replica_bitcell_array_0/dummy_array_3_0/dummy_cell_1rw_18/q bank_0/replica_bitcell_array_0/dummy_array_3_0/dummy_cell_1rw_18/qb vdd sky130_fd_pr__nfet_01v8 ad=0 pd=0 as=7.728n ps=0.42m w=126 l=15
X1107 bank_0/replica_bitcell_array_0/dummy_array_3_0/dummy_cell_1rw_18/q bank_0/replica_bitcell_array_0/dummy_array_3_0/dummy_cell_1rw_18/qb vdd vdd sky130_fd_pr__nfet_01v8 ad=7.728n pd=0.42m as=0 ps=0 w=126 l=15
X1108 bank_0/replica_bitcell_array_0/dummy_array_3_0/dummy_cell_1rw_18/qb vdd bank_0/replica_bitcell_array_0/dummy_array_3_0/dummy_cell_1rw_18/a_145_76# vdd sky130_fd_pr__nfet_01v8 ad=0 pd=0 as=1.428n ps=0.152m w=42 l=15
X1109 vdd bank_0/replica_bitcell_array_0/dummy_array_3_0/dummy_cell_1rw_18/q bank_0/replica_bitcell_array_0/dummy_array_3_0/dummy_cell_1rw_18/qb vdd sky130_fd_pr__pfet_01v8 ad=0 pd=0 as=1.925n ps=0.18m w=55 l=15
X1110 bank_0/replica_bitcell_array_0/dummy_array_3_0/dummy_cell_1rw_18/q vdd bank_0/replica_bitcell_array_0/dummy_array_3_0/dummy_cell_1rw_18/a_76_76# vdd sky130_fd_pr__nfet_01v8 ad=0 pd=0 as=1.428n ps=0.152m w=42 l=15
X1111 bank_0/replica_bitcell_array_0/dummy_array_3_0/dummy_cell_1rw_7/q bank_0/replica_bitcell_array_0/dummy_array_3_0/dummy_cell_1rw_7/qb vdd vdd sky130_fd_pr__pfet_01v8 ad=1.925n pd=0.18m as=0 ps=0 w=55 l=15
X1112 vdd bank_0/replica_bitcell_array_0/dummy_array_3_0/dummy_cell_1rw_7/q bank_0/replica_bitcell_array_0/dummy_array_3_0/dummy_cell_1rw_7/qb vdd sky130_fd_pr__nfet_01v8 ad=0 pd=0 as=7.728n ps=0.42m w=126 l=15
X1113 bank_0/replica_bitcell_array_0/dummy_array_3_0/dummy_cell_1rw_7/q bank_0/replica_bitcell_array_0/dummy_array_3_0/dummy_cell_1rw_7/qb vdd vdd sky130_fd_pr__nfet_01v8 ad=7.728n pd=0.42m as=0 ps=0 w=126 l=15
X1114 bank_0/replica_bitcell_array_0/dummy_array_3_0/dummy_cell_1rw_7/qb bank_0/port_address_0/wl_9 bank_0/replica_bitcell_array_0/dummy_array_3_0/dummy_cell_1rw_7/a_145_76# vdd sky130_fd_pr__nfet_01v8 ad=0 pd=0 as=1.428n ps=0.152m w=42 l=15
X1115 vdd bank_0/replica_bitcell_array_0/dummy_array_3_0/dummy_cell_1rw_7/q bank_0/replica_bitcell_array_0/dummy_array_3_0/dummy_cell_1rw_7/qb vdd sky130_fd_pr__pfet_01v8 ad=0 pd=0 as=1.925n ps=0.18m w=55 l=15
X1116 bank_0/replica_bitcell_array_0/dummy_array_3_0/dummy_cell_1rw_7/q bank_0/port_address_0/wl_9 bank_0/replica_bitcell_array_0/dummy_array_3_0/dummy_cell_1rw_7/a_76_76# vdd sky130_fd_pr__nfet_01v8 ad=0 pd=0 as=1.428n ps=0.152m w=42 l=15
X1117 bank_0/replica_bitcell_array_0/dummy_array_3_0/dummy_cell_1rw_8/q bank_0/replica_bitcell_array_0/dummy_array_3_0/dummy_cell_1rw_8/qb vdd vdd sky130_fd_pr__pfet_01v8 ad=1.925n pd=0.18m as=0 ps=0 w=55 l=15
X1118 vdd bank_0/replica_bitcell_array_0/dummy_array_3_0/dummy_cell_1rw_8/q bank_0/replica_bitcell_array_0/dummy_array_3_0/dummy_cell_1rw_8/qb vdd sky130_fd_pr__nfet_01v8 ad=0 pd=0 as=7.728n ps=0.42m w=126 l=15
X1119 bank_0/replica_bitcell_array_0/dummy_array_3_0/dummy_cell_1rw_8/q bank_0/replica_bitcell_array_0/dummy_array_3_0/dummy_cell_1rw_8/qb vdd vdd sky130_fd_pr__nfet_01v8 ad=7.728n pd=0.42m as=0 ps=0 w=126 l=15
X1120 bank_0/replica_bitcell_array_0/dummy_array_3_0/dummy_cell_1rw_8/qb bank_0/port_address_0/wl_8 bank_0/replica_bitcell_array_0/dummy_array_3_0/dummy_cell_1rw_8/a_145_76# vdd sky130_fd_pr__nfet_01v8 ad=0 pd=0 as=1.428n ps=0.152m w=42 l=15
X1121 vdd bank_0/replica_bitcell_array_0/dummy_array_3_0/dummy_cell_1rw_8/q bank_0/replica_bitcell_array_0/dummy_array_3_0/dummy_cell_1rw_8/qb vdd sky130_fd_pr__pfet_01v8 ad=0 pd=0 as=1.925n ps=0.18m w=55 l=15
X1122 bank_0/replica_bitcell_array_0/dummy_array_3_0/dummy_cell_1rw_8/q bank_0/port_address_0/wl_8 bank_0/replica_bitcell_array_0/dummy_array_3_0/dummy_cell_1rw_8/a_76_76# vdd sky130_fd_pr__nfet_01v8 ad=0 pd=0 as=1.428n ps=0.152m w=42 l=15
X1123 bank_0/replica_bitcell_array_0/dummy_array_3_0/dummy_cell_1rw_9/q bank_0/replica_bitcell_array_0/dummy_array_3_0/dummy_cell_1rw_9/qb vdd vdd sky130_fd_pr__pfet_01v8 ad=1.925n pd=0.18m as=0 ps=0 w=55 l=15
X1124 vdd bank_0/replica_bitcell_array_0/dummy_array_3_0/dummy_cell_1rw_9/q bank_0/replica_bitcell_array_0/dummy_array_3_0/dummy_cell_1rw_9/qb vdd sky130_fd_pr__nfet_01v8 ad=0 pd=0 as=7.728n ps=0.42m w=126 l=15
X1125 bank_0/replica_bitcell_array_0/dummy_array_3_0/dummy_cell_1rw_9/q bank_0/replica_bitcell_array_0/dummy_array_3_0/dummy_cell_1rw_9/qb vdd vdd sky130_fd_pr__nfet_01v8 ad=7.728n pd=0.42m as=0 ps=0 w=126 l=15
X1126 bank_0/replica_bitcell_array_0/dummy_array_3_0/dummy_cell_1rw_9/qb bank_0/port_address_0/wl_7 bank_0/replica_bitcell_array_0/dummy_array_3_0/dummy_cell_1rw_9/a_145_76# vdd sky130_fd_pr__nfet_01v8 ad=0 pd=0 as=1.428n ps=0.152m w=42 l=15
X1127 vdd bank_0/replica_bitcell_array_0/dummy_array_3_0/dummy_cell_1rw_9/q bank_0/replica_bitcell_array_0/dummy_array_3_0/dummy_cell_1rw_9/qb vdd sky130_fd_pr__pfet_01v8 ad=0 pd=0 as=1.925n ps=0.18m w=55 l=15
X1128 bank_0/replica_bitcell_array_0/dummy_array_3_0/dummy_cell_1rw_9/q bank_0/port_address_0/wl_7 bank_0/replica_bitcell_array_0/dummy_array_3_0/dummy_cell_1rw_9/a_76_76# vdd sky130_fd_pr__nfet_01v8 ad=0 pd=0 as=1.428n ps=0.152m w=42 l=15
X1129 bank_0/replica_bitcell_array_0/dummy_array_1_0/dummy_cell_1rw_0/q bank_0/replica_bitcell_array_0/dummy_array_1_0/dummy_cell_1rw_0/qb vdd vdd sky130_fd_pr__pfet_01v8 ad=1.925n pd=0.18m as=0 ps=0 w=55 l=15
X1130 vdd bank_0/replica_bitcell_array_0/dummy_array_1_0/dummy_cell_1rw_0/q bank_0/replica_bitcell_array_0/dummy_array_1_0/dummy_cell_1rw_0/qb vdd sky130_fd_pr__nfet_01v8 ad=0 pd=0 as=7.728n ps=0.42m w=126 l=15
X1131 bank_0/replica_bitcell_array_0/dummy_array_1_0/dummy_cell_1rw_0/q bank_0/replica_bitcell_array_0/dummy_array_1_0/dummy_cell_1rw_0/qb vdd vdd sky130_fd_pr__nfet_01v8 ad=7.728n pd=0.42m as=0 ps=0 w=126 l=15
X1132 bank_0/replica_bitcell_array_0/dummy_array_1_0/dummy_cell_1rw_0/qb vdd bank_0/replica_bitcell_array_0/dummy_array_1_0/dummy_cell_1rw_0/a_145_76# vdd sky130_fd_pr__nfet_01v8 ad=0 pd=0 as=1.428n ps=0.152m w=42 l=15
X1133 vdd bank_0/replica_bitcell_array_0/dummy_array_1_0/dummy_cell_1rw_0/q bank_0/replica_bitcell_array_0/dummy_array_1_0/dummy_cell_1rw_0/qb vdd sky130_fd_pr__pfet_01v8 ad=0 pd=0 as=1.925n ps=0.18m w=55 l=15
X1134 bank_0/replica_bitcell_array_0/dummy_array_1_0/dummy_cell_1rw_0/q vdd bank_0/replica_bitcell_array_0/dummy_array_1_0/dummy_cell_1rw_0/a_76_76# vdd sky130_fd_pr__nfet_01v8 ad=0 pd=0 as=1.428n ps=0.152m w=42 l=15
X1135 bank_0/replica_bitcell_array_0/dummy_array_1_0/dummy_cell_1rw_1/q bank_0/replica_bitcell_array_0/dummy_array_1_0/dummy_cell_1rw_1/qb vdd vdd sky130_fd_pr__pfet_01v8 ad=1.925n pd=0.18m as=0 ps=0 w=55 l=15
X1136 vdd bank_0/replica_bitcell_array_0/dummy_array_1_0/dummy_cell_1rw_1/q bank_0/replica_bitcell_array_0/dummy_array_1_0/dummy_cell_1rw_1/qb vdd sky130_fd_pr__nfet_01v8 ad=0 pd=0 as=7.728n ps=0.42m w=126 l=15
X1137 bank_0/replica_bitcell_array_0/dummy_array_1_0/dummy_cell_1rw_1/q bank_0/replica_bitcell_array_0/dummy_array_1_0/dummy_cell_1rw_1/qb vdd vdd sky130_fd_pr__nfet_01v8 ad=7.728n pd=0.42m as=0 ps=0 w=126 l=15
X1138 bank_0/replica_bitcell_array_0/dummy_array_1_0/dummy_cell_1rw_1/qb vdd bank_0/replica_bitcell_array_0/dummy_array_1_0/dummy_cell_1rw_1/a_145_76# vdd sky130_fd_pr__nfet_01v8 ad=0 pd=0 as=1.428n ps=0.152m w=42 l=15
X1139 vdd bank_0/replica_bitcell_array_0/dummy_array_1_0/dummy_cell_1rw_1/q bank_0/replica_bitcell_array_0/dummy_array_1_0/dummy_cell_1rw_1/qb vdd sky130_fd_pr__pfet_01v8 ad=0 pd=0 as=1.925n ps=0.18m w=55 l=15
X1140 bank_0/replica_bitcell_array_0/dummy_array_1_0/dummy_cell_1rw_1/q vdd bank_0/replica_bitcell_array_0/dummy_array_1_0/dummy_cell_1rw_1/a_76_76# vdd sky130_fd_pr__nfet_01v8 ad=0 pd=0 as=1.428n ps=0.152m w=42 l=15
X1141 bank_0/replica_bitcell_array_0/dummy_array_2_0/dummy_cell_1rw_10/q bank_0/replica_bitcell_array_0/dummy_array_2_0/dummy_cell_1rw_10/qb vdd vdd sky130_fd_pr__pfet_01v8 ad=1.925n pd=0.18m as=0 ps=0 w=55 l=15
X1142 vdd bank_0/replica_bitcell_array_0/dummy_array_2_0/dummy_cell_1rw_10/q bank_0/replica_bitcell_array_0/dummy_array_2_0/dummy_cell_1rw_10/qb vdd sky130_fd_pr__nfet_01v8 ad=0 pd=0 as=7.728n ps=0.42m w=126 l=15
X1143 bank_0/replica_bitcell_array_0/dummy_array_2_0/dummy_cell_1rw_10/q bank_0/replica_bitcell_array_0/dummy_array_2_0/dummy_cell_1rw_10/qb vdd vdd sky130_fd_pr__nfet_01v8 ad=7.728n pd=0.42m as=0 ps=0 w=126 l=15
X1144 bank_0/replica_bitcell_array_0/dummy_array_2_0/dummy_cell_1rw_10/qb bank_0/port_address_0/wl_6 bank_0/replica_bitcell_array_0/dummy_array_2_0/dummy_cell_1rw_10/a_145_76# vdd sky130_fd_pr__nfet_01v8 ad=0 pd=0 as=1.428n ps=0.152m w=42 l=15
X1145 vdd bank_0/replica_bitcell_array_0/dummy_array_2_0/dummy_cell_1rw_10/q bank_0/replica_bitcell_array_0/dummy_array_2_0/dummy_cell_1rw_10/qb vdd sky130_fd_pr__pfet_01v8 ad=0 pd=0 as=1.925n ps=0.18m w=55 l=15
X1146 bank_0/replica_bitcell_array_0/dummy_array_2_0/dummy_cell_1rw_10/q bank_0/port_address_0/wl_6 bank_0/replica_bitcell_array_0/dummy_array_2_0/dummy_cell_1rw_10/a_76_76# vdd sky130_fd_pr__nfet_01v8 ad=0 pd=0 as=1.428n ps=0.152m w=42 l=15
X1147 bank_0/replica_bitcell_array_0/dummy_array_2_0/dummy_cell_1rw_11/q bank_0/replica_bitcell_array_0/dummy_array_2_0/dummy_cell_1rw_11/qb vdd vdd sky130_fd_pr__pfet_01v8 ad=1.925n pd=0.18m as=0 ps=0 w=55 l=15
X1148 vdd bank_0/replica_bitcell_array_0/dummy_array_2_0/dummy_cell_1rw_11/q bank_0/replica_bitcell_array_0/dummy_array_2_0/dummy_cell_1rw_11/qb vdd sky130_fd_pr__nfet_01v8 ad=0 pd=0 as=7.728n ps=0.42m w=126 l=15
X1149 bank_0/replica_bitcell_array_0/dummy_array_2_0/dummy_cell_1rw_11/q bank_0/replica_bitcell_array_0/dummy_array_2_0/dummy_cell_1rw_11/qb vdd vdd sky130_fd_pr__nfet_01v8 ad=7.728n pd=0.42m as=0 ps=0 w=126 l=15
X1150 bank_0/replica_bitcell_array_0/dummy_array_2_0/dummy_cell_1rw_11/qb bank_0/port_address_0/wl_5 bank_0/replica_bitcell_array_0/dummy_array_2_0/dummy_cell_1rw_11/a_145_76# vdd sky130_fd_pr__nfet_01v8 ad=0 pd=0 as=1.428n ps=0.152m w=42 l=15
X1151 vdd bank_0/replica_bitcell_array_0/dummy_array_2_0/dummy_cell_1rw_11/q bank_0/replica_bitcell_array_0/dummy_array_2_0/dummy_cell_1rw_11/qb vdd sky130_fd_pr__pfet_01v8 ad=0 pd=0 as=1.925n ps=0.18m w=55 l=15
X1152 bank_0/replica_bitcell_array_0/dummy_array_2_0/dummy_cell_1rw_11/q bank_0/port_address_0/wl_5 bank_0/replica_bitcell_array_0/dummy_array_2_0/dummy_cell_1rw_11/a_76_76# vdd sky130_fd_pr__nfet_01v8 ad=0 pd=0 as=1.428n ps=0.152m w=42 l=15
X1153 bank_0/replica_bitcell_array_0/dummy_array_2_0/dummy_cell_1rw_0/q bank_0/replica_bitcell_array_0/dummy_array_2_0/dummy_cell_1rw_0/qb vdd vdd sky130_fd_pr__pfet_01v8 ad=1.925n pd=0.18m as=0 ps=0 w=55 l=15
X1154 vdd bank_0/replica_bitcell_array_0/dummy_array_2_0/dummy_cell_1rw_0/q bank_0/replica_bitcell_array_0/dummy_array_2_0/dummy_cell_1rw_0/qb vdd sky130_fd_pr__nfet_01v8 ad=0 pd=0 as=7.728n ps=0.42m w=126 l=15
X1155 bank_0/replica_bitcell_array_0/dummy_array_2_0/dummy_cell_1rw_0/q bank_0/replica_bitcell_array_0/dummy_array_2_0/dummy_cell_1rw_0/qb vdd vdd sky130_fd_pr__nfet_01v8 ad=7.728n pd=0.42m as=0 ps=0 w=126 l=15
X1156 bank_0/replica_bitcell_array_0/dummy_array_2_0/dummy_cell_1rw_0/qb vdd bank_0/replica_bitcell_array_0/dummy_array_2_0/dummy_cell_1rw_0/a_145_76# vdd sky130_fd_pr__nfet_01v8 ad=0 pd=0 as=1.428n ps=0.152m w=42 l=15
X1157 vdd bank_0/replica_bitcell_array_0/dummy_array_2_0/dummy_cell_1rw_0/q bank_0/replica_bitcell_array_0/dummy_array_2_0/dummy_cell_1rw_0/qb vdd sky130_fd_pr__pfet_01v8 ad=0 pd=0 as=1.925n ps=0.18m w=55 l=15
X1158 bank_0/replica_bitcell_array_0/dummy_array_2_0/dummy_cell_1rw_0/q vdd bank_0/replica_bitcell_array_0/dummy_array_2_0/dummy_cell_1rw_0/a_76_76# vdd sky130_fd_pr__nfet_01v8 ad=0 pd=0 as=1.428n ps=0.152m w=42 l=15
X1159 bank_0/replica_bitcell_array_0/dummy_array_2_0/dummy_cell_1rw_12/q bank_0/replica_bitcell_array_0/dummy_array_2_0/dummy_cell_1rw_12/qb vdd vdd sky130_fd_pr__pfet_01v8 ad=1.925n pd=0.18m as=0 ps=0 w=55 l=15
X1160 vdd bank_0/replica_bitcell_array_0/dummy_array_2_0/dummy_cell_1rw_12/q bank_0/replica_bitcell_array_0/dummy_array_2_0/dummy_cell_1rw_12/qb vdd sky130_fd_pr__nfet_01v8 ad=0 pd=0 as=7.728n ps=0.42m w=126 l=15
X1161 bank_0/replica_bitcell_array_0/dummy_array_2_0/dummy_cell_1rw_12/q bank_0/replica_bitcell_array_0/dummy_array_2_0/dummy_cell_1rw_12/qb vdd vdd sky130_fd_pr__nfet_01v8 ad=7.728n pd=0.42m as=0 ps=0 w=126 l=15
X1162 bank_0/replica_bitcell_array_0/dummy_array_2_0/dummy_cell_1rw_12/qb bank_0/port_address_0/wl_4 bank_0/replica_bitcell_array_0/dummy_array_2_0/dummy_cell_1rw_12/a_145_76# vdd sky130_fd_pr__nfet_01v8 ad=0 pd=0 as=1.428n ps=0.152m w=42 l=15
X1163 vdd bank_0/replica_bitcell_array_0/dummy_array_2_0/dummy_cell_1rw_12/q bank_0/replica_bitcell_array_0/dummy_array_2_0/dummy_cell_1rw_12/qb vdd sky130_fd_pr__pfet_01v8 ad=0 pd=0 as=1.925n ps=0.18m w=55 l=15
X1164 bank_0/replica_bitcell_array_0/dummy_array_2_0/dummy_cell_1rw_12/q bank_0/port_address_0/wl_4 bank_0/replica_bitcell_array_0/dummy_array_2_0/dummy_cell_1rw_12/a_76_76# vdd sky130_fd_pr__nfet_01v8 ad=0 pd=0 as=1.428n ps=0.152m w=42 l=15
X1165 bank_0/replica_bitcell_array_0/dummy_array_2_0/dummy_cell_1rw_1/q bank_0/replica_bitcell_array_0/dummy_array_2_0/dummy_cell_1rw_1/qb vdd vdd sky130_fd_pr__pfet_01v8 ad=1.925n pd=0.18m as=0 ps=0 w=55 l=15
X1166 vdd bank_0/replica_bitcell_array_0/dummy_array_2_0/dummy_cell_1rw_1/q bank_0/replica_bitcell_array_0/dummy_array_2_0/dummy_cell_1rw_1/qb vdd sky130_fd_pr__nfet_01v8 ad=0 pd=0 as=7.728n ps=0.42m w=126 l=15
X1167 bank_0/replica_bitcell_array_0/dummy_array_2_0/dummy_cell_1rw_1/q bank_0/replica_bitcell_array_0/dummy_array_2_0/dummy_cell_1rw_1/qb vdd vdd sky130_fd_pr__nfet_01v8 ad=7.728n pd=0.42m as=0 ps=0 w=126 l=15
X1168 bank_0/replica_bitcell_array_0/dummy_array_2_0/dummy_cell_1rw_1/qb bank_0/port_address_0/wl_15 bank_0/replica_bitcell_array_0/dummy_array_2_0/dummy_cell_1rw_1/a_145_76# vdd sky130_fd_pr__nfet_01v8 ad=0 pd=0 as=1.428n ps=0.152m w=42 l=15
X1169 vdd bank_0/replica_bitcell_array_0/dummy_array_2_0/dummy_cell_1rw_1/q bank_0/replica_bitcell_array_0/dummy_array_2_0/dummy_cell_1rw_1/qb vdd sky130_fd_pr__pfet_01v8 ad=0 pd=0 as=1.925n ps=0.18m w=55 l=15
X1170 bank_0/replica_bitcell_array_0/dummy_array_2_0/dummy_cell_1rw_1/q bank_0/port_address_0/wl_15 bank_0/replica_bitcell_array_0/dummy_array_2_0/dummy_cell_1rw_1/a_76_76# vdd sky130_fd_pr__nfet_01v8 ad=0 pd=0 as=1.428n ps=0.152m w=42 l=15
X1171 bank_0/replica_bitcell_array_0/dummy_array_2_0/dummy_cell_1rw_13/q bank_0/replica_bitcell_array_0/dummy_array_2_0/dummy_cell_1rw_13/qb vdd vdd sky130_fd_pr__pfet_01v8 ad=1.925n pd=0.18m as=0 ps=0 w=55 l=15
X1172 vdd bank_0/replica_bitcell_array_0/dummy_array_2_0/dummy_cell_1rw_13/q bank_0/replica_bitcell_array_0/dummy_array_2_0/dummy_cell_1rw_13/qb vdd sky130_fd_pr__nfet_01v8 ad=0 pd=0 as=7.728n ps=0.42m w=126 l=15
X1173 bank_0/replica_bitcell_array_0/dummy_array_2_0/dummy_cell_1rw_13/q bank_0/replica_bitcell_array_0/dummy_array_2_0/dummy_cell_1rw_13/qb vdd vdd sky130_fd_pr__nfet_01v8 ad=7.728n pd=0.42m as=0 ps=0 w=126 l=15
X1174 bank_0/replica_bitcell_array_0/dummy_array_2_0/dummy_cell_1rw_13/qb bank_0/port_address_0/wl_3 bank_0/replica_bitcell_array_0/dummy_array_2_0/dummy_cell_1rw_13/a_145_76# vdd sky130_fd_pr__nfet_01v8 ad=0 pd=0 as=1.428n ps=0.152m w=42 l=15
X1175 vdd bank_0/replica_bitcell_array_0/dummy_array_2_0/dummy_cell_1rw_13/q bank_0/replica_bitcell_array_0/dummy_array_2_0/dummy_cell_1rw_13/qb vdd sky130_fd_pr__pfet_01v8 ad=0 pd=0 as=1.925n ps=0.18m w=55 l=15
X1176 bank_0/replica_bitcell_array_0/dummy_array_2_0/dummy_cell_1rw_13/q bank_0/port_address_0/wl_3 bank_0/replica_bitcell_array_0/dummy_array_2_0/dummy_cell_1rw_13/a_76_76# vdd sky130_fd_pr__nfet_01v8 ad=0 pd=0 as=1.428n ps=0.152m w=42 l=15
X1177 bank_0/replica_bitcell_array_0/dummy_array_2_0/dummy_cell_1rw_2/q bank_0/replica_bitcell_array_0/dummy_array_2_0/dummy_cell_1rw_2/qb vdd vdd sky130_fd_pr__pfet_01v8 ad=1.925n pd=0.18m as=0 ps=0 w=55 l=15
X1178 vdd bank_0/replica_bitcell_array_0/dummy_array_2_0/dummy_cell_1rw_2/q bank_0/replica_bitcell_array_0/dummy_array_2_0/dummy_cell_1rw_2/qb vdd sky130_fd_pr__nfet_01v8 ad=0 pd=0 as=7.728n ps=0.42m w=126 l=15
X1179 bank_0/replica_bitcell_array_0/dummy_array_2_0/dummy_cell_1rw_2/q bank_0/replica_bitcell_array_0/dummy_array_2_0/dummy_cell_1rw_2/qb vdd vdd sky130_fd_pr__nfet_01v8 ad=7.728n pd=0.42m as=0 ps=0 w=126 l=15
X1180 bank_0/replica_bitcell_array_0/dummy_array_2_0/dummy_cell_1rw_2/qb bank_0/port_address_0/wl_14 bank_0/replica_bitcell_array_0/dummy_array_2_0/dummy_cell_1rw_2/a_145_76# vdd sky130_fd_pr__nfet_01v8 ad=0 pd=0 as=1.428n ps=0.152m w=42 l=15
X1181 vdd bank_0/replica_bitcell_array_0/dummy_array_2_0/dummy_cell_1rw_2/q bank_0/replica_bitcell_array_0/dummy_array_2_0/dummy_cell_1rw_2/qb vdd sky130_fd_pr__pfet_01v8 ad=0 pd=0 as=1.925n ps=0.18m w=55 l=15
X1182 bank_0/replica_bitcell_array_0/dummy_array_2_0/dummy_cell_1rw_2/q bank_0/port_address_0/wl_14 bank_0/replica_bitcell_array_0/dummy_array_2_0/dummy_cell_1rw_2/a_76_76# vdd sky130_fd_pr__nfet_01v8 ad=0 pd=0 as=1.428n ps=0.152m w=42 l=15
X1183 bank_0/replica_bitcell_array_0/dummy_array_2_0/dummy_cell_1rw_3/q bank_0/replica_bitcell_array_0/dummy_array_2_0/dummy_cell_1rw_3/qb vdd vdd sky130_fd_pr__pfet_01v8 ad=1.925n pd=0.18m as=0 ps=0 w=55 l=15
X1184 vdd bank_0/replica_bitcell_array_0/dummy_array_2_0/dummy_cell_1rw_3/q bank_0/replica_bitcell_array_0/dummy_array_2_0/dummy_cell_1rw_3/qb vdd sky130_fd_pr__nfet_01v8 ad=0 pd=0 as=7.728n ps=0.42m w=126 l=15
X1185 bank_0/replica_bitcell_array_0/dummy_array_2_0/dummy_cell_1rw_3/q bank_0/replica_bitcell_array_0/dummy_array_2_0/dummy_cell_1rw_3/qb vdd vdd sky130_fd_pr__nfet_01v8 ad=7.728n pd=0.42m as=0 ps=0 w=126 l=15
X1186 bank_0/replica_bitcell_array_0/dummy_array_2_0/dummy_cell_1rw_3/qb bank_0/port_address_0/wl_13 bank_0/replica_bitcell_array_0/dummy_array_2_0/dummy_cell_1rw_3/a_145_76# vdd sky130_fd_pr__nfet_01v8 ad=0 pd=0 as=1.428n ps=0.152m w=42 l=15
X1187 vdd bank_0/replica_bitcell_array_0/dummy_array_2_0/dummy_cell_1rw_3/q bank_0/replica_bitcell_array_0/dummy_array_2_0/dummy_cell_1rw_3/qb vdd sky130_fd_pr__pfet_01v8 ad=0 pd=0 as=1.925n ps=0.18m w=55 l=15
X1188 bank_0/replica_bitcell_array_0/dummy_array_2_0/dummy_cell_1rw_3/q bank_0/port_address_0/wl_13 bank_0/replica_bitcell_array_0/dummy_array_2_0/dummy_cell_1rw_3/a_76_76# vdd sky130_fd_pr__nfet_01v8 ad=0 pd=0 as=1.428n ps=0.152m w=42 l=15
X1189 bank_0/replica_bitcell_array_0/dummy_array_2_0/dummy_cell_1rw_14/q bank_0/replica_bitcell_array_0/dummy_array_2_0/dummy_cell_1rw_14/qb vdd vdd sky130_fd_pr__pfet_01v8 ad=1.925n pd=0.18m as=0 ps=0 w=55 l=15
X1190 vdd bank_0/replica_bitcell_array_0/dummy_array_2_0/dummy_cell_1rw_14/q bank_0/replica_bitcell_array_0/dummy_array_2_0/dummy_cell_1rw_14/qb vdd sky130_fd_pr__nfet_01v8 ad=0 pd=0 as=7.728n ps=0.42m w=126 l=15
X1191 bank_0/replica_bitcell_array_0/dummy_array_2_0/dummy_cell_1rw_14/q bank_0/replica_bitcell_array_0/dummy_array_2_0/dummy_cell_1rw_14/qb vdd vdd sky130_fd_pr__nfet_01v8 ad=7.728n pd=0.42m as=0 ps=0 w=126 l=15
X1192 bank_0/replica_bitcell_array_0/dummy_array_2_0/dummy_cell_1rw_14/qb bank_0/port_address_0/wl_2 bank_0/replica_bitcell_array_0/dummy_array_2_0/dummy_cell_1rw_14/a_145_76# vdd sky130_fd_pr__nfet_01v8 ad=0 pd=0 as=1.428n ps=0.152m w=42 l=15
X1193 vdd bank_0/replica_bitcell_array_0/dummy_array_2_0/dummy_cell_1rw_14/q bank_0/replica_bitcell_array_0/dummy_array_2_0/dummy_cell_1rw_14/qb vdd sky130_fd_pr__pfet_01v8 ad=0 pd=0 as=1.925n ps=0.18m w=55 l=15
X1194 bank_0/replica_bitcell_array_0/dummy_array_2_0/dummy_cell_1rw_14/q bank_0/port_address_0/wl_2 bank_0/replica_bitcell_array_0/dummy_array_2_0/dummy_cell_1rw_14/a_76_76# vdd sky130_fd_pr__nfet_01v8 ad=0 pd=0 as=1.428n ps=0.152m w=42 l=15
X1195 bank_0/replica_bitcell_array_0/dummy_array_2_0/dummy_cell_1rw_4/q bank_0/replica_bitcell_array_0/dummy_array_2_0/dummy_cell_1rw_4/qb vdd vdd sky130_fd_pr__pfet_01v8 ad=1.925n pd=0.18m as=0 ps=0 w=55 l=15
X1196 vdd bank_0/replica_bitcell_array_0/dummy_array_2_0/dummy_cell_1rw_4/q bank_0/replica_bitcell_array_0/dummy_array_2_0/dummy_cell_1rw_4/qb vdd sky130_fd_pr__nfet_01v8 ad=0 pd=0 as=7.728n ps=0.42m w=126 l=15
X1197 bank_0/replica_bitcell_array_0/dummy_array_2_0/dummy_cell_1rw_4/q bank_0/replica_bitcell_array_0/dummy_array_2_0/dummy_cell_1rw_4/qb vdd vdd sky130_fd_pr__nfet_01v8 ad=7.728n pd=0.42m as=0 ps=0 w=126 l=15
X1198 bank_0/replica_bitcell_array_0/dummy_array_2_0/dummy_cell_1rw_4/qb bank_0/port_address_0/wl_12 bank_0/replica_bitcell_array_0/dummy_array_2_0/dummy_cell_1rw_4/a_145_76# vdd sky130_fd_pr__nfet_01v8 ad=0 pd=0 as=1.428n ps=0.152m w=42 l=15
X1199 vdd bank_0/replica_bitcell_array_0/dummy_array_2_0/dummy_cell_1rw_4/q bank_0/replica_bitcell_array_0/dummy_array_2_0/dummy_cell_1rw_4/qb vdd sky130_fd_pr__pfet_01v8 ad=0 pd=0 as=1.925n ps=0.18m w=55 l=15
X1200 bank_0/replica_bitcell_array_0/dummy_array_2_0/dummy_cell_1rw_4/q bank_0/port_address_0/wl_12 bank_0/replica_bitcell_array_0/dummy_array_2_0/dummy_cell_1rw_4/a_76_76# vdd sky130_fd_pr__nfet_01v8 ad=0 pd=0 as=1.428n ps=0.152m w=42 l=15
X1201 bank_0/replica_bitcell_array_0/dummy_array_2_0/dummy_cell_1rw_15/q bank_0/replica_bitcell_array_0/dummy_array_2_0/dummy_cell_1rw_15/qb vdd vdd sky130_fd_pr__pfet_01v8 ad=1.925n pd=0.18m as=0 ps=0 w=55 l=15
X1202 vdd bank_0/replica_bitcell_array_0/dummy_array_2_0/dummy_cell_1rw_15/q bank_0/replica_bitcell_array_0/dummy_array_2_0/dummy_cell_1rw_15/qb vdd sky130_fd_pr__nfet_01v8 ad=0 pd=0 as=7.728n ps=0.42m w=126 l=15
X1203 bank_0/replica_bitcell_array_0/dummy_array_2_0/dummy_cell_1rw_15/q bank_0/replica_bitcell_array_0/dummy_array_2_0/dummy_cell_1rw_15/qb vdd vdd sky130_fd_pr__nfet_01v8 ad=7.728n pd=0.42m as=0 ps=0 w=126 l=15
X1204 bank_0/replica_bitcell_array_0/dummy_array_2_0/dummy_cell_1rw_15/qb bank_0/port_address_0/wl_1 bank_0/replica_bitcell_array_0/dummy_array_2_0/dummy_cell_1rw_15/a_145_76# vdd sky130_fd_pr__nfet_01v8 ad=0 pd=0 as=1.428n ps=0.152m w=42 l=15
X1205 vdd bank_0/replica_bitcell_array_0/dummy_array_2_0/dummy_cell_1rw_15/q bank_0/replica_bitcell_array_0/dummy_array_2_0/dummy_cell_1rw_15/qb vdd sky130_fd_pr__pfet_01v8 ad=0 pd=0 as=1.925n ps=0.18m w=55 l=15
X1206 bank_0/replica_bitcell_array_0/dummy_array_2_0/dummy_cell_1rw_15/q bank_0/port_address_0/wl_1 bank_0/replica_bitcell_array_0/dummy_array_2_0/dummy_cell_1rw_15/a_76_76# vdd sky130_fd_pr__nfet_01v8 ad=0 pd=0 as=1.428n ps=0.152m w=42 l=15
X1207 bank_0/replica_bitcell_array_0/dummy_array_2_0/dummy_cell_1rw_5/q bank_0/replica_bitcell_array_0/dummy_array_2_0/dummy_cell_1rw_5/qb vdd vdd sky130_fd_pr__pfet_01v8 ad=1.925n pd=0.18m as=0 ps=0 w=55 l=15
X1208 vdd bank_0/replica_bitcell_array_0/dummy_array_2_0/dummy_cell_1rw_5/q bank_0/replica_bitcell_array_0/dummy_array_2_0/dummy_cell_1rw_5/qb vdd sky130_fd_pr__nfet_01v8 ad=0 pd=0 as=7.728n ps=0.42m w=126 l=15
X1209 bank_0/replica_bitcell_array_0/dummy_array_2_0/dummy_cell_1rw_5/q bank_0/replica_bitcell_array_0/dummy_array_2_0/dummy_cell_1rw_5/qb vdd vdd sky130_fd_pr__nfet_01v8 ad=7.728n pd=0.42m as=0 ps=0 w=126 l=15
X1210 bank_0/replica_bitcell_array_0/dummy_array_2_0/dummy_cell_1rw_5/qb bank_0/port_address_0/wl_11 bank_0/replica_bitcell_array_0/dummy_array_2_0/dummy_cell_1rw_5/a_145_76# vdd sky130_fd_pr__nfet_01v8 ad=0 pd=0 as=1.428n ps=0.152m w=42 l=15
X1211 vdd bank_0/replica_bitcell_array_0/dummy_array_2_0/dummy_cell_1rw_5/q bank_0/replica_bitcell_array_0/dummy_array_2_0/dummy_cell_1rw_5/qb vdd sky130_fd_pr__pfet_01v8 ad=0 pd=0 as=1.925n ps=0.18m w=55 l=15
X1212 bank_0/replica_bitcell_array_0/dummy_array_2_0/dummy_cell_1rw_5/q bank_0/port_address_0/wl_11 bank_0/replica_bitcell_array_0/dummy_array_2_0/dummy_cell_1rw_5/a_76_76# vdd sky130_fd_pr__nfet_01v8 ad=0 pd=0 as=1.428n ps=0.152m w=42 l=15
X1213 bank_0/replica_bitcell_array_0/dummy_array_2_0/dummy_cell_1rw_16/q bank_0/replica_bitcell_array_0/dummy_array_2_0/dummy_cell_1rw_16/qb vdd vdd sky130_fd_pr__pfet_01v8 ad=1.925n pd=0.18m as=0 ps=0 w=55 l=15
X1214 vdd bank_0/replica_bitcell_array_0/dummy_array_2_0/dummy_cell_1rw_16/q bank_0/replica_bitcell_array_0/dummy_array_2_0/dummy_cell_1rw_16/qb vdd sky130_fd_pr__nfet_01v8 ad=0 pd=0 as=7.728n ps=0.42m w=126 l=15
X1215 bank_0/replica_bitcell_array_0/dummy_array_2_0/dummy_cell_1rw_16/q bank_0/replica_bitcell_array_0/dummy_array_2_0/dummy_cell_1rw_16/qb vdd vdd sky130_fd_pr__nfet_01v8 ad=7.728n pd=0.42m as=0 ps=0 w=126 l=15
X1216 bank_0/replica_bitcell_array_0/dummy_array_2_0/dummy_cell_1rw_16/qb bank_0/port_address_0/wl_0 bank_0/replica_bitcell_array_0/dummy_array_2_0/dummy_cell_1rw_16/a_145_76# vdd sky130_fd_pr__nfet_01v8 ad=0 pd=0 as=1.428n ps=0.152m w=42 l=15
X1217 vdd bank_0/replica_bitcell_array_0/dummy_array_2_0/dummy_cell_1rw_16/q bank_0/replica_bitcell_array_0/dummy_array_2_0/dummy_cell_1rw_16/qb vdd sky130_fd_pr__pfet_01v8 ad=0 pd=0 as=1.925n ps=0.18m w=55 l=15
X1218 bank_0/replica_bitcell_array_0/dummy_array_2_0/dummy_cell_1rw_16/q bank_0/port_address_0/wl_0 bank_0/replica_bitcell_array_0/dummy_array_2_0/dummy_cell_1rw_16/a_76_76# vdd sky130_fd_pr__nfet_01v8 ad=0 pd=0 as=1.428n ps=0.152m w=42 l=15
X1219 bank_0/replica_bitcell_array_0/dummy_array_2_0/dummy_cell_1rw_6/q bank_0/replica_bitcell_array_0/dummy_array_2_0/dummy_cell_1rw_6/qb vdd vdd sky130_fd_pr__pfet_01v8 ad=1.925n pd=0.18m as=0 ps=0 w=55 l=15
X1220 vdd bank_0/replica_bitcell_array_0/dummy_array_2_0/dummy_cell_1rw_6/q bank_0/replica_bitcell_array_0/dummy_array_2_0/dummy_cell_1rw_6/qb vdd sky130_fd_pr__nfet_01v8 ad=0 pd=0 as=7.728n ps=0.42m w=126 l=15
X1221 bank_0/replica_bitcell_array_0/dummy_array_2_0/dummy_cell_1rw_6/q bank_0/replica_bitcell_array_0/dummy_array_2_0/dummy_cell_1rw_6/qb vdd vdd sky130_fd_pr__nfet_01v8 ad=7.728n pd=0.42m as=0 ps=0 w=126 l=15
X1222 bank_0/replica_bitcell_array_0/dummy_array_2_0/dummy_cell_1rw_6/qb bank_0/port_address_0/wl_10 bank_0/replica_bitcell_array_0/dummy_array_2_0/dummy_cell_1rw_6/a_145_76# vdd sky130_fd_pr__nfet_01v8 ad=0 pd=0 as=1.428n ps=0.152m w=42 l=15
X1223 vdd bank_0/replica_bitcell_array_0/dummy_array_2_0/dummy_cell_1rw_6/q bank_0/replica_bitcell_array_0/dummy_array_2_0/dummy_cell_1rw_6/qb vdd sky130_fd_pr__pfet_01v8 ad=0 pd=0 as=1.925n ps=0.18m w=55 l=15
X1224 bank_0/replica_bitcell_array_0/dummy_array_2_0/dummy_cell_1rw_6/q bank_0/port_address_0/wl_10 bank_0/replica_bitcell_array_0/dummy_array_2_0/dummy_cell_1rw_6/a_76_76# vdd sky130_fd_pr__nfet_01v8 ad=0 pd=0 as=1.428n ps=0.152m w=42 l=15
X1225 bank_0/replica_bitcell_array_0/dummy_array_2_0/dummy_cell_1rw_17/q bank_0/replica_bitcell_array_0/dummy_array_2_0/dummy_cell_1rw_17/qb vdd vdd sky130_fd_pr__pfet_01v8 ad=1.925n pd=0.18m as=0 ps=0 w=55 l=15
X1226 vdd bank_0/replica_bitcell_array_0/dummy_array_2_0/dummy_cell_1rw_17/q bank_0/replica_bitcell_array_0/dummy_array_2_0/dummy_cell_1rw_17/qb vdd sky130_fd_pr__nfet_01v8 ad=0 pd=0 as=7.728n ps=0.42m w=126 l=15
X1227 bank_0/replica_bitcell_array_0/dummy_array_2_0/dummy_cell_1rw_17/q bank_0/replica_bitcell_array_0/dummy_array_2_0/dummy_cell_1rw_17/qb vdd vdd sky130_fd_pr__nfet_01v8 ad=7.728n pd=0.42m as=0 ps=0 w=126 l=15
X1228 bank_0/replica_bitcell_array_0/dummy_array_2_0/dummy_cell_1rw_17/qb bank_0/port_address_0/rbl_wl bank_0/replica_bitcell_array_0/dummy_array_2_0/dummy_cell_1rw_17/a_145_76# vdd sky130_fd_pr__nfet_01v8 ad=0 pd=0 as=1.428n ps=0.152m w=42 l=15
X1229 vdd bank_0/replica_bitcell_array_0/dummy_array_2_0/dummy_cell_1rw_17/q bank_0/replica_bitcell_array_0/dummy_array_2_0/dummy_cell_1rw_17/qb vdd sky130_fd_pr__pfet_01v8 ad=0 pd=0 as=1.925n ps=0.18m w=55 l=15
X1230 bank_0/replica_bitcell_array_0/dummy_array_2_0/dummy_cell_1rw_17/q bank_0/port_address_0/rbl_wl bank_0/replica_bitcell_array_0/dummy_array_2_0/dummy_cell_1rw_17/a_76_76# vdd sky130_fd_pr__nfet_01v8 ad=0 pd=0 as=1.428n ps=0.152m w=42 l=15
X1231 bank_0/replica_bitcell_array_0/dummy_array_2_0/dummy_cell_1rw_18/q bank_0/replica_bitcell_array_0/dummy_array_2_0/dummy_cell_1rw_18/qb vdd vdd sky130_fd_pr__pfet_01v8 ad=1.925n pd=0.18m as=0 ps=0 w=55 l=15
X1232 vdd bank_0/replica_bitcell_array_0/dummy_array_2_0/dummy_cell_1rw_18/q bank_0/replica_bitcell_array_0/dummy_array_2_0/dummy_cell_1rw_18/qb vdd sky130_fd_pr__nfet_01v8 ad=0 pd=0 as=7.728n ps=0.42m w=126 l=15
X1233 bank_0/replica_bitcell_array_0/dummy_array_2_0/dummy_cell_1rw_18/q bank_0/replica_bitcell_array_0/dummy_array_2_0/dummy_cell_1rw_18/qb vdd vdd sky130_fd_pr__nfet_01v8 ad=7.728n pd=0.42m as=0 ps=0 w=126 l=15
X1234 bank_0/replica_bitcell_array_0/dummy_array_2_0/dummy_cell_1rw_18/qb vdd bank_0/replica_bitcell_array_0/dummy_array_2_0/dummy_cell_1rw_18/a_145_76# vdd sky130_fd_pr__nfet_01v8 ad=0 pd=0 as=1.428n ps=0.152m w=42 l=15
X1235 vdd bank_0/replica_bitcell_array_0/dummy_array_2_0/dummy_cell_1rw_18/q bank_0/replica_bitcell_array_0/dummy_array_2_0/dummy_cell_1rw_18/qb vdd sky130_fd_pr__pfet_01v8 ad=0 pd=0 as=1.925n ps=0.18m w=55 l=15
X1236 bank_0/replica_bitcell_array_0/dummy_array_2_0/dummy_cell_1rw_18/q vdd bank_0/replica_bitcell_array_0/dummy_array_2_0/dummy_cell_1rw_18/a_76_76# vdd sky130_fd_pr__nfet_01v8 ad=0 pd=0 as=1.428n ps=0.152m w=42 l=15
X1237 bank_0/replica_bitcell_array_0/dummy_array_2_0/dummy_cell_1rw_7/q bank_0/replica_bitcell_array_0/dummy_array_2_0/dummy_cell_1rw_7/qb vdd vdd sky130_fd_pr__pfet_01v8 ad=1.925n pd=0.18m as=0 ps=0 w=55 l=15
X1238 vdd bank_0/replica_bitcell_array_0/dummy_array_2_0/dummy_cell_1rw_7/q bank_0/replica_bitcell_array_0/dummy_array_2_0/dummy_cell_1rw_7/qb vdd sky130_fd_pr__nfet_01v8 ad=0 pd=0 as=7.728n ps=0.42m w=126 l=15
X1239 bank_0/replica_bitcell_array_0/dummy_array_2_0/dummy_cell_1rw_7/q bank_0/replica_bitcell_array_0/dummy_array_2_0/dummy_cell_1rw_7/qb vdd vdd sky130_fd_pr__nfet_01v8 ad=7.728n pd=0.42m as=0 ps=0 w=126 l=15
X1240 bank_0/replica_bitcell_array_0/dummy_array_2_0/dummy_cell_1rw_7/qb bank_0/port_address_0/wl_9 bank_0/replica_bitcell_array_0/dummy_array_2_0/dummy_cell_1rw_7/a_145_76# vdd sky130_fd_pr__nfet_01v8 ad=0 pd=0 as=1.428n ps=0.152m w=42 l=15
X1241 vdd bank_0/replica_bitcell_array_0/dummy_array_2_0/dummy_cell_1rw_7/q bank_0/replica_bitcell_array_0/dummy_array_2_0/dummy_cell_1rw_7/qb vdd sky130_fd_pr__pfet_01v8 ad=0 pd=0 as=1.925n ps=0.18m w=55 l=15
X1242 bank_0/replica_bitcell_array_0/dummy_array_2_0/dummy_cell_1rw_7/q bank_0/port_address_0/wl_9 bank_0/replica_bitcell_array_0/dummy_array_2_0/dummy_cell_1rw_7/a_76_76# vdd sky130_fd_pr__nfet_01v8 ad=0 pd=0 as=1.428n ps=0.152m w=42 l=15
X1243 bank_0/replica_bitcell_array_0/dummy_array_2_0/dummy_cell_1rw_8/q bank_0/replica_bitcell_array_0/dummy_array_2_0/dummy_cell_1rw_8/qb vdd vdd sky130_fd_pr__pfet_01v8 ad=1.925n pd=0.18m as=0 ps=0 w=55 l=15
X1244 vdd bank_0/replica_bitcell_array_0/dummy_array_2_0/dummy_cell_1rw_8/q bank_0/replica_bitcell_array_0/dummy_array_2_0/dummy_cell_1rw_8/qb vdd sky130_fd_pr__nfet_01v8 ad=0 pd=0 as=7.728n ps=0.42m w=126 l=15
X1245 bank_0/replica_bitcell_array_0/dummy_array_2_0/dummy_cell_1rw_8/q bank_0/replica_bitcell_array_0/dummy_array_2_0/dummy_cell_1rw_8/qb vdd vdd sky130_fd_pr__nfet_01v8 ad=7.728n pd=0.42m as=0 ps=0 w=126 l=15
X1246 bank_0/replica_bitcell_array_0/dummy_array_2_0/dummy_cell_1rw_8/qb bank_0/port_address_0/wl_8 bank_0/replica_bitcell_array_0/dummy_array_2_0/dummy_cell_1rw_8/a_145_76# vdd sky130_fd_pr__nfet_01v8 ad=0 pd=0 as=1.428n ps=0.152m w=42 l=15
X1247 vdd bank_0/replica_bitcell_array_0/dummy_array_2_0/dummy_cell_1rw_8/q bank_0/replica_bitcell_array_0/dummy_array_2_0/dummy_cell_1rw_8/qb vdd sky130_fd_pr__pfet_01v8 ad=0 pd=0 as=1.925n ps=0.18m w=55 l=15
X1248 bank_0/replica_bitcell_array_0/dummy_array_2_0/dummy_cell_1rw_8/q bank_0/port_address_0/wl_8 bank_0/replica_bitcell_array_0/dummy_array_2_0/dummy_cell_1rw_8/a_76_76# vdd sky130_fd_pr__nfet_01v8 ad=0 pd=0 as=1.428n ps=0.152m w=42 l=15
X1249 bank_0/replica_bitcell_array_0/dummy_array_2_0/dummy_cell_1rw_9/q bank_0/replica_bitcell_array_0/dummy_array_2_0/dummy_cell_1rw_9/qb vdd vdd sky130_fd_pr__pfet_01v8 ad=1.925n pd=0.18m as=0 ps=0 w=55 l=15
X1250 vdd bank_0/replica_bitcell_array_0/dummy_array_2_0/dummy_cell_1rw_9/q bank_0/replica_bitcell_array_0/dummy_array_2_0/dummy_cell_1rw_9/qb vdd sky130_fd_pr__nfet_01v8 ad=0 pd=0 as=7.728n ps=0.42m w=126 l=15
X1251 bank_0/replica_bitcell_array_0/dummy_array_2_0/dummy_cell_1rw_9/q bank_0/replica_bitcell_array_0/dummy_array_2_0/dummy_cell_1rw_9/qb vdd vdd sky130_fd_pr__nfet_01v8 ad=7.728n pd=0.42m as=0 ps=0 w=126 l=15
X1252 bank_0/replica_bitcell_array_0/dummy_array_2_0/dummy_cell_1rw_9/qb bank_0/port_address_0/wl_7 bank_0/replica_bitcell_array_0/dummy_array_2_0/dummy_cell_1rw_9/a_145_76# vdd sky130_fd_pr__nfet_01v8 ad=0 pd=0 as=1.428n ps=0.152m w=42 l=15
X1253 vdd bank_0/replica_bitcell_array_0/dummy_array_2_0/dummy_cell_1rw_9/q bank_0/replica_bitcell_array_0/dummy_array_2_0/dummy_cell_1rw_9/qb vdd sky130_fd_pr__pfet_01v8 ad=0 pd=0 as=1.925n ps=0.18m w=55 l=15
X1254 bank_0/replica_bitcell_array_0/dummy_array_2_0/dummy_cell_1rw_9/q bank_0/port_address_0/wl_7 bank_0/replica_bitcell_array_0/dummy_array_2_0/dummy_cell_1rw_9/a_76_76# vdd sky130_fd_pr__nfet_01v8 ad=0 pd=0 as=1.428n ps=0.152m w=42 l=15
X1255 bank_0/replica_bitcell_array_0/dummy_array_0_0/dummy_cell_1rw_0/q bank_0/replica_bitcell_array_0/dummy_array_0_0/dummy_cell_1rw_0/qb vdd vdd sky130_fd_pr__pfet_01v8 ad=1.925n pd=0.18m as=0 ps=0 w=55 l=15
X1256 vdd bank_0/replica_bitcell_array_0/dummy_array_0_0/dummy_cell_1rw_0/q bank_0/replica_bitcell_array_0/dummy_array_0_0/dummy_cell_1rw_0/qb vdd sky130_fd_pr__nfet_01v8 ad=0 pd=0 as=7.728n ps=0.42m w=126 l=15
X1257 bank_0/replica_bitcell_array_0/dummy_array_0_0/dummy_cell_1rw_0/q bank_0/replica_bitcell_array_0/dummy_array_0_0/dummy_cell_1rw_0/qb vdd vdd sky130_fd_pr__nfet_01v8 ad=7.728n pd=0.42m as=0 ps=0 w=126 l=15
X1258 bank_0/replica_bitcell_array_0/dummy_array_0_0/dummy_cell_1rw_0/qb vdd bank_0/replica_bitcell_array_0/dummy_array_0_0/dummy_cell_1rw_0/a_145_76# vdd sky130_fd_pr__nfet_01v8 ad=0 pd=0 as=1.428n ps=0.152m w=42 l=15
X1259 vdd bank_0/replica_bitcell_array_0/dummy_array_0_0/dummy_cell_1rw_0/q bank_0/replica_bitcell_array_0/dummy_array_0_0/dummy_cell_1rw_0/qb vdd sky130_fd_pr__pfet_01v8 ad=0 pd=0 as=1.925n ps=0.18m w=55 l=15
X1260 bank_0/replica_bitcell_array_0/dummy_array_0_0/dummy_cell_1rw_0/q vdd bank_0/replica_bitcell_array_0/dummy_array_0_0/dummy_cell_1rw_0/a_76_76# vdd sky130_fd_pr__nfet_01v8 ad=0 pd=0 as=1.428n ps=0.152m w=42 l=15
X1261 bank_0/replica_bitcell_array_0/dummy_array_0_0/dummy_cell_1rw_1/q bank_0/replica_bitcell_array_0/dummy_array_0_0/dummy_cell_1rw_1/qb vdd vdd sky130_fd_pr__pfet_01v8 ad=1.925n pd=0.18m as=0 ps=0 w=55 l=15
X1262 vdd bank_0/replica_bitcell_array_0/dummy_array_0_0/dummy_cell_1rw_1/q bank_0/replica_bitcell_array_0/dummy_array_0_0/dummy_cell_1rw_1/qb vdd sky130_fd_pr__nfet_01v8 ad=0 pd=0 as=7.728n ps=0.42m w=126 l=15
X1263 bank_0/replica_bitcell_array_0/dummy_array_0_0/dummy_cell_1rw_1/q bank_0/replica_bitcell_array_0/dummy_array_0_0/dummy_cell_1rw_1/qb vdd vdd sky130_fd_pr__nfet_01v8 ad=7.728n pd=0.42m as=0 ps=0 w=126 l=15
X1264 bank_0/replica_bitcell_array_0/dummy_array_0_0/dummy_cell_1rw_1/qb vdd bank_0/replica_bitcell_array_0/dummy_array_0_0/dummy_cell_1rw_1/a_145_76# vdd sky130_fd_pr__nfet_01v8 ad=0 pd=0 as=1.428n ps=0.152m w=42 l=15
X1265 vdd bank_0/replica_bitcell_array_0/dummy_array_0_0/dummy_cell_1rw_1/q bank_0/replica_bitcell_array_0/dummy_array_0_0/dummy_cell_1rw_1/qb vdd sky130_fd_pr__pfet_01v8 ad=0 pd=0 as=1.925n ps=0.18m w=55 l=15
X1266 bank_0/replica_bitcell_array_0/dummy_array_0_0/dummy_cell_1rw_1/q vdd bank_0/replica_bitcell_array_0/dummy_array_0_0/dummy_cell_1rw_1/a_76_76# vdd sky130_fd_pr__nfet_01v8 ad=0 pd=0 as=1.428n ps=0.152m w=42 l=15
C0 bank_0/replica_bitcell_array_0/bitcell_array_0/cell_1rw_31/qb bank_0/replica_bitcell_array_0/replica_column_0/replica_cell_1rw_15/q 0.02064f
C1 control_logic_rw_0/pdriver_0_0/pinv_6_0/A control_logic_rw_0/pdriver_0_0/pinv_4_0/pmos_m2_w0_840_sli_dli_da_p_0/a_54_0# 0.01899f
C2 control_logic_rw_0/dff_buf_array_0/dff_buf_0_1/pinv_1_0/vdd control_logic_rw_0/dff_buf_array_0/dout_0 0.15253f
C3 bank_0/replica_bitcell_array_0/dummy_array_3_0/dummy_cell_1rw_4/q bank_0/replica_bitcell_array_0/bitcell_array_0/cell_1rw_3/qb 0.01651f
C4 control_logic_rw_0/pdriver_1_0/pinv_6_0/nmos_m4_w0_520_sli_dli_da_p_0/a_54_0# bank_0/wl_en0 0.01546f
C5 control_logic_rw_0/delay_chain_0/pinv_11_17/pmos_m1_w0_840_sli_dli_da_p_0/a_54_0# control_logic_rw_0/delay_chain_0/pinv_11_17/Z 0.0129f
C6 bank_0/port_address_0/wordline_driver_array_0/wordline_driver_15/pinv_0/pmos_m1_w0_840_sli_dli_da_p_0/a_54_0# bank_0/port_address_0/wl_0 0.01304f
C7 bank_0/replica_bitcell_array_0/dummy_array_2_0/dummy_cell_1rw_15/a_145_76# bank_0/replica_bitcell_array_0/dummy_array_2_0/dummy_cell_1rw_15/qb 0.0163f
C8 control_logic_rw_0/pand3_0/C control_logic_rw_0/dff_buf_array_0/dff_buf_0_0/pinv_1_0/pmos_m3_w1_120_sli_dli_da_p_0/a_54_0# 0.01026f
C9 control_logic_rw_0/dff_buf_array_0/dff_buf_0_0/dff_0/net2 control_logic_rw_0/dff_buf_array_0/dff_buf_0_0/dff_0/net1 0.12728f
C10 bank_0/replica_bitcell_array_0/bitcell_array_0/cell_1rw_18/q bank_0/replica_bitcell_array_0/bitcell_array_0/cell_1rw_2/qb 0.02064f
C11 control_logic_rw_0/pand2_0/Z control_logic_rw_0/pand3_0/C 5.6523f
C12 bank_0/replica_bitcell_array_0/bitcell_array_0/cell_1rw_15/qb bank_0/port_address_0/wl_0 0.03696f
C13 control_logic_rw_0/pand3_0/C control_logic_rw_0/pand2_1/pnand2_0_0/nmos_m1_w0_840_sli_dactive_0/D 0.01213f
C14 control_logic_rw_0/pdriver_0_0/pinv_6_0/nmos_m4_w0_520_sli_dli_da_p_0/a_210_0# control_logic_rw_0/pdriver_0_0/pinv_7_0/A 0.01641f
C15 bank_0/replica_bitcell_array_0/dummy_array_2_0/dummy_cell_1rw_3/qb bank_0/port_address_0/wl_13 0.03923f
C16 control_logic_rw_0/pand3_0/C control_logic_rw_0/pdriver_0_0/pinv_4_0/pmos_m2_w0_840_sli_dli_da_p_0/a_132_0# 0.01481f
C17 bank_0/replica_bitcell_array_0/dummy_array_2_0/dummy_cell_1rw_9/qb bank_0/port_address_0/wl_7 0.03923f
C18 control_logic_rw_0/delay_chain_0/pinv_11_39/Z control_logic_rw_0/delay_chain_0/pinv_11_34/w_n127_403# 0.05137f
C19 control_logic_rw_0/pand3_0/C control_logic_rw_0/pand2_1/pdriver_0/pinv_2_0/nmos_m9_w0_560_sli_dli_da_p_0/a_678_0# 0.01142f
C20 bank_0/port_address_0/wordline_driver_array_0/wordline_driver_1/pinv_0/pmos_m1_w0_840_sli_dli_da_p_0/a_54_0# bank_0/port_address_0/wl_14 0.01304f
C21 bank_0/replica_bitcell_array_0/dummy_array_3_0/dummy_cell_1rw_10/a_145_76# bank_0/replica_bitcell_array_0/dummy_array_3_0/dummy_cell_1rw_10/qb 0.0163f
C22 control_logic_rw_0/delay_chain_0/pinv_11_7/pmos_m1_w0_840_sli_dli_da_p_0/a_54_0# control_logic_rw_0/delay_chain_0/pinv_11_7/Z 0.0129f
C23 bank_0/port_address_0/hierarchical_decoder_0/and2_dec_3/pinv_0/w_n127_244# bank_0/wl_en0 0.29624f
C24 control_logic_rw_0/pand3_0_0/gnd control_logic_rw_0/pinv_3_0/vdd 0.02784f
C25 row_addr_dff_0/dff_3/clk row_addr_dff_0/dff_2/net4 0.15111f
C26 bank_0/replica_bitcell_array_0/dummy_array_3_0/dummy_cell_1rw_18/qb bank_0/replica_bitcell_array_0/dummy_array_1_0/dummy_cell_1rw_0/q 0.02064f
C27 bank_0/port_address_0/hierarchical_decoder_0/and2_dec_9/pinv_0/w_n127_244# bank_0/port_address_0/hierarchical_decoder_0/predecode_3 0.02155f
C28 bank_0/replica_bitcell_array_0/dummy_array_3_0/dummy_cell_1rw_15/a_76_76# bank_0/replica_bitcell_array_0/dummy_array_3_0/dummy_cell_1rw_15/q 0.01645f
C29 bank_0/replica_bitcell_array_0/dummy_array_3_0/dummy_cell_1rw_11/q bank_0/replica_bitcell_array_0/dummy_array_3_0/dummy_cell_1rw_11/a_76_76# 0.01645f
C30 bank_0/replica_bitcell_array_0/dummy_array_1_0/dummy_cell_1rw_1/a_76_76# bank_0/replica_bitcell_array_0/dummy_array_1_0/dummy_cell_1rw_1/a_145_76# 0.06598f
C31 bank_0/replica_bitcell_array_0/bitcell_array_0/cell_1rw_6/q bank_0/port_address_0/wl_9 0.04136f
C32 bank_0/replica_bitcell_array_0/dummy_array_2_0/dummy_cell_1rw_4/a_76_76# bank_0/port_address_0/wl_12 0.05228f
C33 bank_0/replica_bitcell_array_0/bitcell_array_0/cell_1rw_11/qb bank_0/port_address_0/wl_4 0.03696f
C34 bank_0/port_address_0/hierarchical_decoder_0/and2_dec_7/pinv_0/w_n127_244# bank_0/port_address_0/hierarchical_decoder_0/predecode_6 0.34963f
C35 control_logic_rw_0/pand3_0/C control_logic_rw_0/pand2_0/pdriver_0/pinv_2_0/pmos_m9_w1_120_sli_dli_da_p_0/a_54_0# 0.02412f
C36 bank_0/port_address_0/wl_11 bank_0/replica_bitcell_array_0/dummy_array_3_0/dummy_cell_1rw_5/qb 0.03577f
C37 control_logic_rw_0/pdriver_0_0/pinv_7_0/nmos_m11_w0_570_sli_dli_da_p_0/a_54_0# control_logic_rw_0/pdriver_0_0/gnd 0.01119f
C38 control_logic_rw_0/delay_chain_0/pinv_11_5/Z control_logic_rw_0/delay_chain_0/pinv_11_6/Z 0.04321f
C39 bank_0/replica_bitcell_array_0/bitcell_array_0/cell_1rw_21/qb bank_0/replica_bitcell_array_0/bitcell_array_0/cell_1rw_21/q 0.28699f
C40 control_logic_rw_0/delay_chain_0/pinv_11_24/w_n127_403# control_logic_rw_0/delay_chain_0/pinv_11_22/Z 0.20256f
C41 bank_0/port_address_0/hierarchical_decoder_0/predecode_7 bank_0/port_address_0/hierarchical_decoder_0/hierarchical_predecode2x4_0/and2_dec_1/pinv_0/w_n127_244# 0.24541f
C42 bank_0/replica_bitcell_array_0/replica_column_0/replica_cell_1rw_0/q bank_0/port_address_0/wl_15 0.04211f
C43 control_logic_rw_0/delay_chain_0/pinv_11_43/Z control_logic_rw_0/delay_chain_0/pinv_11_44/w_n127_403# 0.20256f
C44 bank_0/replica_bitcell_array_0/dummy_array_3_0/dummy_cell_1rw_7/qb bank_0/replica_bitcell_array_0/bitcell_array_0/cell_1rw_6/q 0.02064f
C45 control_logic_rw_0/pand3_0/C control_logic_rw_0/pand3_0/pnand3_0_0/pmos_m1_w0_840_sli_dli_0/a_54_0# 0.01558f
C46 bank_0/replica_bitcell_array_0/bitcell_array_0/cell_1rw_8/qb bank_0/port_address_0/wl_7 0.03696f
C47 control_logic_rw_0/dff_buf_array_0/dff_buf_0_0/dff_0/clkb web0 0.34002f
C48 bank_0/replica_bitcell_array_0/dummy_array_3_0/dummy_cell_1rw_7/q bank_0/port_address_0/wl_9 0.04136f
C49 bank_0/replica_bitcell_array_0/bitcell_array_0/cell_1rw_14/q bank_0/replica_bitcell_array_0/bitcell_array_0/cell_1rw_30/qb 0.01651f
C50 bank_0/replica_bitcell_array_0/dummy_array_3_0/dummy_cell_1rw_10/qb bank_0/port_address_0/wl_6 0.03696f
C51 row_addr_dff_0/dff_3/clk bank_0/addr0_1 0.02092f
C52 bank_0/port_address_0/wl_10 bank_0/replica_bitcell_array_0/dummy_array_3_0/dummy_cell_1rw_6/a_76_76# 0.05176f
C53 control_logic_rw_0/pdriver_1_0/w_n127_195# bank_0/wl_en0 0.2879f
C54 bank_0/replica_bitcell_array_0/dummy_array_2_0/dummy_cell_1rw_8/a_76_76# bank_0/replica_bitcell_array_0/dummy_array_2_0/dummy_cell_1rw_8/q 0.01645f
C55 control_logic_rw_0/pnand2_1_0/w_n127_195# control_logic_rw_0/pand3_0/gnd 0.06745f
C56 bank_0/replica_bitcell_array_0/bitcell_array_0/cell_1rw_28/q bank_0/port_address_0/wl_3 0.04155f
C57 bank_0/replica_bitcell_array_0/dummy_array_2_0/dummy_cell_1rw_17/q bank_0/port_address_0/rbl_wl 0.0474f
C58 bank_0/replica_bitcell_array_0/dummy_array_3_0/dummy_cell_1rw_9/qb bank_0/replica_bitcell_array_0/dummy_array_3_0/dummy_cell_1rw_9/q 0.28699f
C59 bank_0/replica_bitcell_array_0/dummy_array_3_0/dummy_cell_1rw_7/qb bank_0/replica_bitcell_array_0/dummy_array_3_0/dummy_cell_1rw_7/q 0.28699f
C60 control_logic_rw_0/pnand2_1_0/nmos_m1_w0_840_sli_dactive_0/a_0_0# control_logic_rw_0/pinv_3_0/A 0.01779f
C61 bank_0/replica_bitcell_array_0/replica_column_0/replica_cell_1rw_14/q bank_0/replica_bitcell_array_0/dummy_array_2_0/dummy_cell_1rw_15/qb 0.01651f
C62 control_logic_rw_0/pand2_0/Z control_logic_rw_0/pand2_0/pdriver_0/pinv_2_0/nmos_m9_w0_560_sli_dli_da_p_0/a_288_0# 0.01255f
C63 control_logic_rw_0/pand3_0/C control_logic_rw_0/pand3_0_0/gnd 0.0202f
C64 control_logic_rw_0/pdriver_1_0/w_n127_195# control_logic_rw_0/pand3_0/gnd 0.05881f
C65 bank_0/replica_bitcell_array_0/dummy_array_2_0/dummy_cell_1rw_1/q bank_0/port_address_0/wl_15 0.0474f
C66 bank_0/replica_bitcell_array_0/dummy_array_3_0/dummy_cell_1rw_3/a_145_76# bank_0/replica_bitcell_array_0/dummy_array_3_0/dummy_cell_1rw_3/qb 0.0163f
C67 bank_0/replica_bitcell_array_0/bitcell_array_0/cell_1rw_0/q bank_0/replica_bitcell_array_0/dummy_array_3_0/dummy_cell_1rw_1/qb 0.02064f
C68 bank_0/replica_bitcell_array_0/dummy_array_2_0/dummy_cell_1rw_17/a_145_76# bank_0/replica_bitcell_array_0/dummy_array_2_0/dummy_cell_1rw_17/qb 0.0163f
C69 control_logic_rw_0/delay_chain_0/pinv_11_22/Z control_logic_rw_0/delay_chain_0/pinv_11_22/pmos_m1_w0_840_sli_dli_da_p_0/a_54_0# 0.0129f
C70 bank_0/wl_en0 control_logic_rw_0/pdriver_1_0/pinv_6_0/pmos_m4_w1_050_sli_dli_da_p_0/a_54_0# 0.02596f
C71 control_logic_rw_0/pand3_0/C bank_0/wl_en0 0.14581f
C72 bank_0/port_address_0/wl_11 bank_0/replica_bitcell_array_0/bitcell_array_0/cell_1rw_4/qb 0.03696f
C73 bank_0/replica_bitcell_array_0/bitcell_array_0/cell_1rw_1/q bank_0/port_address_0/wl_14 0.04136f
C74 control_logic_rw_0/delay_chain_0/pinv_11_1/Z control_logic_rw_0/delay_chain_0/pinv_11_4/w_n127_403# 0.20256f
C75 bank_0/replica_bitcell_array_0/dummy_array_2_0/dummy_cell_1rw_1/a_145_76# bank_0/replica_bitcell_array_0/dummy_array_2_0/dummy_cell_1rw_1/qb 0.0163f
C76 control_logic_rw_0/pand2_0/Z control_logic_rw_0/pdriver_1_0/pinv_8_0/Z 0.01198f
C77 bank_0/replica_bitcell_array_0/replica_column_0/replica_cell_1rw_4/q bank_0/replica_bitcell_array_0/dummy_array_2_0/dummy_cell_1rw_5/qb 0.01651f
C78 bank_0/replica_bitcell_array_0/replica_column_0/replica_cell_1rw_3/q bank_0/replica_bitcell_array_0/dummy_array_2_0/dummy_cell_1rw_4/qb 0.01651f
C79 control_logic_rw_0/delay_chain_0/pinv_11_29/Z control_logic_rw_0/delay_chain_0/pinv_11_34/Z 0.36098f
C80 control_logic_rw_0/dff_buf_array_0/dff_buf_0_1/pinv_1_0/pmos_m3_w1_120_sli_dli_da_p_0/a_132_0# control_logic_rw_0/dff_buf_array_0/dout_0 0.02363f
C81 control_logic_rw_0/pand3_0/C control_logic_rw_0/pand3_0/gnd 0.32108f
C82 bank_0/replica_bitcell_array_0/dummy_array_2_0/dummy_cell_1rw_7/a_76_76# bank_0/replica_bitcell_array_0/dummy_array_2_0/dummy_cell_1rw_7/a_145_76# 0.06598f
C83 control_logic_rw_0/delay_chain_0/pinv_11_24/w_n127_403# control_logic_rw_0/pinv_3_0/A 0.33207f
C84 control_logic_rw_0/dff_buf_array_0/dff_buf_0_0/pinv_1_0/pmos_m3_w1_120_sli_dli_da_p_0/a_210_0# control_logic_rw_0/pand3_0_0/C 0.02197f
C85 bank_0/replica_bitcell_array_0/dummy_array_3_0/dummy_cell_1rw_12/q bank_0/replica_bitcell_array_0/bitcell_array_0/cell_1rw_11/qb 0.01651f
C86 control_logic_rw_0/dff_buf_array_0/dff_buf_0_1/pinv_1_0/vdd control_logic_rw_0/dff_buf_array_0/dff_buf_0_0/pinv_1_0/pmos_m3_w1_120_sli_dli_da_p_0/a_210_0# 0.01281f
C87 bank_0/replica_bitcell_array_0/dummy_array_2_0/dummy_cell_1rw_6/a_76_76# bank_0/port_address_0/wl_10 0.05228f
C88 bank_0/replica_bitcell_array_0/dummy_array_2_0/dummy_cell_1rw_2/a_76_76# bank_0/replica_bitcell_array_0/dummy_array_2_0/dummy_cell_1rw_2/a_145_76# 0.06598f
C89 control_logic_rw_0/delay_chain_0/pinv_11_27/Z control_logic_rw_0/delay_chain_0/pinv_11_28/Z 0.04321f
C90 control_logic_rw_0/pand3_0/C control_logic_rw_0/pand2_1/pdriver_0/pinv_2_0/pmos_m9_w1_120_sli_dli_da_p_0/a_54_0# 0.0591f
C91 bank_0/replica_bitcell_array_0/bitcell_array_0/cell_1rw_10/qb bank_0/port_address_0/wl_5 0.03696f
C92 control_logic_rw_0/pand3_0/C control_logic_rw_0/pdriver_0_0/pinv_5_0/pmos_m1_w0_840_sli_dli_da_p_0/a_54_0# 0.01103f
C93 bank_0/replica_bitcell_array_0/dummy_array_2_0/dummy_cell_1rw_12/a_76_76# bank_0/port_address_0/wl_4 0.05228f
C94 bank_0/wl_en0 bank_0/port_address_0/hierarchical_decoder_0/and2_dec_11/pinv_0/w_n127_244# 0.29624f
C95 bank_0/replica_bitcell_array_0/replica_column_0/replica_cell_1rw_13/q bank_0/replica_bitcell_array_0/dummy_array_2_0/dummy_cell_1rw_14/qb 0.01651f
C96 bank_0/replica_bitcell_array_0/dummy_array_3_0/dummy_cell_1rw_4/q bank_0/replica_bitcell_array_0/dummy_array_3_0/dummy_cell_1rw_4/a_76_76# 0.01645f
C97 control_logic_rw_0/dff_buf_array_0/dff_buf_0_1/pinv_1_0/nmos_m3_w0_560_sli_dli_da_p_0/a_132_0# control_logic_rw_0/dff_buf_array_0/dout_0 0.01532f
C98 control_logic_rw_0/dff_buf_array_0/dff_buf_0_0/pinv_1_0/nmos_m3_w0_560_sli_dli_da_p_0/a_132_0# control_logic_rw_0/dff_buf_array_0/dff_buf_0_0/pinv_1_0/gnd 0.01798f
C99 bank_0/port_address_0/hierarchical_decoder_0/hierarchical_predecode2x4_1/and2_dec_1/pinv_0/w_n127_244# bank_0/port_address_0/hierarchical_decoder_0/hierarchical_predecode2x4_1/pinv_1/Z 0.0212f
C100 control_logic_rw_0/delay_chain_0/pinv_11_34/Z control_logic_rw_0/delay_chain_0/pinv_11_34/pmos_m1_w0_840_sli_dli_da_p_0/a_54_0# 0.01702f
C101 bank_0/port_address_0/wl_7 bank_0/replica_bitcell_array_0/dummy_array_3_0/dummy_cell_1rw_9/qb 0.03696f
C102 control_logic_rw_0/pand3_0/pdriver_2_0/pinv_9_0/pmos_m7_w1_200_sli_dli_da_p_0/a_288_0# control_logic_rw_0/pinv_3_0/A 0.02847f
C103 bank_0/port_address_0/wl_11 bank_0/replica_bitcell_array_0/dummy_array_2_0/dummy_cell_1rw_5/a_145_76# 0.04284f
C104 data_dff_0/dff_0/net4 data_dff_0/dff_0/net5 0.13677f
C105 bank_0/port_address_0/hierarchical_decoder_0/hierarchical_predecode2x4_0/and2_dec_0/pinv_0/pmos_m1_w0_840_sli_dli_da_p_0/a_54_0# bank_0/port_address_0/hierarchical_decoder_0/predecode_7 0.01558f
C106 bank_0/port_address_0/hierarchical_decoder_0/and2_dec_13/pinv_0/w_n127_244# bank_0/port_address_0/hierarchical_decoder_0/predecode_6 0.02963f
C107 bank_0/replica_bitcell_array_0/bitcell_array_0/cell_1rw_23/qb bank_0/replica_bitcell_array_0/replica_column_0/replica_cell_1rw_7/q 0.02064f
C108 web0 csb0 0.01007f
C109 control_logic_rw_0/dff_buf_array_0/dff_buf_0_1/pinv_1_0/vdd control_logic_rw_0/dff_buf_array_0/dff_buf_0_1/dff_0/Q 0.05616f
C110 control_logic_rw_0/pdriver_0_0/pinv_6_0/A control_logic_rw_0/pinv_3_1/w_n127_195# 0.20248f
C111 bank_0/replica_bitcell_array_0/replica_column_0/dummy_cell_1rw_0/q bank_0/replica_bitcell_array_0/replica_column_0/dummy_cell_1rw_0/a_76_76# 0.01645f
C112 control_logic_rw_0/pand3_0/pdriver_2_0/pinv_9_0/nmos_m7_w0_600_sli_dli_da_p_0/a_210_0# control_logic_rw_0/pand3_0/gnd 0.01158f
C113 bank_0/replica_bitcell_array_0/dummy_array_3_0/dummy_cell_1rw_1/q bank_0/replica_bitcell_array_0/dummy_array_3_0/dummy_cell_1rw_1/qb 0.28699f
C114 control_logic_rw_0/pand3_0/C control_logic_rw_0/pand2_1/pdriver_0/pinv_2_0/pmos_m9_w1_120_sli_dli_da_p_0/a_678_0# 0.03322f
C115 row_addr_dff_0/dff_1/net4 row_addr_dff_0/dff_1/net5 0.13677f
C116 control_logic_rw_0/pand3_0_0/pnand3_0_0/nmos_m1_w0_840_sactive_dli_0/a_54_0# control_logic_rw_0/pand3_0_0/C 0.01624f
C117 control_logic_rw_0/dff_buf_array_0/dff_buf_0_1/dff_0/net1 control_logic_rw_0/dff_buf_array_0/dff_buf_0_1/dff_0/clkb 0.1543f
C118 control_logic_rw_0/pand2_1/gnd control_logic_rw_0/pand2_0/pdriver_0/pinv_2_0/nmos_m9_w0_560_sli_dli_da_p_0/a_0_0# 0.01105f
C119 bank_0/port_address_0/hierarchical_decoder_0/hierarchical_predecode2x4_1/and2_dec_1/pinv_0/w_n127_244# bank_0/port_address_0/hierarchical_decoder_0/predecode_0 0.15028f
C120 bank_0/port_address_0/hierarchical_decoder_0/predecode_1 bank_0/port_address_0/hierarchical_decoder_0/and2_dec_15/pinv_0/w_n127_244# 0.04371f
C121 bank_0/port_address_0/wordline_driver_array_0/in_4 bank_0/wl_en0 0.18688f
C122 control_logic_rw_0/delay_chain_0/pinv_11_34/Z control_logic_rw_0/delay_chain_0/pinv_11_31/Z 0.13787f
C123 control_logic_rw_0/delay_chain_0/pinv_11_15/Z control_logic_rw_0/delay_chain_0/pinv_11_24/w_n127_403# 0.19711f
C124 bank_0/replica_bitcell_array_0/dummy_array_3_0/dummy_cell_1rw_5/a_145_76# bank_0/replica_bitcell_array_0/dummy_array_3_0/dummy_cell_1rw_5/qb 0.0163f
C125 bank_0/replica_bitcell_array_0/dummy_array_2_0/dummy_cell_1rw_10/a_76_76# bank_0/replica_bitcell_array_0/dummy_array_2_0/dummy_cell_1rw_10/a_145_76# 0.06598f
C126 control_logic_rw_0/dff_buf_array_0/dff_buf_0_1/pinv_1_0/vdd control_logic_rw_0/dff_buf_array_0/dff_buf_0_1/pinv_0_0/pmos_m2_w0_840_sli_dli_da_p_0/a_0_0# 0.01403f
C127 control_logic_rw_0/pdriver_1_0/pinv_8_0/Z control_logic_rw_0/pand3_0/gnd 0.12549f
C128 control_logic_rw_0/delay_chain_0/pinv_11_44/w_n127_403# control_logic_rw_0/pinv_3_0/A 0.33207f
C129 bank_0/replica_bitcell_array_0/replica_column_0/dummy_cell_1rw_1/q bank_0/replica_bitcell_array_0/replica_column_0/dummy_cell_1rw_1/qb 0.28699f
C130 data_dff_0/dff_1/clkb din0[0] 0.31952f
C131 control_logic_rw_0/dff_buf_array_0/dff_buf_0_1/pinv_1_0/vdd control_logic_rw_0/dff_buf_array_0/dff_buf_0_1/pinv_1_0/pmos_m3_w1_120_sli_dli_da_p_0/a_0_0# 0.0184f
C132 bank_0/replica_bitcell_array_0/bitcell_array_0/cell_1rw_15/q bank_0/port_address_0/wl_0 0.04136f
C133 bank_0/replica_bitcell_array_0/dummy_array_2_0/dummy_cell_1rw_3/q bank_0/port_address_0/wl_13 0.0474f
C134 control_logic_rw_0/pand2_0/Z control_logic_rw_0/pand2_0/pdriver_0/pinv_2_0/pmos_m9_w1_120_sli_dli_da_p_0/a_210_0# 0.03489f
C135 bank_0/replica_bitcell_array_0/dummy_array_2_0/dummy_cell_1rw_9/q bank_0/port_address_0/wl_7 0.0474f
C136 bank_0/replica_bitcell_array_0/dummy_array_3_0/dummy_cell_1rw_6/a_76_76# bank_0/replica_bitcell_array_0/dummy_array_3_0/dummy_cell_1rw_6/a_145_76# 0.06598f
C137 control_logic_rw_0/delay_chain_0/pinv_11_16/Z control_logic_rw_0/delay_chain_0/pinv_11_17/Z 0.04321f
C138 control_logic_rw_0/delay_chain_0/pinv_11_26/Z control_logic_rw_0/delay_chain_0/pinv_11_26/pmos_m1_w0_840_sli_dli_da_p_0/a_54_0# 0.0129f
C139 bank_0/port_address_0/hierarchical_decoder_0/predecode_1 bank_0/port_address_0/hierarchical_decoder_0/predecode_0 5.43708f
C140 control_logic_rw_0/pand2_1/gnd control_logic_rw_0/pand2_1/pdriver_0/pinv_2_0/nmos_m9_w0_560_sli_dli_da_p_0/a_210_0# 0.01066f
C141 bank_0/replica_bitcell_array_0/dummy_array_3_0/dummy_cell_1rw_4/qb bank_0/replica_bitcell_array_0/bitcell_array_0/cell_1rw_3/q 0.02064f
C142 control_logic_rw_0/delay_chain_0/pinv_11_35/Z control_logic_rw_0/delay_chain_0/pinv_11_36/Z 0.04321f
C143 bank_0/replica_bitcell_array_0/dummy_array_2_0/dummy_cell_1rw_3/a_145_76# bank_0/replica_bitcell_array_0/dummy_array_2_0/dummy_cell_1rw_3/qb 0.0163f
C144 control_logic_rw_0/delay_chain_0/pinv_11_33/Z control_logic_rw_0/delay_chain_0/pinv_11_32/Z 0.04321f
C145 row_addr_dff_0/dff_2/net3 row_addr_dff_0/dff_2/net1 0.14299f
C146 bank_0/replica_bitcell_array_0/dummy_array_2_0/dummy_cell_1rw_9/a_145_76# bank_0/replica_bitcell_array_0/dummy_array_2_0/dummy_cell_1rw_9/qb 0.0163f
C147 bank_0/addr0_2 row_addr_dff_0/dff_1/net4 0.22531f
C148 bank_0/port_address_0/hierarchical_decoder_0/and2_dec_5/pinv_0/w_n127_244# bank_0/port_address_0/hierarchical_decoder_0/predecode_6 0.34424f
C149 bank_0/port_address_0/hierarchical_decoder_0/and2_dec_13/pinv_0/w_n127_244# bank_0/port_address_0/wordline_driver_array_0/in_3 0.14946f
C150 control_logic_rw_0/pdriver_1_0/w_n127_195# control_logic_rw_0/pdriver_1_0/pinv_8_0/A 0.16641f
C151 bank_0/replica_bitcell_array_0/bitcell_array_0/cell_1rw_11/q bank_0/port_address_0/wl_4 0.04136f
C152 control_logic_rw_0/pand3_0/C control_logic_rw_0/pdriver_0_0/pinv_6_0/A 0.22888f
C153 bank_0/port_address_0/wl_11 bank_0/replica_bitcell_array_0/dummy_array_3_0/dummy_cell_1rw_5/q 0.04009f
C154 control_logic_rw_0/delay_chain_0/pinv_11_15/Z control_logic_rw_0/pinv_3_0/A 0.04231f
C155 bank_0/replica_bitcell_array_0/bitcell_array_0/cell_1rw_20/qb bank_0/port_address_0/wl_11 0.03704f
C156 bank_0/port_address_0/hierarchical_decoder_0/predecode_7 bank_0/port_address_0/hierarchical_decoder_0/and2_dec_3/pinv_0/w_n127_244# 0.44085f
C157 control_logic_rw_0/pand2_0/Z control_logic_rw_0/pand2_0/pdriver_0/pinv_2_0/pmos_m9_w1_120_sli_dli_da_p_0/a_444_0# 0.02293f
C158 control_logic_rw_0/pdriver_0_0/pinv_6_0/A control_logic_rw_0/pdriver_0_0/pinv_4_0/nmos_m2_w0_420_sli_dli_da_p_0/a_54_0# 0.01144f
C159 bank_0/wl_en0 control_logic_rw_0/pdriver_1_0/pinv_6_0/nmos_m4_w0_520_sli_dli_da_p_0/a_210_0# 0.0171f
C160 bank_0/replica_bitcell_array_0/replica_column_0/replica_cell_1rw_6/q bank_0/port_address_0/wl_9 0.04211f
C161 bank_0/replica_bitcell_array_0/dummy_array_3_0/dummy_cell_1rw_2/qb bank_0/replica_bitcell_array_0/bitcell_array_0/cell_1rw_1/q 0.02064f
C162 bank_0/port_address_0/wordline_driver_array_0/in_13 bank_0/port_address_0/wordline_driver_array_0/in_14 0.01362f
C163 bank_0/replica_bitcell_array_0/dummy_array_2_0/dummy_cell_1rw_4/a_76_76# bank_0/replica_bitcell_array_0/dummy_array_2_0/dummy_cell_1rw_4/a_145_76# 0.06598f
C164 control_logic_rw_0/pand3_0/C control_logic_rw_0/dff_buf_array_0/dout_0 0.20301f
C165 bank_0/port_address_0/wl_1 bank_0/replica_bitcell_array_0/dummy_array_2_0/dummy_cell_1rw_15/a_76_76# 0.05228f
C166 control_logic_rw_0/delay_chain_0/pinv_11_33/Z control_logic_rw_0/delay_chain_0/pinv_11_34/w_n127_403# 0.20256f
C167 bank_0/replica_bitcell_array_0/bitcell_array_0/cell_1rw_23/qb bank_0/replica_bitcell_array_0/bitcell_array_0/cell_1rw_23/q 0.28699f
C168 bank_0/replica_bitcell_array_0/dummy_array_2_0/dummy_cell_1rw_2/qb bank_0/replica_bitcell_array_0/dummy_array_2_0/dummy_cell_1rw_2/q 0.28699f
C169 bank_0/replica_bitcell_array_0/dummy_array_2_0/dummy_cell_1rw_8/a_76_76# bank_0/port_address_0/wl_8 0.05228f
C170 control_logic_rw_0/pand3_0/C control_logic_rw_0/pdriver_1_0/pinv_8_0/A 0.22575f
C171 bank_0/replica_bitcell_array_0/dummy_array_0_0/dummy_cell_1rw_1/q bank_0/replica_bitcell_array_0/dummy_array_0_0/dummy_cell_1rw_1/a_76_76# 0.01645f
C172 control_logic_rw_0/dff_buf_array_0/dff_buf_0_0/pinv_0_0/pmos_m2_w0_840_sli_dli_da_p_0/a_0_0# control_logic_rw_0/dff_buf_array_0/dff_buf_0_1/pinv_1_0/vdd 0.01403f
C173 row_addr_dff_0/dff_2/net1 row_addr_dff_0/dff_2/net2 0.12728f
C174 bank_0/port_address_0/wordline_driver_array_0/in_11 bank_0/port_address_0/wordline_driver_array_0/in_10 0.01302f
C175 bank_0/replica_bitcell_array_0/bitcell_array_0/cell_1rw_25/q bank_0/replica_bitcell_array_0/bitcell_array_0/cell_1rw_9/qb 0.02064f
C176 bank_0/port_address_0/hierarchical_decoder_0/predecode_4 bank_0/port_address_0/hierarchical_decoder_0/hierarchical_predecode2x4_0/and2_dec_3/pinv_0/w_n127_244# 0.15163f
C177 row_addr_dff_0/dff_1/net3 row_addr_dff_0/dff_1/clkb 0.14179f
C178 bank_0/port_address_0/wordline_driver_array_0/in_9 bank_0/wl_en0 0.18688f
C179 bank_0/addr0_3 row_addr_dff_0/dff_0/net5 0.08416f
C180 control_logic_rw_0/pand3_0/pdriver_2_0/pinv_9_0/nmos_m7_w0_600_sli_dli_da_p_0/a_0_0# control_logic_rw_0/pand3_0/gnd 0.01171f
C181 row_addr_dff_0/dff_3/clk row_addr_dff_0/dff_1/net5 0.03761f
C182 bank_0/replica_bitcell_array_0/bitcell_array_0/cell_1rw_9/q bank_0/replica_bitcell_array_0/dummy_array_3_0/dummy_cell_1rw_10/qb 0.02064f
C183 bank_0/replica_bitcell_array_0/bitcell_array_0/cell_1rw_14/qb bank_0/port_address_0/wl_1 0.03696f
C184 bank_0/port_address_0/wordline_driver_array_0/in_3 bank_0/port_address_0/hierarchical_decoder_0/and2_dec_12/pinv_0/pmos_m1_w0_840_sli_dli_da_p_0/a_54_0# 0.01304f
C185 bank_0/replica_bitcell_array_0/dummy_array_2_0/dummy_cell_1rw_7/q bank_0/replica_bitcell_array_0/dummy_array_2_0/dummy_cell_1rw_7/a_76_76# 0.01645f
C186 bank_0/port_address_0/wl_4 bank_0/port_address_0/wl_3 0.13236f
C187 bank_0/port_address_0/hierarchical_decoder_0/hierarchical_predecode2x4_0/pinv_0/Z bank_0/addr0_2 1.57282f
C188 control_logic_rw_0/delay_chain_0/pinv_11_28/Z control_logic_rw_0/delay_chain_0/pinv_11_34/w_n127_403# 0.20256f
C189 bank_0/port_address_0/hierarchical_decoder_0/predecode_6 bank_0/port_address_0/hierarchical_decoder_0/hierarchical_predecode2x4_0/and2_dec_1/pinv_0/w_n127_244# 0.18316f
C190 control_logic_rw_0/pand3_0/C control_logic_rw_0/pand2_1/pdriver_0/pinv_2_0/nmos_m9_w0_560_sli_dli_da_p_0/a_132_0# 0.01211f
C191 control_logic_rw_0/pdriver_0_0/pinv_7_0/nmos_m11_w0_570_sli_dli_da_p_0/a_210_0# control_logic_rw_0/pdriver_0_0/gnd 0.01095f
C192 control_logic_rw_0/delay_chain_0/pinv_11_37/pmos_m1_w0_840_sli_dli_da_p_0/a_54_0# control_logic_rw_0/delay_chain_0/pinv_11_37/Z 0.0129f
C193 control_logic_rw_0/dff_buf_array_0/dff_buf_0_1/pinv_1_0/pmos_m3_w1_120_sli_dli_da_p_0/a_210_0# control_logic_rw_0/dff_buf_array_0/dout_0 0.02156f
C194 control_logic_rw_0/delay_chain_0/pinv_11_27/Z control_logic_rw_0/delay_chain_0/pinv_11_34/w_n127_403# 0.20256f
C195 control_logic_rw_0/pand3_0/B control_logic_rw_0/pand3_0_0/C 0.1375f
C196 bank_0/replica_bitcell_array_0/dummy_array_2_0/dummy_cell_1rw_5/q bank_0/port_address_0/wl_11 0.04613f
C197 bank_0/replica_bitcell_array_0/bitcell_array_0/cell_1rw_22/qb bank_0/replica_bitcell_array_0/bitcell_array_0/cell_1rw_22/q 0.28699f
C198 control_logic_rw_0/dff_buf_array_0/dff_buf_0_1/pinv_1_0/vdd control_logic_rw_0/pand3_0/B 0.02965f
C199 control_logic_rw_0/pdriver_0_0/gnd control_logic_rw_0/pdriver_0_0/pinv_7_0/nmos_m11_w0_570_sli_dli_da_p_0/a_288_0# 0.01807f
C200 bank_0/replica_bitcell_array_0/dummy_array_3_0/dummy_cell_1rw_6/qb bank_0/replica_bitcell_array_0/dummy_array_3_0/dummy_cell_1rw_6/q 0.28699f
C201 control_logic_rw_0/pand2_1/gnd control_logic_rw_0/pand2_1/pdriver_0/pinv_2_0/nmos_m9_w0_560_sli_dli_da_p_0/a_600_0# 0.01796f
C202 bank_0/port_address_0/rbl_wl bank_0/replica_bitcell_array_0/dummy_array_0/dummy_cell_1rw_0/a_145_76# 0.04284f
C203 bank_0/port_address_0/wordline_driver_array_0/in_5 bank_0/port_address_0/hierarchical_decoder_0/and2_dec_11/pinv_0/w_n127_244# 0.14946f
C204 bank_0/port_address_0/wordline_driver_array_0/in_9 bank_0/port_address_0/wordline_driver_array_0/in_8 0.01302f
C205 bank_0/replica_bitcell_array_0/bitcell_array_0/cell_1rw_2/qb bank_0/replica_bitcell_array_0/bitcell_array_0/cell_1rw_2/q 0.28699f
C206 control_logic_rw_0/pdriver_1_0/pinv_6_0/nmos_m4_w0_520_sli_dli_da_p_0/a_288_0# control_logic_rw_0/pand3_0/gnd 0.01011f
C207 control_logic_rw_0/delay_chain_0/pinv_11_34/w_n127_403# control_logic_rw_0/pinv_3_0/A 0.33207f
C208 control_logic_rw_0/pand3_0/C control_logic_rw_0/pdriver_0_0/pinv_6_0/pmos_m4_w1_050_sli_dli_da_p_0/a_132_0# 0.02823f
C209 control_logic_rw_0/pinv_3_0/w_n127_195# bank_0/p_en_bar0 0.01149f
C210 bank_0/replica_bitcell_array_0/bitcell_array_0/cell_1rw_1/q bank_0/replica_bitcell_array_0/bitcell_array_0/cell_1rw_1/qb 0.28699f
C211 addr0[3] row_addr_dff_0/dff_0/net1 0.08098f
C212 bank_0/replica_bitcell_array_0/dummy_array_3_0/dummy_cell_1rw_17/a_76_76# bank_0/port_address_0/rbl_wl 0.05176f
C213 bank_0/replica_bitcell_array_0/dummy_array_3_0/dummy_cell_1rw_18/a_76_76# bank_0/replica_bitcell_array_0/dummy_array_3_0/dummy_cell_1rw_18/q 0.01645f
C214 bank_0/replica_bitcell_array_0/dummy_array_3_0/dummy_cell_1rw_13/a_145_76# bank_0/replica_bitcell_array_0/dummy_array_3_0/dummy_cell_1rw_13/a_76_76# 0.06598f
C215 control_logic_rw_0/pand3_0/pnand3_0_0/nmos_m1_w0_840_sactive_dli_0/S control_logic_rw_0/pand3_0/gnd 0.01146f
C216 bank_0/addr0_2 row_addr_dff_0/dff_3/clk 0.02068f
C217 bank_0/port_address_0/hierarchical_decoder_0/and2_dec_15/pinv_0/w_n127_244# bank_0/port_address_0/wl_0 0.16398f
C218 bank_0/replica_bitcell_array_0/bitcell_array_0/cell_1rw_10/q bank_0/port_address_0/wl_5 0.04136f
C219 bank_0/port_address_0/wl_11 bank_0/port_address_0/wordline_driver_array_0/wordline_driver_4/pinv_0/pmos_m1_w0_840_sli_dli_da_p_0/a_54_0# 0.01304f
C220 bank_0/port_address_0/hierarchical_decoder_0/predecode_4 bank_0/port_address_0/hierarchical_decoder_0/predecode_3 5.50661f
C221 bank_0/replica_bitcell_array_0/bitcell_array_0/cell_1rw_10/qb bank_0/replica_bitcell_array_0/bitcell_array_0/cell_1rw_10/q 0.28699f
C222 control_logic_rw_0/pdriver_1_0/pinv_8_0/pmos_m1_w0_840_sli_dli_da_p_0/a_54_0# control_logic_rw_0/pdriver_1_0/pinv_8_0/Z 0.0132f
C223 bank_0/replica_bitcell_array_0/dummy_array_2_0/dummy_cell_1rw_10/qb bank_0/replica_bitcell_array_0/dummy_array_2_0/dummy_cell_1rw_10/q 0.28699f
C224 bank_0/port_address_0/rbl_wl bank_0/replica_bitcell_array_0/replica_column_0/replica_cell_1rw_16/q 0.04211f
C225 control_logic_rw_0/delay_chain_0/pinv_11_8/pmos_m1_w0_840_sli_dli_da_p_0/a_54_0# control_logic_rw_0/delay_chain_0/pinv_11_8/Z 0.0129f
C226 control_logic_rw_0/delay_chain_0/pinv_11_36/Z control_logic_rw_0/delay_chain_0/pinv_11_36/pmos_m1_w0_840_sli_dli_da_p_0/a_54_0# 0.0129f
C227 bank_0/replica_bitcell_array_0/dummy_array_2_0/dummy_cell_1rw_6/a_76_76# bank_0/replica_bitcell_array_0/dummy_array_2_0/dummy_cell_1rw_6/a_145_76# 0.06598f
C228 bank_0/port_address_0/wordline_driver_array_0/wordline_driver_11/pinv_0/pmos_m1_w0_840_sli_dli_da_p_0/a_54_0# bank_0/port_address_0/wl_4 0.01304f
C229 bank_0/port_address_0/wordline_driver_array_0/in_13 bank_0/port_address_0/hierarchical_decoder_0/and2_dec_2/pinv_0/pmos_m1_w0_840_sli_dli_da_p_0/a_54_0# 0.01304f
C230 bank_0/replica_bitcell_array_0/dummy_array_3_0/dummy_cell_1rw_12/a_76_76# bank_0/replica_bitcell_array_0/dummy_array_3_0/dummy_cell_1rw_12/a_145_76# 0.06598f
C231 bank_0/port_address_0/wl_7 bank_0/replica_bitcell_array_0/dummy_array_3_0/dummy_cell_1rw_9/q 0.04136f
C232 bank_0/replica_bitcell_array_0/bitcell_array_0/cell_1rw_7/qb bank_0/replica_bitcell_array_0/bitcell_array_0/cell_1rw_23/q 0.02064f
C233 bank_0/replica_bitcell_array_0/dummy_array_2_0/dummy_cell_1rw_11/a_145_76# bank_0/port_address_0/wl_5 0.04284f
C234 bank_0/replica_bitcell_array_0/dummy_array_3_0/dummy_cell_1rw_14/q bank_0/replica_bitcell_array_0/dummy_array_3_0/dummy_cell_1rw_14/qb 0.28699f
C235 bank_0/replica_bitcell_array_0/dummy_array_2_0/dummy_cell_1rw_12/a_76_76# bank_0/replica_bitcell_array_0/dummy_array_2_0/dummy_cell_1rw_12/a_145_76# 0.06598f
C236 bank_0/port_address_0/hierarchical_decoder_0/predecode_5 bank_0/port_address_0/hierarchical_decoder_0/and2_dec_11/pinv_0/w_n127_244# 0.30344f
C237 row_addr_dff_0/dff_3/clkb row_addr_dff_0/dff_3/net3 0.14179f
C238 bank_0/port_address_0/hierarchical_decoder_0/predecode_7 bank_0/port_address_0/hierarchical_decoder_0/and2_dec_11/pinv_0/w_n127_244# 0.14845f
C239 bank_0/replica_bitcell_array_0/bitcell_array_0/cell_1rw_13/q bank_0/replica_bitcell_array_0/bitcell_array_0/cell_1rw_29/qb 0.01651f
C240 bank_0/replica_bitcell_array_0/bitcell_array_0/cell_1rw_13/qb bank_0/replica_bitcell_array_0/bitcell_array_0/cell_1rw_29/q 0.02064f
C241 bank_0/port_address_0/wordline_driver_array_0/in_4 bank_0/port_address_0/wordline_driver_array_0/in_5 0.01302f
C242 bank_0/replica_bitcell_array_0/replica_column_0/dummy_cell_1rw_1/a_76_76# bank_0/replica_bitcell_array_0/replica_column_0/dummy_cell_1rw_1/q 0.01645f
C243 bank_0/replica_bitcell_array_0/replica_column_0/replica_cell_1rw_12/q bank_0/port_address_0/wl_3 0.04211f
C244 control_logic_rw_0/pdriver_1_0/pinv_8_0/Z control_logic_rw_0/pdriver_1_0/pinv_8_0/A 0.0798f
C245 control_logic_rw_0/delay_chain_0/pinv_11_25/Z control_logic_rw_0/delay_chain_0/pinv_11_26/Z 0.04321f
C246 bank_0/port_address_0/wordline_driver_array_0/wordline_driver_2/pinv_0/pmos_m1_w0_840_sli_dli_da_p_0/a_54_0# bank_0/port_address_0/wl_13 0.01304f
C247 bank_0/replica_bitcell_array_0/dummy_array_3_0/dummy_cell_1rw_11/a_76_76# bank_0/replica_bitcell_array_0/dummy_array_3_0/dummy_cell_1rw_11/a_145_76# 0.06598f
C248 control_logic_rw_0/pand3_0_0/pnand3_0_0/pmos_m1_w0_840_sli_dli_0/a_54_0# control_logic_rw_0/pand3_0_0/C 0.01534f
C249 bank_0/port_address_0/wordline_driver_array_0/in_15 bank_0/port_address_0/wordline_driver_array_0/in_14 0.01302f
C250 bank_0/replica_bitcell_array_0/dummy_array_1_0/dummy_cell_1rw_0/q bank_0/replica_bitcell_array_0/dummy_array_1_0/dummy_cell_1rw_0/qb 0.28699f
C251 control_logic_rw_0/pinv_3_1/pmos_m1_w0_840_sli_dli_da_p_0/a_54_0# control_logic_rw_0/pand2_1/A 0.01319f
C252 control_logic_rw_0/delay_chain_0/pinv_11_44/Z control_logic_rw_0/delay_chain_0/pinv_11_42/Z 0.14324f
C253 bank_0/port_address_0/wordline_driver_array_0/in_12 bank_0/port_address_0/wordline_driver_array_0/in_13 0.01302f
C254 bank_0/port_address_0/wl_14 bank_0/port_address_0/wl_15 0.03867f
C255 control_logic_rw_0/delay_chain_0/pinv_11_29/Z control_logic_rw_0/delay_chain_0/pinv_11_25/Z 0.11884f
C256 control_logic_rw_0/dff_buf_array_0/dff_buf_0_1/pinv_1_0/w_n127_195# control_logic_rw_0/dff_buf_array_0/dff_buf_0_1/pinv_1_0/gnd 0.04571f
C257 control_logic_rw_0/dff_buf_array_0/dff_buf_0_1/pinv_1_0/vdd control_logic_rw_0/dff_buf_array_0/dff_buf_0_1/pinv_0_0/pmos_m2_w0_840_sli_dli_da_p_0/a_54_0# 0.01857f
C258 control_logic_rw_0/delay_chain_0/pinv_11_9/w_n127_403# control_logic_rw_0/delay_chain_0/pinv_11_9/Z 0.75229f
C259 bank_0/replica_bitcell_array_0/dummy_array_2_0/dummy_cell_1rw_4/qb bank_0/replica_bitcell_array_0/dummy_array_2_0/dummy_cell_1rw_4/q 0.28699f
C260 control_logic_rw_0/dff_buf_array_0/dff_buf_0_1/pinv_1_0/vdd control_logic_rw_0/dff_buf_array_0/dff_buf_0_1/pinv_1_0/pmos_m3_w1_120_sli_dli_da_p_0/a_54_0# 0.02305f
C261 row_addr_dff_0/dff_2/net3 row_addr_dff_0/dff_2/net2 0.03271f
C262 bank_0/port_address_0/wordline_driver_array_0/in_1 bank_0/port_address_0/hierarchical_decoder_0/and2_dec_14/pinv_0/pmos_m1_w0_840_sli_dli_da_p_0/a_54_0# 0.01304f
C263 bank_0/replica_bitcell_array_0/dummy_array_2_0/dummy_cell_1rw_9/qb bank_0/replica_bitcell_array_0/replica_column_0/replica_cell_1rw_8/q 0.01651f
C264 bank_0/replica_bitcell_array_0/replica_column_0/replica_cell_1rw_1/q bank_0/replica_bitcell_array_0/dummy_array_2_0/dummy_cell_1rw_2/qb 0.01651f
C265 bank_0/addr0_1 row_addr_dff_0/dff_2/net4 0.22508f
C266 control_logic_rw_0/delay_chain_0/pinv_11_9/A control_logic_rw_0/delay_chain_0/pinv_11_10/Z 0.11884f
C267 control_logic_rw_0/delay_chain_0/pinv_11_19/Z control_logic_rw_0/delay_chain_0/pinv_11_17/Z 0.14367f
C268 control_logic_rw_0/pand3_0/C control_logic_rw_0/pdriver_0_0/pinv_7_0/pmos_m11_w1_150_sli_dli_da_p_0/a_522_0# 0.02257f
C269 control_logic_rw_0/pand2_0/Z control_logic_rw_0/pand2_0/pdriver_0/pinv_2_0/pmos_m9_w1_120_sli_dli_da_p_0/a_522_0# 0.03184f
C270 control_logic_rw_0/pand2_0/Z control_logic_rw_0/pand2_0/pdriver_0/pinv_2_0/pmos_m9_w1_120_sli_dli_da_p_0/a_288_0# 0.02542f
C271 bank_0/replica_bitcell_array_0/dummy_array_3_0/dummy_cell_1rw_3/q bank_0/port_address_0/wl_13 0.04136f
C272 row_addr_dff_0/dff_3/net4 row_addr_dff_0/dff_3/net3 0.04611f
C273 control_logic_rw_0/pand2_1/gnd control_logic_rw_0/pand2_1/pdriver_0/pinv_2_0/nmos_m9_w0_560_sli_dli_da_p_0/a_54_0# 0.01089f
C274 control_logic_rw_0/pand3_0/C control_logic_rw_0/dff_buf_array_0/dff_buf_0_1/dff_0/Q 0.14549f
C275 bank_0/port_address_0/wordline_driver_array_0/in_2 bank_0/port_address_0/hierarchical_decoder_0/and2_dec_13/pinv_0/pmos_m1_w0_840_sli_dli_da_p_0/a_54_0# 0.01304f
C276 control_logic_rw_0/delay_chain_0/pinv_11_34/w_n127_403# control_logic_rw_0/delay_chain_0/pinv_11_32/Z 0.20256f
C277 bank_0/port_address_0/hierarchical_decoder_0/predecode_2 bank_0/port_address_0/hierarchical_decoder_0/hierarchical_predecode2x4_1/and2_dec_1/pinv_0/w_n127_244# 0.17575f
C278 control_logic_rw_0/dff_buf_array_0/dff_buf_0_0/dff_0/net3 control_logic_rw_0/dff_buf_array_0/dff_buf_0_0/dff_0/net1 0.14299f
C279 control_logic_rw_0/delay_chain_0/pinv_11_12/Z control_logic_rw_0/delay_chain_0/pinv_11_9/A 0.14367f
C280 control_logic_rw_0/pand2_1/gnd control_logic_rw_0/pand2_1/pnand2_0_0/nmos_m1_w0_840_sli_dactive_0/a_0_0# 0.01604f
C281 bank_0/port_address_0/hierarchical_decoder_0/and2_dec_15/pinv_0/w_n127_244# bank_0/port_address_0/wordline_driver_array_0/in_0 0.14989f
C282 bank_0/replica_bitcell_array_0/dummy_array_3_0/dummy_cell_1rw_1/a_145_76# bank_0/replica_bitcell_array_0/dummy_array_3_0/dummy_cell_1rw_1/a_76_76# 0.06598f
C283 control_logic_rw_0/delay_chain_0/pinv_11_30/Z control_logic_rw_0/delay_chain_0/pinv_11_31/Z 0.04321f
C284 control_logic_rw_0/pand3_0/C control_logic_rw_0/pdriver_0_0/pinv_7_0/pmos_m11_w1_150_sli_dli_da_p_0/a_678_0# 0.02257f
C285 control_logic_rw_0/delay_chain_0/pinv_11_0/Z control_logic_rw_0/delay_chain_0/pinv_11_4/w_n127_403# 0.19711f
C286 control_logic_rw_0/pand2_1/gnd control_logic_rw_0/pand2_1/pdriver_0/pinv_2_0/nmos_m9_w0_560_sli_dli_da_p_0/a_366_0# 0.01066f
C287 bank_0/replica_bitcell_array_0/replica_column_0/replica_cell_1rw_5/q bank_0/replica_bitcell_array_0/dummy_array_2_0/dummy_cell_1rw_6/qb 0.01651f
C288 control_logic_rw_0/delay_chain_0/pinv_11_10/pmos_m1_w0_840_sli_dli_da_p_0/a_54_0# control_logic_rw_0/delay_chain_0/pinv_11_10/Z 0.0129f
C289 bank_0/replica_bitcell_array_0/dummy_array_3_0/dummy_cell_1rw_15/a_76_76# bank_0/replica_bitcell_array_0/dummy_array_3_0/dummy_cell_1rw_15/a_145_76# 0.06598f
C290 bank_0/replica_bitcell_array_0/dummy_array_0_0/dummy_cell_1rw_0/a_145_76# bank_0/replica_bitcell_array_0/dummy_array_0_0/dummy_cell_1rw_0/qb 0.0163f
C291 bank_0/replica_bitcell_array_0/bitcell_array_0/cell_1rw_19/qb bank_0/replica_bitcell_array_0/replica_column_0/replica_cell_1rw_3/q 0.02064f
C292 control_logic_rw_0/delay_chain_0/pinv_11_8/Z control_logic_rw_0/delay_chain_0/pinv_11_9/w_n127_403# 0.20256f
C293 bank_0/port_address_0/wl_0 bank_0/replica_bitcell_array_0/bitcell_array_0/cell_1rw_31/qb 0.03704f
C294 bank_0/port_address_0/hierarchical_decoder_0/and2_dec_1/pinv_0/w_n127_244# bank_0/port_address_0/wl_15 0.16341f
C295 bank_0/port_address_0/hierarchical_decoder_0/and2_dec_5/pinv_0/pmos_m1_w0_840_sli_dli_da_p_0/a_54_0# bank_0/port_address_0/wordline_driver_array_0/in_10 0.01304f
C296 bank_0/port_address_0/wordline_driver_array_0/in_2 bank_0/wl_en0 0.18688f
C297 bank_0/port_address_0/hierarchical_decoder_0/and2_dec_9/pinv_0/w_n127_244# bank_0/wl_en0 0.29624f
C298 bank_0/replica_bitcell_array_0/bitcell_array_0/cell_1rw_28/qb bank_0/replica_bitcell_array_0/bitcell_array_0/cell_1rw_28/q 0.28699f
C299 bank_0/replica_bitcell_array_0/dummy_array_0/dummy_cell_1rw_1/a_145_76# bank_0/port_address_0/rbl_wl 0.04284f
C300 bank_0/port_address_0/wl_9 bank_0/port_address_0/wl_10 0.13236f
C301 bank_0/port_address_0/hierarchical_decoder_0/hierarchical_predecode2x4_0/pinv_0/Z bank_0/port_address_0/hierarchical_decoder_0/hierarchical_predecode2x4_0/pinv_1/w_n127_244# 0.19953f
C302 control_logic_rw_0/pdriver_0_0/gnd control_logic_rw_0/pdriver_0_0/pinv_6_0/nmos_m4_w0_520_sli_dli_da_p_0/a_288_0# 0.01014f
C303 control_logic_rw_0/pnand2_1_0/nmos_m1_w0_840_sactive_dli_0/a_54_0# control_logic_rw_0/pinv_3_0/A 0.02324f
C304 bank_0/port_address_0/wordline_driver_array_0/in_7 bank_0/wl_en0 0.18688f
C305 control_logic_rw_0/dff_buf_array_0/dff_buf_0_1/pinv_1_0/vdd control_logic_rw_0/pand3_0_0/C 0.1541f
C306 bank_0/replica_bitcell_array_0/dummy_array_0_0/dummy_cell_1rw_0/q bank_0/replica_bitcell_array_0/dummy_array_0_0/dummy_cell_1rw_0/qb 0.28699f
C307 bank_0/replica_bitcell_array_0/dummy_array_3_0/dummy_cell_1rw_7/a_145_76# bank_0/port_address_0/wl_9 0.04184f
C308 bank_0/replica_bitcell_array_0/dummy_array_0/dummy_cell_1rw_0/qb bank_0/port_address_0/rbl_wl 0.03696f
C309 control_logic_rw_0/pand3_0/C control_logic_rw_0/pdriver_1_0/pinv_4_0/pmos_m2_w0_840_sli_dli_da_p_0/a_132_0# 0.01374f
C310 control_logic_rw_0/pand3_0/B control_logic_rw_0/dff_buf_array_0/dff_buf_0_0/pinv_1_0/gnd 0.01442f
C311 row_addr_dff_0/dff_1/net1 addr0[2] 0.08005f
C312 bank_0/port_address_0/hierarchical_decoder_0/predecode_1 bank_0/port_address_0/hierarchical_decoder_0/predecode_2 5.71068f
C313 bank_0/replica_bitcell_array_0/dummy_array_2_0/dummy_cell_1rw_6/qb bank_0/replica_bitcell_array_0/dummy_array_2_0/dummy_cell_1rw_6/q 0.28699f
C314 bank_0/wl_en0 bank_0/port_address_0/wordline_driver_array_0/in_6 0.18688f
C315 bank_0/replica_bitcell_array_0/bitcell_array_0/cell_1rw_14/q bank_0/port_address_0/wl_1 0.04136f
C316 bank_0/port_address_0/hierarchical_decoder_0/predecode_6 bank_0/port_address_0/hierarchical_decoder_0/and2_dec_3/pinv_0/w_n127_244# 0.03094f
C317 bank_0/replica_bitcell_array_0/dummy_array_2_0/dummy_cell_1rw_8/a_76_76# bank_0/replica_bitcell_array_0/dummy_array_2_0/dummy_cell_1rw_8/a_145_76# 0.06598f
C318 bank_0/port_address_0/wl_9 bank_0/replica_bitcell_array_0/dummy_array_2_0/dummy_cell_1rw_7/a_76_76# 0.05228f
C319 control_logic_rw_0/pand3_0/pnand3_0_0/nmos_m1_w0_840_sli_dactive_0/D control_logic_rw_0/pand3_0/gnd 0.01436f
C320 bank_0/port_address_0/wordline_driver_array_0/in_14 bank_0/port_address_0/hierarchical_decoder_0/and2_dec_1/pinv_0/pmos_m1_w0_840_sli_dli_da_p_0/a_54_0# 0.01304f
C321 bank_0/replica_bitcell_array_0/bitcell_array_0/cell_1rw_3/qb bank_0/port_address_0/wl_12 0.03577f
C322 bank_0/replica_bitcell_array_0/dummy_array_2_0/dummy_cell_1rw_17/a_145_76# bank_0/port_address_0/rbl_wl 0.04284f
C323 bank_0/replica_bitcell_array_0/dummy_array_2_0/dummy_cell_1rw_12/qb bank_0/replica_bitcell_array_0/dummy_array_2_0/dummy_cell_1rw_12/q 0.28699f
C324 row_addr_dff_0/dff_1/net2 row_addr_dff_0/dff_3/clk 0.0716f
C325 bank_0/replica_bitcell_array_0/dummy_array_3_0/dummy_cell_1rw_7/a_145_76# bank_0/replica_bitcell_array_0/dummy_array_3_0/dummy_cell_1rw_7/qb 0.0163f
C326 bank_0/replica_bitcell_array_0/bitcell_array_0/cell_1rw_27/qb bank_0/replica_bitcell_array_0/bitcell_array_0/cell_1rw_27/q 0.28699f
C327 control_logic_rw_0/pand3_0/C control_logic_rw_0/pand2_0/pdriver_0/pinv_2_0/pmos_m9_w1_120_sli_dli_da_p_0/a_366_0# 0.02225f
C328 control_logic_rw_0/pand3_0/B control_logic_rw_0/pinv_3_0/vdd 0.08704f
C329 control_logic_rw_0/pand3_0/C control_logic_rw_0/pdriver_1_0/pinv_6_0/pmos_m4_w1_050_sli_dli_da_p_0/a_132_0# 0.02601f
C330 bank_0/replica_bitcell_array_0/dummy_array_2_0/dummy_cell_1rw_1/a_145_76# bank_0/port_address_0/wl_15 0.04284f
C331 bank_0/replica_bitcell_array_0/dummy_array_2_0/dummy_cell_1rw_18/a_76_76# bank_0/replica_bitcell_array_0/dummy_array_2_0/dummy_cell_1rw_18/q 0.01645f
C332 control_logic_rw_0/pand2_1/gnd control_logic_rw_0/pand2_1/A 0.18489f
C333 bank_0/port_address_0/wordline_driver_array_0/in_7 bank_0/port_address_0/wordline_driver_array_0/in_8 0.01362f
C334 control_logic_rw_0/delay_chain_0/pinv_11_41/Z control_logic_rw_0/delay_chain_0/pinv_11_42/Z 0.04321f
C335 bank_0/port_address_0/rbl_wl bank_0/replica_bitcell_array_0/dummy_array_0/dummy_cell_1rw_1/qb 0.03704f
C336 bank_0/replica_bitcell_array_0/dummy_array_3_0/dummy_cell_1rw_4/q bank_0/port_address_0/wl_12 0.04136f
C337 bank_0/replica_bitcell_array_0/dummy_array_0/dummy_cell_1rw_0/qb bank_0/replica_bitcell_array_0/dummy_array_0/dummy_cell_1rw_0/a_145_76# 0.0163f
C338 control_logic_rw_0/delay_chain_0/pinv_11_12/pmos_m1_w0_840_sli_dli_da_p_0/a_54_0# control_logic_rw_0/delay_chain_0/pinv_11_12/Z 0.0129f
C339 bank_0/replica_bitcell_array_0/bitcell_array_0/cell_1rw_5/qb bank_0/replica_bitcell_array_0/bitcell_array_0/cell_1rw_5/q 0.28699f
C340 bank_0/replica_bitcell_array_0/replica_column_0/replica_cell_1rw_3/q bank_0/port_address_0/wl_12 0.04211f
C341 bank_0/replica_bitcell_array_0/bitcell_array_0/cell_1rw_13/q bank_0/replica_bitcell_array_0/dummy_array_3_0/dummy_cell_1rw_14/qb 0.02064f
C342 control_logic_rw_0/dff_buf_array_0/dff_buf_0_1/dff_0/clkb control_logic_rw_0/dff_buf_array_0/dff_buf_0_1/dff_0/net2 0.07662f
C343 control_logic_rw_0/pdriver_0_0/pinv_7_0/nmos_m11_w0_570_sli_dli_da_p_0/a_522_0# control_logic_rw_0/pdriver_0_0/gnd 0.01095f
C344 control_logic_rw_0/pand3_0/B control_logic_rw_0/pnand2_1_0/w_n127_195# 0.09247f
C345 bank_0/replica_bitcell_array_0/dummy_array_2_0/dummy_cell_1rw_13/a_76_76# bank_0/replica_bitcell_array_0/dummy_array_2_0/dummy_cell_1rw_13/q 0.01645f
C346 bank_0/replica_bitcell_array_0/dummy_array_3_0/dummy_cell_1rw_9/a_76_76# bank_0/replica_bitcell_array_0/dummy_array_3_0/dummy_cell_1rw_9/a_145_76# 0.06598f
C347 row_addr_dff_0/dff_3/net2 row_addr_dff_0/dff_3/net3 0.03271f
C348 bank_0/port_address_0/and2_dec_0_0/pinv_0/w_n127_244# bank_0/wl_en0 0.25053f
C349 control_logic_rw_0/pand3_0/C control_logic_rw_0/pdriver_0_0/pinv_7_0/pmos_m11_w1_150_sli_dli_da_p_0/a_444_0# 0.02761f
C350 bank_0/p_en_bar0 control_logic_rw_0/pinv_3_0/A 0.10462f
C351 bank_0/port_address_0/hierarchical_decoder_0/predecode_2 bank_0/port_address_0/hierarchical_decoder_0/and2_dec_9/pinv_0/w_n127_244# 0.02155f
C352 bank_0/replica_bitcell_array_0/bitcell_array_0/cell_1rw_15/qb bank_0/replica_bitcell_array_0/bitcell_array_0/cell_1rw_15/q 0.28699f
C353 control_logic_rw_0/delay_chain_0/pinv_11_1/pmos_m1_w0_840_sli_dli_da_p_0/a_54_0# control_logic_rw_0/delay_chain_0/pinv_11_1/Z 0.0129f
C354 bank_0/port_address_0/wordline_driver_array_0/in_12 bank_0/port_address_0/hierarchical_decoder_0/and2_dec_3/pinv_0/w_n127_244# 0.14989f
C355 control_logic_rw_0/pdriver_0_0/gnd control_logic_rw_0/pdriver_0_0/pinv_7_0/nmos_m11_w0_570_sli_dli_da_p_0/a_366_0# 0.01095f
C356 bank_0/port_address_0/wl_6 bank_0/port_address_0/wl_5 0.13236f
C357 bank_0/replica_bitcell_array_0/dummy_array_2_0/dummy_cell_1rw_10/qb bank_0/port_address_0/wl_6 0.03924f
C358 bank_0/replica_bitcell_array_0/replica_column_0/replica_cell_1rw_13/q bank_0/port_address_0/wl_2 0.04211f
C359 row_addr_dff_0/dff_0/net5 row_addr_dff_0/dff_0/net4 0.13677f
C360 control_logic_rw_0/pand2_0/pdriver_0/pinv_2_0/nmos_m9_w0_560_sli_dli_da_p_0/a_210_0# control_logic_rw_0/pand2_1/gnd 0.01066f
C361 bank_0/port_address_0/hierarchical_decoder_0/predecode_4 bank_0/port_address_0/hierarchical_decoder_0/and2_dec_15/pinv_0/w_n127_244# 0.29931f
C362 bank_0/replica_bitcell_array_0/bitcell_array_0/cell_1rw_17/qb bank_0/replica_bitcell_array_0/bitcell_array_0/cell_1rw_1/q 0.01651f
C363 control_logic_rw_0/pand2_0/pnand2_0_0/pmos_m1_w0_840_sli_dli_0/a_54_0# control_logic_rw_0/pand3_0/C 0.02414f
C364 bank_0/port_address_0/hierarchical_decoder_0/and2_dec_1/pinv_0/w_n127_244# bank_0/port_address_0/wl_14 0.16398f
C365 control_logic_rw_0/pand3_0/C control_logic_rw_0/pdriver_0_0/pinv_4_0/pmos_m2_w0_840_sli_dli_da_p_0/a_0_0# 0.01587f
C366 bank_0/port_address_0/wl_10 bank_0/port_address_0/wordline_driver_array_0/wordline_driver_5/pinv_0/pmos_m1_w0_840_sli_dli_da_p_0/a_54_0# 0.01304f
C367 control_logic_rw_0/pand3_0/C control_logic_rw_0/pand3_0/B 1.22624f
C368 control_logic_rw_0/pinv_3_0/w_n127_195# control_logic_rw_0/pand3_0_0/gnd 0.04344f
C369 control_logic_rw_0/pand3_0/C control_logic_rw_0/pdriver_0_0/pinv_7_0/pmos_m11_w1_150_sli_dli_da_p_0/a_756_0# 0.02684f
C370 control_logic_rw_0/delay_chain_0/pinv_11_20/Z control_logic_rw_0/delay_chain_0/pinv_11_24/Z 0.11884f
C371 control_logic_rw_0/pand2_1/gnd control_logic_rw_0/pand2_1/pdriver_0/pinv_2_0/nmos_m9_w0_560_sli_dli_da_p_0/a_0_0# 0.01105f
C372 bank_0/port_address_0/hierarchical_decoder_0/hierarchical_predecode2x4_1/and2_dec_3/pinv_0/w_n127_244# bank_0/addr0_1 0.12164f
C373 bank_0/replica_bitcell_array_0/dummy_array_0/dummy_cell_1rw_1/qb bank_0/replica_bitcell_array_0/replica_column_0/replica_cell_1rw_16/q 0.02064f
C374 row_addr_dff_0/dff_2/clkb row_addr_dff_0/dff_2/net1 0.1543f
C375 control_logic_rw_0/dff_buf_array_0/dff_buf_0_1/pinv_1_0/vdd control_logic_rw_0/dff_buf_array_0/dff_buf_0_1/pinv_0_0/pmos_m2_w0_840_sli_dli_da_p_0/a_132_0# 0.01602f
C376 bank_0/replica_bitcell_array_0/replica_column_0/replica_cell_1rw_11/q bank_0/replica_bitcell_array_0/dummy_array_2_0/dummy_cell_1rw_12/qb 0.01651f
C377 control_logic_rw_0/dff_buf_array_0/dff_buf_0_1/pinv_1_0/vdd control_logic_rw_0/dff_buf_array_0/dff_buf_0_1/pinv_1_0/pmos_m3_w1_120_sli_dli_da_p_0/a_132_0# 0.02745f
C378 bank_0/port_address_0/hierarchical_decoder_0/predecode_4 bank_0/port_address_0/hierarchical_decoder_0/predecode_0 0.5146f
C379 control_logic_rw_0/pand3_0_0/pnand3_0_0/pmos_m1_w0_840_sli_dli_0/a_0_0# control_logic_rw_0/pand3_0_0/C 0.01432f
C380 bank_0/replica_bitcell_array_0/dummy_array_3_0/dummy_cell_1rw_13/a_76_76# bank_0/port_address_0/wl_3 0.05176f
C381 bank_0/replica_bitcell_array_0/dummy_array_3_0/dummy_cell_1rw_15/qb bank_0/replica_bitcell_array_0/dummy_array_3_0/dummy_cell_1rw_15/q 0.28699f
C382 bank_0/replica_bitcell_array_0/bitcell_array_0/cell_1rw_13/qb bank_0/replica_bitcell_array_0/dummy_array_3_0/dummy_cell_1rw_14/q 0.01651f
C383 bank_0/port_address_0/hierarchical_decoder_0/predecode_3 bank_0/port_address_0/hierarchical_decoder_0/and2_dec_1/pinv_0/w_n127_244# 0.02796f
C384 control_logic_rw_0/pinv_3_0/A control_logic_rw_0/delay_chain_0/pinv_11_2/Z 0.14262f
C385 bank_0/replica_bitcell_array_0/dummy_array_2_0/dummy_cell_1rw_4/qb bank_0/port_address_0/wl_12 0.03924f
C386 bank_0/port_address_0/hierarchical_decoder_0/and2_dec_11/pinv_0/w_n127_244# bank_0/port_address_0/wl_5 0.16341f
C387 bank_0/port_address_0/hierarchical_decoder_0/predecode_6 bank_0/port_address_0/hierarchical_decoder_0/and2_dec_11/pinv_0/w_n127_244# 0.02963f
C388 row_addr_dff_0/dff_0/clkb bank_0/addr0_3 0.0198f
C389 bank_0/port_address_0/hierarchical_decoder_0/hierarchical_predecode2x4_0/and2_dec_3/pinv_0/pmos_m1_w0_840_sli_dli_da_p_0/a_54_0# bank_0/port_address_0/hierarchical_decoder_0/predecode_4 0.01431f
C390 bank_0/replica_bitcell_array_0/dummy_array_3_0/dummy_cell_1rw_14/a_76_76# bank_0/replica_bitcell_array_0/dummy_array_3_0/dummy_cell_1rw_14/q 0.01645f
C391 control_logic_rw_0/delay_chain_0/pinv_11_20/Z control_logic_rw_0/delay_chain_0/pinv_11_21/Z 0.04321f
C392 bank_0/replica_bitcell_array_0/dummy_array_3_0/dummy_cell_1rw_11/a_76_76# bank_0/port_address_0/wl_5 0.05176f
C393 bank_0/replica_bitcell_array_0/dummy_array_3_0/dummy_cell_1rw_13/q bank_0/replica_bitcell_array_0/dummy_array_3_0/dummy_cell_1rw_13/a_76_76# 0.01645f
C394 data_dff_0/dff_1/net1 din0[0] 0.0923f
C395 bank_0/replica_bitcell_array_0/dummy_array_3_0/dummy_cell_1rw_16/a_76_76# bank_0/replica_bitcell_array_0/dummy_array_3_0/dummy_cell_1rw_16/q 0.01645f
C396 control_logic_rw_0/delay_chain_0/pinv_11_38/Z control_logic_rw_0/delay_chain_0/pinv_11_38/pmos_m1_w0_840_sli_dli_da_p_0/a_54_0# 0.0129f
C397 control_logic_rw_0/pand3_0/C control_logic_rw_0/pand2_0/pdriver_0/pinv_2_0/pmos_m9_w1_120_sli_dli_da_p_0/a_678_0# 0.01371f
C398 bank_0/port_address_0/hierarchical_decoder_0/hierarchical_predecode2x4_0/pinv_1/Z bank_0/port_address_0/hierarchical_decoder_0/hierarchical_predecode2x4_0/pinv_0/Z 1.67081f
C399 control_logic_rw_0/pnand2_1_0/w_n127_195# control_logic_rw_0/pdriver_4_0/pinv_8_0/A 0.15114f
C400 control_logic_rw_0/delay_chain_0/pinv_11_11/Z control_logic_rw_0/delay_chain_0/pinv_11_9/A 0.14303f
C401 bank_0/port_address_0/hierarchical_decoder_0/and2_dec_0/pinv_0/pmos_m1_w0_840_sli_dli_da_p_0/a_54_0# bank_0/port_address_0/wordline_driver_array_0/in_15 0.01304f
C402 bank_0/port_address_0/hierarchical_decoder_0/hierarchical_predecode2x4_0/pinv_0/Z bank_0/addr0_3 0.21555f
C403 control_logic_rw_0/pdriver_0_0/gnd control_logic_rw_0/pdriver_0_0/pinv_7_0/nmos_m11_w0_570_sli_dli_da_p_0/a_678_0# 0.01095f
C404 bank_0/port_address_0/hierarchical_decoder_0/and2_dec_3/pinv_0/w_n127_244# bank_0/port_address_0/wl_13 0.16341f
C405 bank_0/replica_bitcell_array_0/dummy_array_2_0/dummy_cell_1rw_8/qb bank_0/replica_bitcell_array_0/dummy_array_2_0/dummy_cell_1rw_8/q 0.28699f
C406 bank_0/port_address_0/hierarchical_decoder_0/predecode_1 bank_0/port_address_0/hierarchical_decoder_0/predecode_5 0.45309f
C407 row_addr_dff_0/dff_0/net3 row_addr_dff_0/dff_0/net4 0.04611f
C408 control_logic_rw_0/dff_buf_array_0/dff_buf_0_1/dff_0/net4 control_logic_rw_0/dff_buf_array_0/dff_buf_0_1/dff_0/net3 0.04611f
C409 control_logic_rw_0/dff_buf_array_0/dff_buf_0_1/dff_0/net1 control_logic_rw_0/dff_buf_array_0/dff_buf_0_1/dff_0/net2 0.12728f
C410 bank_0/port_address_0/hierarchical_decoder_0/predecode_1 bank_0/port_address_0/hierarchical_decoder_0/predecode_7 0.45915f
C411 bank_0/replica_bitcell_array_0/dummy_array_3_0/dummy_cell_1rw_4/a_76_76# bank_0/port_address_0/wl_12 0.05176f
C412 control_logic_rw_0/pand3_0_0/pnand3_0_0/pmos_m1_w0_840_sli_dli_1/a_0_0# control_logic_rw_0/pand3_0_0/C 0.0204f
C413 control_logic_rw_0/delay_chain_0/pinv_11_39/Z control_logic_rw_0/delay_chain_0/pinv_11_34/Z 0.43969f
C414 control_logic_rw_0/pdriver_0_0/gnd control_logic_rw_0/pinv_3_1/w_n127_195# 0.06324f
C415 bank_0/replica_bitcell_array_0/dummy_array_2_0/dummy_cell_1rw_3/a_145_76# bank_0/port_address_0/wl_13 0.04284f
C416 bank_0/replica_bitcell_array_0/dummy_array_3_0/dummy_cell_1rw_2/qb bank_0/port_address_0/wl_14 0.03696f
C417 bank_0/replica_bitcell_array_0/bitcell_array_0/cell_1rw_6/qb bank_0/port_address_0/wl_9 0.03696f
C418 data_dff_0/dff_1/clkb data_dff_0/dff_1/net3 0.14179f
C419 bank_0/replica_bitcell_array_0/dummy_array_2_0/dummy_cell_1rw_9/a_145_76# bank_0/port_address_0/wl_7 0.04284f
C420 row_addr_dff_0/dff_3/net3 row_addr_dff_0/dff_3/clk 0.09344f
C421 bank_0/replica_bitcell_array_0/bitcell_array_0/cell_1rw_19/q bank_0/replica_bitcell_array_0/bitcell_array_0/cell_1rw_3/qb 0.02064f
C422 bank_0/port_address_0/wordline_driver_array_0/in_9 bank_0/port_address_0/hierarchical_decoder_0/and2_dec_7/pinv_0/w_n127_244# 0.14946f
C423 bank_0/port_address_0/wl_2 bank_0/port_address_0/wl_3 0.03867f
C424 bank_0/port_address_0/wordline_driver_array_0/wordline_driver_0/pinv_0/pmos_m1_w0_840_sli_dli_da_p_0/a_54_0# bank_0/port_address_0/wl_15 0.01304f
C425 bank_0/replica_bitcell_array_0/dummy_array_2_0/dummy_cell_1rw_14/a_76_76# bank_0/replica_bitcell_array_0/dummy_array_2_0/dummy_cell_1rw_14/q 0.01645f
C426 control_logic_rw_0/pand3_0_0/C control_logic_rw_0/dff_buf_array_0/dff_buf_0_0/pinv_1_0/gnd 0.24675f
C427 bank_0/replica_bitcell_array_0/bitcell_array_0/cell_1rw_16/qb bank_0/replica_bitcell_array_0/bitcell_array_0/cell_1rw_0/q 0.01651f
C428 bank_0/replica_bitcell_array_0/bitcell_array_0/cell_1rw_16/q bank_0/replica_bitcell_array_0/bitcell_array_0/cell_1rw_0/qb 0.02064f
C429 control_logic_rw_0/pand3_0/C control_logic_rw_0/dff_buf_array_0/dff_buf_0_1/pinv_0_0/pmos_m2_w0_840_sli_dli_da_p_0/a_54_0# 0.02309f
C430 bank_0/replica_bitcell_array_0/dummy_array_3_0/dummy_cell_1rw_12/a_145_76# bank_0/port_address_0/wl_4 0.04184f
C431 control_logic_rw_0/dff_buf_array_0/dff_buf_0_1/pinv_1_0/vdd control_logic_rw_0/dff_buf_array_0/dff_buf_0_0/pinv_1_0/gnd 0.0233f
C432 bank_0/port_address_0/wordline_driver_array_0/in_6 bank_0/port_address_0/wordline_driver_array_0/in_5 0.01362f
C433 bank_0/port_address_0/wordline_driver_array_0/in_0 bank_0/wl_en0 0.20766f
C434 bank_0/port_address_0/wl_0 bank_0/replica_bitcell_array_0/bitcell_array_0/cell_1rw_31/q 0.04155f
C435 bank_0/port_address_0/wl_11 bank_0/replica_bitcell_array_0/dummy_array_3_0/dummy_cell_1rw_5/a_145_76# 0.04184f
C436 control_logic_rw_0/pdriver_0_0/pinv_6_0/A control_logic_rw_0/pdriver_0_0/pinv_7_0/A 0.21971f
C437 bank_0/replica_bitcell_array_0/replica_column_0/dummy_cell_1rw_0/qb bank_0/replica_bitcell_array_0/replica_column_0/dummy_cell_1rw_0/q 0.28699f
C438 control_logic_rw_0/pand3_0_0/C control_logic_rw_0/pinv_3_0/vdd 0.29156f
C439 bank_0/addr0_3 row_addr_dff_0/dff_3/clk 0.02069f
C440 bank_0/replica_bitcell_array_0/dummy_array_3_0/dummy_cell_1rw_2/a_76_76# bank_0/port_address_0/wl_14 0.05176f
C441 control_logic_rw_0/pand3_0/C control_logic_rw_0/pdriver_1_0/pinv_6_0/pmos_m4_w1_050_sli_dli_da_p_0/a_210_0# 0.02157f
C442 control_logic_rw_0/dff_buf_array_0/dff_buf_0_1/pinv_1_0/w_n127_195# control_logic_rw_0/dff_buf_array_0/dout_0 0.15692f
C443 row_addr_dff_0/dff_1/net1 row_addr_dff_0/dff_3/clk 0.31285f
C444 control_logic_rw_0/delay_chain_0/pinv_11_5/Z control_logic_rw_0/delay_chain_0/pinv_11_9/w_n127_403# 0.19711f
C445 bank_0/port_address_0/hierarchical_decoder_0/and2_dec_9/pinv_0/w_n127_244# bank_0/port_address_0/hierarchical_decoder_0/predecode_5 0.32887f
C446 bank_0/port_address_0/wordline_driver_array_0/in_13 bank_0/port_address_0/hierarchical_decoder_0/and2_dec_3/pinv_0/w_n127_244# 0.14946f
C447 bank_0/port_address_0/hierarchical_decoder_0/and2_dec_9/pinv_0/w_n127_244# bank_0/port_address_0/hierarchical_decoder_0/predecode_7 0.14917f
C448 bank_0/replica_bitcell_array_0/dummy_array_2_0/dummy_cell_1rw_6/qb bank_0/port_address_0/wl_10 0.03805f
C449 control_logic_rw_0/pand3_0/C control_logic_rw_0/pand2_1/pdriver_0/pinv_2_0/nmos_m9_w0_560_sli_dli_da_p_0/a_444_0# 0.01112f
C450 bank_0/replica_bitcell_array_0/dummy_array_2_0/dummy_cell_1rw_2/a_145_76# bank_0/replica_bitcell_array_0/dummy_array_2_0/dummy_cell_1rw_2/qb 0.0163f
C451 control_logic_rw_0/pand3_0/C control_logic_rw_0/pand2_0/pnand2_0_0/pmos_m1_w0_840_sli_dli_0/a_0_0# 0.02303f
C452 bank_0/port_address_0/wl_10 bank_0/replica_bitcell_array_0/bitcell_array_0/cell_1rw_5/q 0.04136f
C453 bank_0/replica_bitcell_array_0/dummy_array_3_0/dummy_cell_1rw_8/a_76_76# bank_0/port_address_0/wl_8 0.05176f
C454 bank_0/replica_bitcell_array_0/replica_column_0/dummy_cell_1rw_0/qb bank_0/replica_bitcell_array_0/dummy_array_0_0/dummy_cell_1rw_1/q 0.01651f
C455 bank_0/replica_bitcell_array_0/dummy_array_0/dummy_cell_1rw_1/a_145_76# bank_0/replica_bitcell_array_0/dummy_array_0/dummy_cell_1rw_1/qb 0.0163f
C456 bank_0/replica_bitcell_array_0/dummy_array_2_0/dummy_cell_1rw_12/qb bank_0/port_address_0/wl_4 0.03924f
C457 control_logic_rw_0/pand2_0/Z control_logic_rw_0/pinv_3_0/A 0.51301f
C458 row_addr_dff_0/dff_2/clkb row_addr_dff_0/dff_1/clkb 0.01308f
C459 bank_0/replica_bitcell_array_0/dummy_array_0/dummy_cell_1rw_0/a_76_76# bank_0/port_address_0/rbl_wl 0.05224f
C460 control_logic_rw_0/pand3_0_0/pnand3_0_0/nmos_m1_w0_840_sli_dactive_0/a_0_0# control_logic_rw_0/pand3_0_0/gnd 0.01544f
C461 control_logic_rw_0/pand3_0/C control_logic_rw_0/pdriver_0_0/gnd 0.03463f
C462 control_logic_rw_0/pand3_0/C control_logic_rw_0/pand2_0/pnand2_0_0/pmos_m1_w0_840_sli_dli_1/a_0_0# 0.02124f
C463 control_logic_rw_0/delay_chain_0/pinv_11_29/Z control_logic_rw_0/delay_chain_0/pinv_11_26/Z 0.14222f
C464 control_logic_rw_0/delay_chain_0/pinv_11_42/Z control_logic_rw_0/delay_chain_0/pinv_11_43/Z 0.04321f
C465 bank_0/replica_bitcell_array_0/bitcell_array_0/cell_1rw_1/qb bank_0/port_address_0/wl_14 0.03696f
C466 row_addr_dff_0/dff_2/clkb row_addr_dff_0/dff_2/net3 0.14179f
C467 bank_0/port_address_0/rbl_wl bank_0/replica_bitcell_array_0/dummy_array_0/dummy_cell_1rw_1/q 0.04155f
C468 bank_0/replica_bitcell_array_0/dummy_array_3_0/dummy_cell_1rw_11/q bank_0/replica_bitcell_array_0/dummy_array_3_0/dummy_cell_1rw_11/qb 0.28699f
C469 bank_0/port_address_0/hierarchical_decoder_0/and2_dec_5/pinv_0/w_n127_244# bank_0/port_address_0/wl_10 0.16398f
C470 control_logic_rw_0/pand3_0/C control_logic_rw_0/pdriver_1_0/pinv_6_0/pmos_m4_w1_050_sli_dli_da_p_0/a_288_0# 0.01681f
C471 bank_0/replica_bitcell_array_0/bitcell_array_0/cell_1rw_14/qb bank_0/replica_bitcell_array_0/bitcell_array_0/cell_1rw_14/q 0.28699f
C472 control_logic_rw_0/dff_buf_array_0/dff_buf_0_1/dff_0/clkb control_logic_rw_0/dff_buf_array_0/dff_buf_0_1/dff_0/net3 0.14179f
C473 bank_0/addr0_2 bank_0/addr0_1 4.60187f
C474 bank_0/addr0_2 bank_0/port_address_0/hierarchical_decoder_0/hierarchical_predecode2x4_0/and2_dec_1/pinv_0/w_n127_244# 0.0212f
C475 bank_0/replica_bitcell_array_0/dummy_array_2_0/dummy_cell_1rw_13/a_76_76# bank_0/port_address_0/wl_3 0.05228f
C476 control_logic_rw_0/delay_chain_0/pinv_11_35/Z control_logic_rw_0/delay_chain_0/pinv_11_39/Z 0.11884f
C477 control_logic_rw_0/delay_chain_0/pinv_11_10/Z control_logic_rw_0/pinv_3_0/A 0.04231f
C478 bank_0/port_address_0/wordline_driver_array_0/in_12 bank_0/port_address_0/hierarchical_decoder_0/and2_dec_3/pinv_0/pmos_m1_w0_840_sli_dli_da_p_0/a_54_0# 0.01304f
C479 control_logic_rw_0/pand3_0/C control_logic_rw_0/pand3_0_0/C 3.08105f
C480 control_logic_rw_0/pand3_0/C control_logic_rw_0/pand2_1/pnand2_0_0/nmos_m1_w0_840_sactive_dli_0/a_54_0# 0.01751f
C481 control_logic_rw_0/pand3_0/C control_logic_rw_0/dff_buf_array_0/dff_buf_0_1/pinv_1_0/vdd 0.63232f
C482 bank_0/wl_en0 control_logic_rw_0/pdriver_1_0/pinv_6_0/nmos_m4_w0_520_sli_dli_da_p_0/a_132_0# 0.01232f
C483 bank_0/replica_bitcell_array_0/dummy_array_0/dummy_cell_1rw_0/a_76_76# bank_0/replica_bitcell_array_0/dummy_array_0/dummy_cell_1rw_0/a_145_76# 0.06598f
C484 bank_0/port_address_0/wordline_driver_array_0/in_3 bank_0/port_address_0/wordline_driver_array_0/in_4 0.01362f
C485 bank_0/replica_bitcell_array_0/dummy_array_2_0/dummy_cell_1rw_16/a_76_76# bank_0/replica_bitcell_array_0/dummy_array_2_0/dummy_cell_1rw_16/q 0.01645f
C486 bank_0/replica_bitcell_array_0/dummy_array_1_0/dummy_cell_1rw_0/a_76_76# bank_0/replica_bitcell_array_0/dummy_array_1_0/dummy_cell_1rw_0/q 0.01645f
C487 control_logic_rw_0/delay_chain_0/pinv_11_9/w_n127_403# control_logic_rw_0/delay_chain_0/pinv_11_9/A 1.16826f
C488 bank_0/replica_bitcell_array_0/replica_column_0/replica_cell_1rw_2/q bank_0/replica_bitcell_array_0/dummy_array_2_0/dummy_cell_1rw_3/qb 0.01651f
C489 control_logic_rw_0/pand3_0/pdriver_2_0/pinv_9_0/nmos_m7_w0_600_sli_dli_da_p_0/a_288_0# control_logic_rw_0/pand3_0/gnd 0.01891f
C490 control_logic_rw_0/pand3_0/C control_logic_rw_0/dff_buf_array_0/dff_buf_0_1/pinv_0_0/nmos_m2_w0_420_sli_dli_da_p_0/a_54_0# 0.01142f
C491 bank_0/port_address_0/hierarchical_decoder_0/predecode_0 bank_0/port_address_0/hierarchical_decoder_0/hierarchical_predecode2x4_0/and2_dec_3/pinv_0/w_n127_244# 0.15028f
C492 bank_0/port_address_0/wordline_driver_array_0/wordline_driver_8/pinv_0/pmos_m1_w0_840_sli_dli_da_p_0/a_54_0# bank_0/port_address_0/wl_7 0.01304f
C493 control_logic_rw_0/pdriver_0_0/pinv_6_0/pmos_m4_w1_050_sli_dli_da_p_0/a_132_0# control_logic_rw_0/pdriver_0_0/pinv_7_0/A 0.02183f
C494 bank_0/replica_bitcell_array_0/dummy_array_2_0/dummy_cell_1rw_10/q bank_0/port_address_0/wl_6 0.04741f
C495 control_logic_rw_0/pand3_0/C control_logic_rw_0/pand2_1/pdriver_0/pinv_2_0/pmos_m9_w1_120_sli_dli_da_p_0/a_522_0# 0.05932f
C496 control_logic_rw_0/pand3_0/C control_logic_rw_0/pdriver_0_0/pinv_4_0/pmos_m2_w0_840_sli_dli_da_p_0/a_54_0# 0.02493f
C497 row_addr_dff_0/dff_2/clkb row_addr_dff_0/dff_2/net2 0.07662f
C498 control_logic_rw_0/pand2_0/pdriver_0/pinv_2_0/nmos_m9_w0_560_sli_dli_da_p_0/a_600_0# control_logic_rw_0/pand2_1/gnd 0.01796f
C499 bank_0/replica_bitcell_array_0/dummy_array_2_0/dummy_cell_1rw_0/a_76_76# bank_0/replica_bitcell_array_0/dummy_array_2_0/dummy_cell_1rw_0/q 0.01645f
C500 control_logic_rw_0/pdriver_0_0/pinv_7_0/nmos_m11_w0_570_sli_dli_da_p_0/a_756_0# control_logic_rw_0/pdriver_0_0/gnd 0.01784f
C501 control_logic_rw_0/pdriver_1_0/pinv_6_0/nmos_m4_w0_520_sli_dli_da_p_0/a_132_0# control_logic_rw_0/pand3_0/gnd 0.01687f
C502 control_logic_rw_0/pdriver_1_0/w_n127_195# control_logic_rw_0/pdriver_1_0/pinv_6_0/A 0.20256f
C503 control_logic_rw_0/delay_chain_0/pinv_11_29/Z control_logic_rw_0/delay_chain_0/pinv_11_29/pmos_m1_w0_840_sli_dli_da_p_0/a_54_0# 0.01414f
C504 bank_0/replica_bitcell_array_0/dummy_array_3_0/dummy_cell_1rw_18/a_76_76# bank_0/replica_bitcell_array_0/dummy_array_3_0/dummy_cell_1rw_18/a_145_76# 0.06598f
C505 bank_0/replica_bitcell_array_0/bitcell_array_0/cell_1rw_13/qb bank_0/replica_bitcell_array_0/bitcell_array_0/cell_1rw_13/q 0.28699f
C506 data_dff_0/dff_0/net3 data_dff_0/dff_0/net1 0.14299f
C507 bank_0/port_address_0/wl_11 bank_0/port_address_0/wl_12 0.13236f
C508 bank_0/port_address_0/hierarchical_decoder_0/hierarchical_predecode2x4_1/pinv_1/w_n127_244# bank_0/port_address_0/hierarchical_decoder_0/hierarchical_predecode2x4_1/pinv_1/Z 0.41826f
C509 bank_0/replica_bitcell_array_0/bitcell_array_0/cell_1rw_28/qb bank_0/replica_bitcell_array_0/replica_column_0/replica_cell_1rw_12/q 0.02064f
C510 bank_0/replica_bitcell_array_0/dummy_array_2_0/dummy_cell_1rw_10/a_145_76# bank_0/replica_bitcell_array_0/dummy_array_2_0/dummy_cell_1rw_10/qb 0.0163f
C511 bank_0/port_address_0/wordline_driver_array_0/wordline_driver_9/pinv_0/pmos_m1_w0_840_sli_dli_da_p_0/a_54_0# bank_0/port_address_0/wl_6 0.01304f
C512 bank_0/replica_bitcell_array_0/dummy_array_3_0/dummy_cell_1rw_12/qb bank_0/replica_bitcell_array_0/bitcell_array_0/cell_1rw_11/q 0.02064f
C513 bank_0/port_address_0/hierarchical_decoder_0/predecode_6 bank_0/port_address_0/hierarchical_decoder_0/hierarchical_predecode2x4_0/and2_dec_1/pinv_0/pmos_m1_w0_840_sli_dli_da_p_0/a_54_0# 0.01459f
C514 bank_0/replica_bitcell_array_0/dummy_array_3_0/dummy_cell_1rw_1/a_145_76# bank_0/replica_bitcell_array_0/dummy_array_3_0/dummy_cell_1rw_1/qb 0.0163f
C515 bank_0/port_address_0/wl_1 bank_0/replica_bitcell_array_0/dummy_array_3_0/dummy_cell_1rw_15/a_76_76# 0.05176f
C516 control_logic_rw_0/delay_chain_0/pinv_11_20/pmos_m1_w0_840_sli_dli_da_p_0/a_54_0# control_logic_rw_0/delay_chain_0/pinv_11_20/Z 0.0129f
C517 control_logic_rw_0/pdriver_0_0/pinv_5_0/Z control_logic_rw_0/pand2_1/A 0.01268f
C518 bank_0/port_address_0/hierarchical_decoder_0/predecode_4 bank_0/wl_en0 0.01162f
C519 control_logic_rw_0/delay_chain_0/pinv_11_1/Z control_logic_rw_0/pinv_3_0/A 0.14475f
C520 bank_0/replica_bitcell_array_0/dummy_array_3_0/dummy_cell_1rw_10/q bank_0/replica_bitcell_array_0/bitcell_array_0/cell_1rw_9/qb 0.01651f
C521 web0 control_logic_rw_0/dff_buf_array_0/dff_buf_0_0/dff_0/net1 0.07965f
C522 control_logic_rw_0/pand3_0_0/gnd control_logic_rw_0/pinv_3_0/A 0.04442f
C523 control_logic_rw_0/pand3_0_0/pdriver_3_0/pinv_10_0/pmos_m2_w0_840_sli_dli_da_p_0/a_132_0# control_logic_rw_0/pinv_3_0/vdd 0.01602f
C524 control_logic_rw_0/delay_chain_0/pinv_11_6/Z control_logic_rw_0/delay_chain_0/pinv_11_7/Z 0.04321f
C525 control_logic_rw_0/dff_buf_array_0/dff_buf_0_1/pinv_1_0/vdd control_logic_rw_0/dff_buf_array_0/dff_buf_0_1/pinv_1_0/pmos_m3_w1_120_sli_dli_da_p_0/a_210_0# 0.01281f
C526 control_logic_rw_0/pand2_1/gnd control_logic_rw_0/pand2_0/pdriver_0/pinv_2_0/nmos_m9_w0_560_sli_dli_da_p_0/a_444_0# 0.01788f
C527 bank_0/replica_bitcell_array_0/dummy_array_1_0/dummy_cell_1rw_0/a_145_76# bank_0/replica_bitcell_array_0/dummy_array_1_0/dummy_cell_1rw_0/qb 0.0163f
C528 bank_0/port_address_0/hierarchical_decoder_0/predecode_1 bank_0/port_address_0/hierarchical_decoder_0/and2_dec_7/pinv_0/w_n127_244# 0.0212f
C529 control_logic_rw_0/pand3_0/C control_logic_rw_0/pdriver_1_0/pinv_6_0/A 0.18327f
C530 control_logic_rw_0/pand3_0_0/pdriver_3_0/pinv_10_0/pmos_m2_w0_840_sli_dli_da_p_0/a_54_0# control_logic_rw_0/pinv_3_0/vdd 0.01857f
C531 bank_0/port_address_0/wordline_driver_array_0/in_11 bank_0/wl_en0 0.18688f
C532 bank_0/port_address_0/wl_9 bank_0/port_address_0/wordline_driver_array_0/wordline_driver_6/pinv_0/pmos_m1_w0_840_sli_dli_da_p_0/a_54_0# 0.01304f
C533 bank_0/port_address_0/hierarchical_decoder_0/hierarchical_predecode2x4_1/pinv_0/Z bank_0/addr0_1 0.21541f
C534 control_logic_rw_0/delay_chain_0/pinv_11_5/pmos_m1_w0_840_sli_dli_da_p_0/a_54_0# control_logic_rw_0/delay_chain_0/pinv_11_5/Z 0.0129f
C535 bank_0/replica_bitcell_array_0/bitcell_array_0/cell_1rw_12/qb bank_0/replica_bitcell_array_0/bitcell_array_0/cell_1rw_12/q 0.28699f
C536 bank_0/replica_bitcell_array_0/dummy_array_3_0/dummy_cell_1rw_4/a_76_76# bank_0/replica_bitcell_array_0/dummy_array_3_0/dummy_cell_1rw_4/a_145_76# 0.06598f
C537 bank_0/replica_bitcell_array_0/dummy_array_3_0/dummy_cell_1rw_9/a_145_76# bank_0/replica_bitcell_array_0/dummy_array_3_0/dummy_cell_1rw_9/qb 0.0163f
C538 control_logic_rw_0/pand3_0_0/pnand3_0_0/pmos_m1_w0_840_sli_dli_0/a_0_0# control_logic_rw_0/pinv_3_0/vdd 0.01484f
C539 control_logic_rw_0/pand3_0/pnand3_0_0/nmos_m1_w0_840_sli_dactive_0/a_0_0# control_logic_rw_0/pand3_0/gnd 0.01544f
C540 bank_0/replica_bitcell_array_0/bitcell_array_0/cell_1rw_29/qb bank_0/port_address_0/wl_2 0.03704f
C541 addr0[2] addr0[3] 0.98587f
C542 bank_0/replica_bitcell_array_0/dummy_array_3_0/dummy_cell_1rw_12/a_76_76# bank_0/port_address_0/wl_4 0.05176f
C543 control_logic_rw_0/dff_buf_array_0/dff_buf_0_1/dff_0/Q control_logic_rw_0/dff_buf_array_0/dff_buf_0_0/dff_0/Q 0.12486f
C544 control_logic_rw_0/pand3_0/C control_logic_rw_0/pdriver_1_0/pinv_6_0/pmos_m4_w1_050_sli_dli_da_p_0/a_0_0# 0.01757f
C545 bank_0/replica_bitcell_array_0/dummy_array_2_0/dummy_cell_1rw_4/q bank_0/port_address_0/wl_12 0.04741f
C546 control_logic_rw_0/pand3_0/gnd control_logic_rw_0/pinv_3_0/A 0.02258f
C547 control_logic_rw_0/pand3_0/pdriver_2_0/pinv_9_0/nmos_m7_w0_600_sli_dli_da_p_0/a_132_0# control_logic_rw_0/pand3_0/gnd 0.01894f
C548 row_addr_dff_0/dff_2/clkb row_addr_dff_0/dff_2/net5 0.03696f
C549 bank_0/port_address_0/hierarchical_decoder_0/predecode_0 bank_0/port_address_0/hierarchical_decoder_0/predecode_3 0.49995f
C550 bank_0/port_address_0/wl_7 bank_0/replica_bitcell_array_0/replica_column_0/replica_cell_1rw_8/q 0.04211f
C551 bank_0/replica_bitcell_array_0/replica_column_0/replica_cell_1rw_4/q bank_0/replica_bitcell_array_0/bitcell_array_0/cell_1rw_20/qb 0.02064f
C552 bank_0/replica_bitcell_array_0/dummy_array_2_0/dummy_cell_1rw_4/a_145_76# bank_0/replica_bitcell_array_0/dummy_array_2_0/dummy_cell_1rw_4/qb 0.0163f
C553 bank_0/port_address_0/wl_14 bank_0/replica_bitcell_array_0/dummy_array_2_0/dummy_cell_1rw_2/a_76_76# 0.05228f
C554 bank_0/port_address_0/wl_1 bank_0/replica_bitcell_array_0/dummy_array_2_0/dummy_cell_1rw_15/qb 0.03923f
C555 control_logic_rw_0/delay_chain_0/pinv_11_4/pmos_m1_w0_840_sli_dli_da_p_0/a_54_0# control_logic_rw_0/pinv_3_0/A 0.0141f
C556 control_logic_rw_0/delay_chain_0/pinv_11_41/pmos_m1_w0_840_sli_dli_da_p_0/a_54_0# control_logic_rw_0/delay_chain_0/pinv_11_41/Z 0.0129f
C557 control_logic_rw_0/pdriver_0_0/gnd clk0 0.04984f
C558 bank_0/port_address_0/wl_8 bank_0/port_address_0/wl_7 0.13236f
C559 bank_0/replica_bitcell_array_0/dummy_array_2_0/dummy_cell_1rw_8/qb bank_0/port_address_0/wl_8 0.03924f
C560 control_logic_rw_0/pand3_0/C control_logic_rw_0/pdriver_0_0/pinv_7_0/pmos_m11_w1_150_sli_dli_da_p_0/a_54_0# 0.02357f
C561 control_logic_rw_0/pand3_0_0/pnand3_0_0/pmos_m1_w0_840_sli_dli_1/a_0_0# control_logic_rw_0/pinv_3_0/vdd 0.01072f
C562 control_logic_rw_0/dff_buf_array_0/dff_buf_0_1/dff_0/net1 control_logic_rw_0/dff_buf_array_0/dff_buf_0_1/dff_0/net3 0.14299f
C563 control_logic_rw_0/pand3_0/C control_logic_rw_0/pand2_1/pnand2_0_0/pmos_m1_w0_840_sli_dli_0/a_0_0# 0.02416f
C564 bank_0/replica_bitcell_array_0/bitcell_array_0/cell_1rw_6/qb bank_0/replica_bitcell_array_0/bitcell_array_0/cell_1rw_6/q 0.28699f
C565 control_logic_rw_0/delay_chain_0/pinv_11_20/Z control_logic_rw_0/delay_chain_0/pinv_11_24/w_n127_403# 0.19711f
C566 bank_0/port_address_0/hierarchical_decoder_0/predecode_4 bank_0/port_address_0/hierarchical_decoder_0/predecode_2 0.46735f
C567 data_dff_0/dff_1/clkb data_dff_0/dff_1/net1 0.1543f
C568 bank_0/replica_bitcell_array_0/dummy_array_2_0/dummy_cell_1rw_5/a_76_76# bank_0/replica_bitcell_array_0/dummy_array_2_0/dummy_cell_1rw_5/a_145_76# 0.06598f
C569 control_logic_rw_0/pand2_0/Z control_logic_rw_0/pand2_1/gnd 0.50107f
C570 control_logic_rw_0/dff_buf_array_0/dff_buf_0_1/pinv_1_0/w_n127_195# control_logic_rw_0/dff_buf_array_0/dff_buf_0_1/dff_0/Q 0.13968f
C571 control_logic_rw_0/pand2_1/gnd control_logic_rw_0/pand2_1/pnand2_0_0/nmos_m1_w0_840_sli_dactive_0/D 0.01486f
C572 bank_0/replica_bitcell_array_0/dummy_array_0/dummy_cell_1rw_0/q bank_0/port_address_0/rbl_wl 0.04136f
C573 control_logic_rw_0/delay_chain_0/pinv_11_4/w_n127_403# control_logic_rw_0/delay_chain_0/pinv_11_3/Z 0.20256f
C574 bank_0/replica_bitcell_array_0/dummy_array_2_0/dummy_cell_1rw_14/a_76_76# bank_0/port_address_0/wl_2 0.05228f
C575 bank_0/replica_bitcell_array_0/replica_column_0/replica_cell_1rw_5/q bank_0/port_address_0/wl_10 0.04085f
C576 control_logic_rw_0/dff_buf_array_0/dff_buf_0_1/pinv_1_0/nmos_m3_w0_560_sli_dli_da_p_0/a_0_0# control_logic_rw_0/dff_buf_array_0/dff_buf_0_1/pinv_1_0/gnd 0.01131f
C577 control_logic_rw_0/delay_chain_0/pinv_11_13/Z control_logic_rw_0/delay_chain_0/pinv_11_12/Z 0.04321f
C578 bank_0/replica_bitcell_array_0/bitcell_array_0/cell_1rw_6/qb bank_0/replica_bitcell_array_0/dummy_array_3_0/dummy_cell_1rw_7/q 0.01651f
C579 control_logic_rw_0/delay_chain_0/pinv_11_24/pmos_m1_w0_840_sli_dli_da_p_0/a_54_0# control_logic_rw_0/delay_chain_0/pinv_11_24/Z 0.01702f
C580 control_logic_rw_0/delay_chain_0/pinv_11_19/Z control_logic_rw_0/delay_chain_0/pinv_11_24/Z 0.36079f
C581 control_logic_rw_0/delay_chain_0/pinv_11_19/Z control_logic_rw_0/delay_chain_0/pinv_11_9/A 0.4357f
C582 control_logic_rw_0/dff_buf_array_0/dff_buf_0_0/dff_0/net3 control_logic_rw_0/dff_buf_array_0/dff_buf_0_0/dff_0/net2 0.03271f
C583 bank_0/replica_bitcell_array_0/dummy_array_0_0/dummy_cell_1rw_1/qb bank_0/replica_bitcell_array_0/dummy_array_0_0/dummy_cell_1rw_1/a_145_76# 0.0163f
C584 bank_0/port_address_0/hierarchical_decoder_0/hierarchical_predecode2x4_0/pinv_0/Z bank_0/port_address_0/hierarchical_decoder_0/hierarchical_predecode2x4_0/pinv_0/pmos_m1_w0_840_sli_dli_da_p_0/a_54_0# 0.01343f
C585 row_addr_dff_0/dff_0/clkb row_addr_dff_0/dff_0/net4 0.08731f
C586 control_logic_rw_0/delay_chain_0/pinv_11_11/pmos_m1_w0_840_sli_dli_da_p_0/a_54_0# control_logic_rw_0/delay_chain_0/pinv_11_11/Z 0.0129f
C587 bank_0/port_address_0/hierarchical_decoder_0/predecode_1 bank_0/port_address_0/hierarchical_decoder_0/predecode_6 0.43402f
C588 control_logic_rw_0/pdriver_1_0/pinv_8_0/Z control_logic_rw_0/pdriver_1_0/pinv_6_0/A 0.12401f
C589 bank_0/port_address_0/wl_0 bank_0/replica_bitcell_array_0/dummy_array_3_0/dummy_cell_1rw_16/a_76_76# 0.05176f
C590 bank_0/replica_bitcell_array_0/dummy_array_3_0/dummy_cell_1rw_12/a_76_76# bank_0/replica_bitcell_array_0/dummy_array_3_0/dummy_cell_1rw_12/q 0.01645f
C591 bank_0/replica_bitcell_array_0/dummy_array_3_0/dummy_cell_1rw_6/q bank_0/replica_bitcell_array_0/dummy_array_3_0/dummy_cell_1rw_6/a_76_76# 0.01645f
C592 control_logic_rw_0/delay_chain_0/pinv_11_34/Z control_logic_rw_0/delay_chain_0/pinv_11_33/Z 0.18385f
C593 bank_0/replica_bitcell_array_0/bitcell_array_0/cell_1rw_18/qb bank_0/port_address_0/wl_13 0.03585f
C594 control_logic_rw_0/delay_chain_0/pinv_11_20/Z control_logic_rw_0/pinv_3_0/A 0.04231f
C595 bank_0/replica_bitcell_array_0/bitcell_array_0/cell_1rw_24/q bank_0/replica_bitcell_array_0/bitcell_array_0/cell_1rw_8/qb 0.02064f
C596 bank_0/replica_bitcell_array_0/dummy_array_2_0/dummy_cell_1rw_6/q bank_0/port_address_0/wl_10 0.04615f
C597 bank_0/replica_bitcell_array_0/dummy_array_3_0/dummy_cell_1rw_17/qb bank_0/port_address_0/rbl_wl 0.03696f
C598 bank_0/replica_bitcell_array_0/dummy_array_3_0/dummy_cell_1rw_18/qb bank_0/replica_bitcell_array_0/dummy_array_3_0/dummy_cell_1rw_18/q 0.28699f
C599 control_logic_rw_0/pand3_0/C control_logic_rw_0/pand2_0/pdriver_0/pinv_2_0/pmos_m9_w1_120_sli_dli_da_p_0/a_600_0# 0.02798f
C600 addr0[1] row_addr_dff_0/dff_1/net1 0.01887f
C601 control_logic_rw_0/dff_buf_array_0/dff_buf_0_1/pinv_1_0/nmos_m3_w0_560_sli_dli_da_p_0/a_54_0# control_logic_rw_0/dff_buf_array_0/dff_buf_0_1/pinv_1_0/gnd 0.011f
C602 control_logic_rw_0/delay_chain_0/pinv_11_14/pmos_m1_w0_840_sli_dli_da_p_0/a_54_0# control_logic_rw_0/delay_chain_0/pinv_11_9/A 0.01702f
C603 control_logic_rw_0/pand3_0/pnand3_0_0/pmos_m1_w0_840_sli_dli_2/a_0_0# control_logic_rw_0/pinv_3_0/A 0.01437f
C604 bank_0/replica_bitcell_array_0/dummy_array_2_0/dummy_cell_1rw_12/q bank_0/port_address_0/wl_4 0.04741f
C605 bank_0/replica_bitcell_array_0/dummy_array_2_0/dummy_cell_1rw_6/a_145_76# bank_0/replica_bitcell_array_0/dummy_array_2_0/dummy_cell_1rw_6/qb 0.0163f
C606 bank_0/replica_bitcell_array_0/dummy_array_3_0/dummy_cell_1rw_10/a_145_76# bank_0/port_address_0/wl_6 0.04184f
C607 bank_0/port_address_0/wordline_driver_array_0/in_10 bank_0/wl_en0 0.18688f
C608 row_addr_dff_0/dff_3/net1 row_addr_dff_0/dff_3/net3 0.14299f
C609 bank_0/replica_bitcell_array_0/bitcell_array_0/cell_1rw_5/qb bank_0/port_address_0/wl_10 0.03696f
C610 control_logic_rw_0/delay_chain_0/pinv_11_19/Z control_logic_rw_0/delay_chain_0/pinv_11_18/Z 0.18896f
C611 control_logic_rw_0/pand3_0/C control_logic_rw_0/dff_buf_array_0/dff_buf_0_0/pinv_1_0/gnd 0.18679f
C612 control_logic_rw_0/delay_chain_0/pinv_11_42/Z control_logic_rw_0/delay_chain_0/pinv_11_44/w_n127_403# 0.20256f
C613 bank_0/port_address_0/hierarchical_decoder_0/hierarchical_predecode2x4_1/pinv_0/Z bank_0/port_address_0/hierarchical_decoder_0/hierarchical_predecode2x4_1/and2_dec_3/pinv_0/w_n127_244# 0.29388f
C614 bank_0/replica_bitcell_array_0/dummy_array_3_0/dummy_cell_1rw_8/a_76_76# bank_0/replica_bitcell_array_0/dummy_array_3_0/dummy_cell_1rw_8/q 0.01645f
C615 bank_0/replica_bitcell_array_0/dummy_array_0/dummy_cell_1rw_0/qb bank_0/replica_bitcell_array_0/dummy_array_0/dummy_cell_1rw_1/q 0.02064f
C616 bank_0/replica_bitcell_array_0/dummy_array_2_0/dummy_cell_1rw_12/a_145_76# bank_0/replica_bitcell_array_0/dummy_array_2_0/dummy_cell_1rw_12/qb 0.0163f
C617 bank_0/port_address_0/hierarchical_decoder_0/and2_dec_10/pinv_0/pmos_m1_w0_840_sli_dli_da_p_0/a_54_0# bank_0/port_address_0/wordline_driver_array_0/in_5 0.01304f
C618 bank_0/replica_bitcell_array_0/dummy_array_3_0/dummy_cell_1rw_0/qb bank_0/replica_bitcell_array_0/dummy_array_0_0/dummy_cell_1rw_0/q 0.02064f
C619 control_logic_rw_0/pand3_0/C control_logic_rw_0/pinv_3_1/w_n127_195# 2.59251f
C620 bank_0/replica_bitcell_array_0/bitcell_array_0/cell_1rw_3/q bank_0/replica_bitcell_array_0/bitcell_array_0/cell_1rw_3/qb 0.28699f
C621 control_logic_rw_0/pand2_0/Z control_logic_rw_0/pand2_0/pdriver_0/pinv_2_0/pmos_m9_w1_120_sli_dli_da_p_0/a_132_0# 0.02492f
C622 row_addr_dff_0/dff_0/net3 row_addr_dff_0/dff_0/net1 0.14299f
C623 addr0[2] row_addr_dff_0/dff_1/clkb 0.31679f
C624 row_addr_dff_0/dff_0/clkb addr0[3] 0.32288f
C625 bank_0/port_address_0/hierarchical_decoder_0/and2_dec_9/pinv_0/w_n127_244# bank_0/port_address_0/hierarchical_decoder_0/predecode_6 0.03401f
C626 bank_0/replica_bitcell_array_0/replica_column_0/dummy_cell_1rw_0/a_76_76# bank_0/replica_bitcell_array_0/replica_column_0/dummy_cell_1rw_0/a_145_76# 0.06598f
C627 bank_0/replica_bitcell_array_0/dummy_array_2_0/dummy_cell_1rw_18/a_76_76# bank_0/replica_bitcell_array_0/dummy_array_2_0/dummy_cell_1rw_18/a_145_76# 0.06598f
C628 control_logic_rw_0/delay_chain_0/pinv_11_34/Z control_logic_rw_0/pinv_3_0/A 0.10996f
C629 control_logic_rw_0/pand3_0/C control_logic_rw_0/pinv_3_0/vdd 0.02748f
C630 bank_0/addr0_2 row_addr_dff_0/dff_1/net5 0.08417f
C631 bank_0/replica_bitcell_array_0/bitcell_array_0/cell_1rw_17/qb bank_0/port_address_0/wl_14 0.03704f
C632 control_logic_rw_0/pand3_0/C control_logic_rw_0/pdriver_0_0/pinv_7_0/pmos_m11_w1_150_sli_dli_da_p_0/a_132_0# 0.0277f
C633 bank_0/replica_bitcell_array_0/dummy_array_3_0/dummy_cell_1rw_10/q bank_0/replica_bitcell_array_0/dummy_array_3_0/dummy_cell_1rw_10/a_76_76# 0.01645f
C634 bank_0/port_address_0/hierarchical_decoder_0/and2_dec_13/pinv_0/w_n127_244# bank_0/port_address_0/wl_3 0.16341f
C635 row_addr_dff_0/dff_3/clk row_addr_dff_0/dff_0/net4 0.15111f
C636 bank_0/replica_bitcell_array_0/dummy_array_2_0/dummy_cell_1rw_16/a_76_76# bank_0/port_address_0/wl_0 0.05228f
C637 control_logic_rw_0/pand2_1/gnd control_logic_rw_0/pand2_0/pdriver_0/pinv_2_0/nmos_m9_w0_560_sli_dli_da_p_0/a_54_0# 0.01089f
C638 control_logic_rw_0/pand3_0/C control_logic_rw_0/pand3_0/pnand3_0_0/pmos_m1_w0_840_sli_dli_0/a_0_0# 0.01452f
C639 bank_0/replica_bitcell_array_0/dummy_array_2_0/dummy_cell_1rw_13/a_76_76# bank_0/replica_bitcell_array_0/dummy_array_2_0/dummy_cell_1rw_13/a_145_76# 0.06598f
C640 bank_0/replica_bitcell_array_0/dummy_array_3_0/dummy_cell_1rw_14/qb bank_0/port_address_0/wl_2 0.03696f
C641 bank_0/replica_bitcell_array_0/bitcell_array_0/cell_1rw_27/q bank_0/replica_bitcell_array_0/bitcell_array_0/cell_1rw_11/qb 0.02064f
C642 bank_0/replica_bitcell_array_0/bitcell_array_0/cell_1rw_27/qb bank_0/replica_bitcell_array_0/bitcell_array_0/cell_1rw_11/q 0.01651f
C643 control_logic_rw_0/delay_chain_0/pinv_11_16/Z control_logic_rw_0/delay_chain_0/pinv_11_24/w_n127_403# 0.20256f
C644 control_logic_rw_0/pand2_0/Z control_logic_rw_0/pand2_0/pdriver_0/pinv_2_0/nmos_m9_w0_560_sli_dli_da_p_0/a_210_0# 0.02082f
C645 control_logic_rw_0/pand3_0/C control_logic_rw_0/pnand2_1_0/w_n127_195# 0.48046f
C646 bank_0/replica_bitcell_array_0/dummy_array_0/dummy_cell_1rw_1/qb bank_0/replica_bitcell_array_0/dummy_array_0/dummy_cell_1rw_1/q 0.28699f
C647 row_addr_dff_0/dff_1/net4 row_addr_dff_0/dff_1/net3 0.04611f
C648 bank_0/replica_bitcell_array_0/bitcell_array_0/cell_1rw_19/qb bank_0/port_address_0/wl_12 0.03585f
C649 bank_0/replica_bitcell_array_0/bitcell_array_0/cell_1rw_7/q bank_0/port_address_0/wl_8 0.04136f
C650 bank_0/replica_bitcell_array_0/dummy_array_3_0/dummy_cell_1rw_3/a_76_76# bank_0/replica_bitcell_array_0/dummy_array_3_0/dummy_cell_1rw_3/a_145_76# 0.06598f
C651 bank_0/port_address_0/wordline_driver_array_0/in_2 bank_0/port_address_0/hierarchical_decoder_0/and2_dec_13/pinv_0/w_n127_244# 0.14989f
C652 bank_0/replica_bitcell_array_0/replica_column_0/dummy_cell_1rw_0/qb bank_0/replica_bitcell_array_0/dummy_array_2_0/dummy_cell_1rw_0/q 0.02064f
C653 control_logic_rw_0/pand3_0/C control_logic_rw_0/pdriver_1_0/w_n127_195# 1.71429f
C654 bank_0/replica_bitcell_array_0/dummy_array_3_0/dummy_cell_1rw_3/qb bank_0/port_address_0/wl_13 0.03696f
C655 bank_0/replica_bitcell_array_0/dummy_array_3_0/dummy_cell_1rw_3/q bank_0/replica_bitcell_array_0/dummy_array_3_0/dummy_cell_1rw_3/qb 0.28699f
C656 bank_0/replica_bitcell_array_0/dummy_array_3_0/dummy_cell_1rw_2/q bank_0/port_address_0/wl_14 0.04136f
C657 bank_0/replica_bitcell_array_0/dummy_array_3_0/dummy_cell_1rw_8/qb bank_0/replica_bitcell_array_0/bitcell_array_0/cell_1rw_7/q 0.02064f
C658 bank_0/port_address_0/wl_0 bank_0/port_address_0/wl_1 0.03867f
C659 control_logic_rw_0/delay_chain_0/pinv_11_16/pmos_m1_w0_840_sli_dli_da_p_0/a_54_0# control_logic_rw_0/delay_chain_0/pinv_11_16/Z 0.0129f
C660 control_logic_rw_0/dff_buf_array_0/dff_buf_0_1/pinv_1_0/w_n127_195# control_logic_rw_0/pand3_0/B 0.11962f
C661 bank_0/replica_bitcell_array_0/bitcell_array_0/cell_1rw_15/qb bank_0/replica_bitcell_array_0/bitcell_array_0/cell_1rw_31/q 0.02064f
C662 bank_0/replica_bitcell_array_0/bitcell_array_0/cell_1rw_15/q bank_0/replica_bitcell_array_0/bitcell_array_0/cell_1rw_31/qb 0.01651f
C663 bank_0/replica_bitcell_array_0/dummy_array_2_0/dummy_cell_1rw_5/q bank_0/replica_bitcell_array_0/dummy_array_2_0/dummy_cell_1rw_5/a_76_76# 0.01645f
C664 bank_0/port_address_0/hierarchical_decoder_0/hierarchical_predecode2x4_1/and2_dec_1/pinv_0/w_n127_244# bank_0/addr0_1 0.42366f
C665 control_logic_rw_0/pand3_0/C control_logic_rw_0/pand2_1/pdriver_0/pinv_2_0/nmos_m9_w0_560_sli_dli_da_p_0/a_288_0# 0.01211f
C666 control_logic_rw_0/pand3_0/C control_logic_rw_0/pdriver_1_0/pinv_6_0/pmos_m4_w1_050_sli_dli_da_p_0/a_54_0# 0.02171f
C667 bank_0/replica_bitcell_array_0/bitcell_array_0/cell_1rw_0/qb bank_0/port_address_0/wl_15 0.03696f
C668 bank_0/port_address_0/hierarchical_decoder_0/predecode_4 bank_0/port_address_0/hierarchical_decoder_0/predecode_5 5.22918f
C669 bank_0/replica_bitcell_array_0/replica_column_0/replica_cell_1rw_11/q bank_0/port_address_0/wl_4 0.04211f
C670 control_logic_rw_0/delay_chain_0/pinv_11_44/Z control_logic_rw_0/delay_chain_0/pinv_11_40/Z 0.11884f
C671 addr0[3] row_addr_dff_0/dff_3/clk 0.16643f
C672 bank_0/port_address_0/hierarchical_decoder_0/predecode_4 bank_0/port_address_0/hierarchical_decoder_0/predecode_7 0.17033f
C673 bank_0/replica_bitcell_array_0/bitcell_array_0/cell_1rw_29/q bank_0/port_address_0/wl_2 0.04155f
C674 row_addr_dff_0/dff_2/net1 row_addr_dff_0/dff_3/clk 0.31285f
C675 control_logic_rw_0/pdriver_1_0/pinv_4_0/pmos_m2_w0_840_sli_dli_da_p_0/a_54_0# control_logic_rw_0/pdriver_1_0/pinv_6_0/A 0.01899f
C676 bank_0/port_address_0/wordline_driver_array_0/in_2 bank_0/port_address_0/wordline_driver_array_0/in_3 0.01302f
C677 bank_0/replica_bitcell_array_0/dummy_array_3_0/dummy_cell_1rw_15/a_145_76# bank_0/replica_bitcell_array_0/dummy_array_3_0/dummy_cell_1rw_15/qb 0.0163f
C678 control_logic_rw_0/delay_chain_0/pinv_11_36/Z control_logic_rw_0/delay_chain_0/pinv_11_37/Z 0.04321f
C679 bank_0/port_address_0/hierarchical_decoder_0/predecode_0 bank_0/port_address_0/hierarchical_decoder_0/and2_dec_15/pinv_0/w_n127_244# 0.02587f
C680 control_logic_rw_0/delay_chain_0/pinv_11_35/Z control_logic_rw_0/pinv_3_0/A 0.04231f
C681 row_addr_dff_0/dff_1/net4 row_addr_dff_0/dff_1/clkb 0.08731f
C682 control_logic_rw_0/pand3_0/C control_logic_rw_0/pdriver_1_0/pinv_4_0/pmos_m2_w0_840_sli_dli_da_p_0/a_0_0# 0.01403f
C683 bank_0/wl_en0 bank_0/port_address_0/hierarchical_decoder_0/and2_dec_1/pinv_0/w_n127_244# 0.29587f
C684 bank_0/port_address_0/wl_1 bank_0/replica_bitcell_array_0/dummy_array_2_0/dummy_cell_1rw_15/q 0.0474f
C685 bank_0/replica_bitcell_array_0/replica_column_0/dummy_cell_1rw_0/q bank_0/replica_bitcell_array_0/dummy_array_2_0/dummy_cell_1rw_0/qb 0.01651f
C686 bank_0/port_address_0/hierarchical_decoder_0/hierarchical_predecode2x4_1/pinv_0/Z bank_0/port_address_0/hierarchical_decoder_0/hierarchical_predecode2x4_1/pinv_0/pmos_m1_w0_840_sli_dli_da_p_0/a_54_0# 0.01343f
C687 control_logic_rw_0/pnand2_1_0/nmos_m1_w0_840_sli_dactive_0/D control_logic_rw_0/pinv_3_0/A 0.02539f
C688 bank_0/replica_bitcell_array_0/dummy_array_2_0/dummy_cell_1rw_8/q bank_0/port_address_0/wl_8 0.04741f
C689 bank_0/port_address_0/hierarchical_decoder_0/predecode_1 bank_0/port_address_0/hierarchical_decoder_0/hierarchical_predecode2x4_0/and2_dec_1/pinv_0/w_n127_244# 0.02566f
C690 bank_0/port_address_0/wordline_driver_array_0/in_2 bank_0/port_address_0/wordline_driver_array_0/in_1 0.01362f
C691 control_logic_rw_0/pand3_0_0/pdriver_3_0/pinv_10_0/pmos_m2_w0_840_sli_dli_da_p_0/a_0_0# control_logic_rw_0/pinv_3_0/vdd 0.01403f
C692 control_logic_rw_0/pand3_0/C control_logic_rw_0/pand2_0/pnand2_0_0/nmos_m1_w0_840_sli_dactive_0/D 0.01236f
C693 control_logic_rw_0/pand3_0/C control_logic_rw_0/pand2_1/pdriver_0/pinv_2_0/nmos_m9_w0_560_sli_dli_da_p_0/a_522_0# 0.01931f
C694 bank_0/replica_bitcell_array_0/dummy_array_3_0/dummy_cell_1rw_16/a_76_76# bank_0/replica_bitcell_array_0/dummy_array_3_0/dummy_cell_1rw_16/a_145_76# 0.06598f
C695 bank_0/replica_bitcell_array_0/dummy_array_2_0/dummy_cell_1rw_16/qb bank_0/replica_bitcell_array_0/replica_column_0/replica_cell_1rw_15/q 0.01651f
C696 addr0[3] addr0[0] 0.01778f
C697 clk0 control_logic_rw_0/pinv_3_1/w_n127_195# 0.11126f
C698 data_dff_0/dff_1/net3 data_dff_0/dff_1/net1 0.14299f
C699 control_logic_rw_0/pinv_3_0/w_n127_195# control_logic_rw_0/pand3_0/B 0.18857f
C700 control_logic_rw_0/delay_chain_0/pinv_11_9/Z control_logic_rw_0/delay_chain_0/pinv_11_4/w_n127_403# 0.05233f
C701 row_addr_dff_0/dff_1/net3 row_addr_dff_0/dff_3/clk 0.09335f
C702 bank_0/replica_bitcell_array_0/bitcell_array_0/cell_1rw_24/qb bank_0/port_address_0/wl_7 0.03704f
C703 bank_0/port_address_0/hierarchical_decoder_0/hierarchical_predecode2x4_0/pinv_1/Z bank_0/port_address_0/hierarchical_decoder_0/hierarchical_predecode2x4_0/and2_dec_1/pinv_0/w_n127_244# 0.0212f
C704 bank_0/replica_bitcell_array_0/dummy_array_2_0/dummy_cell_1rw_8/a_145_76# bank_0/replica_bitcell_array_0/dummy_array_2_0/dummy_cell_1rw_8/qb 0.0163f
C705 bank_0/replica_bitcell_array_0/dummy_array_0/dummy_cell_1rw_0/qb bank_0/replica_bitcell_array_0/dummy_array_0/dummy_cell_1rw_0/q 0.28699f
C706 bank_0/replica_bitcell_array_0/dummy_array_3_0/dummy_cell_1rw_11/qb bank_0/replica_bitcell_array_0/dummy_array_3_0/dummy_cell_1rw_11/a_145_76# 0.0163f
C707 control_logic_rw_0/delay_chain_0/pinv_11_34/Z control_logic_rw_0/delay_chain_0/pinv_11_32/Z 0.13851f
C708 bank_0/addr0_3 bank_0/addr0_1 0.03236f
C709 control_logic_rw_0/pdriver_1_0/pinv_8_0/Z control_logic_rw_0/pdriver_1_0/w_n127_195# 0.18899f
C710 control_logic_rw_0/delay_chain_0/pinv_11_9/w_n127_403# control_logic_rw_0/pinv_3_0/A 0.33207f
C711 row_addr_dff_0/dff_0/clkb row_addr_dff_0/dff_1/clkb 0.0128f
C712 bank_0/port_address_0/hierarchical_decoder_0/hierarchical_predecode2x4_0/and2_dec_1/pinv_0/w_n127_244# bank_0/addr0_3 0.42366f
C713 control_logic_rw_0/dff_buf_array_0/dff_buf_0_0/dff_0/net5 control_logic_rw_0/dff_buf_array_0/dff_buf_0_0/dff_0/net4 0.13677f
C714 bank_0/port_address_0/hierarchical_decoder_0/predecode_2 bank_0/port_address_0/hierarchical_decoder_0/predecode_3 5.37298f
C715 bank_0/port_address_0/and2_dec_0_0/pinv_0/w_n127_244# bank_0/port_address_0/rbl_wl 0.16341f
C716 bank_0/replica_bitcell_array_0/dummy_array_3_0/dummy_cell_1rw_9/a_145_76# bank_0/port_address_0/wl_7 0.04184f
C717 bank_0/replica_bitcell_array_0/dummy_array_2_0/dummy_cell_1rw_18/qb bank_0/replica_bitcell_array_0/dummy_array_2_0/dummy_cell_1rw_18/q 0.28699f
C718 control_logic_rw_0/delay_chain_0/pinv_11_35/Z control_logic_rw_0/delay_chain_0/pinv_11_44/w_n127_403# 0.19711f
C719 bank_0/replica_bitcell_array_0/dummy_array_2_0/dummy_cell_1rw_14/a_76_76# bank_0/replica_bitcell_array_0/dummy_array_2_0/dummy_cell_1rw_14/a_145_76# 0.06598f
C720 control_logic_rw_0/delay_chain_0/pinv_11_15/Z control_logic_rw_0/delay_chain_0/pinv_11_16/Z 0.04321f
C721 control_logic_rw_0/pdriver_4_0/pinv_5_0/pmos_m1_w0_840_sli_dli_da_p_0/a_0_0# control_logic_rw_0/pinv_3_0/A 0.0169f
C722 bank_0/replica_bitcell_array_0/dummy_array_3_0/dummy_cell_1rw_1/a_76_76# bank_0/port_address_0/wl_15 0.05176f
C723 bank_0/port_address_0/wl_9 bank_0/replica_bitcell_array_0/bitcell_array_0/cell_1rw_22/qb 0.03704f
C724 bank_0/replica_bitcell_array_0/replica_column_0/replica_cell_1rw_4/q bank_0/port_address_0/wl_11 0.04084f
C725 control_logic_rw_0/dff_buf_array_0/dff_buf_0_0/dff_0/clkb control_logic_rw_0/dff_buf_array_0/dff_buf_0_0/dff_0/net1 0.1543f
C726 bank_0/replica_bitcell_array_0/dummy_array_2_0/dummy_cell_1rw_13/qb bank_0/replica_bitcell_array_0/dummy_array_2_0/dummy_cell_1rw_13/q 0.28699f
C727 bank_0/replica_bitcell_array_0/dummy_array_0/dummy_cell_1rw_0/q bank_0/replica_bitcell_array_0/dummy_array_0/dummy_cell_1rw_1/qb 0.01651f
C728 control_logic_rw_0/delay_chain_0/pinv_11_34/Z control_logic_rw_0/delay_chain_0/pinv_11_34/w_n127_403# 1.168f
C729 control_logic_rw_0/pand3_0/C control_logic_rw_0/pdriver_1_0/pinv_8_0/Z 0.14361f
C730 bank_0/replica_bitcell_array_0/bitcell_array_0/cell_1rw_18/q bank_0/port_address_0/wl_13 0.04029f
C731 control_logic_rw_0/pand3_0/C control_logic_rw_0/pinv_3_1/pmos_m1_w0_840_sli_dli_da_p_0/a_0_0# 0.01719f
C732 bank_0/port_address_0/wl_0 bank_0/port_address_0/rbl_wl 0.13236f
C733 bank_0/replica_bitcell_array_0/dummy_array_3_0/dummy_cell_1rw_17/q bank_0/port_address_0/rbl_wl 0.04136f
C734 bank_0/replica_bitcell_array_0/bitcell_array_0/cell_1rw_30/qb bank_0/replica_bitcell_array_0/replica_column_0/replica_cell_1rw_14/q 0.02064f
C735 bank_0/port_address_0/hierarchical_decoder_0/predecode_2 bank_0/port_address_0/hierarchical_decoder_0/and2_dec_1/pinv_0/w_n127_244# 0.02797f
C736 bank_0/replica_bitcell_array_0/bitcell_array_0/cell_1rw_19/qb bank_0/replica_bitcell_array_0/bitcell_array_0/cell_1rw_19/q 0.28699f
C737 control_logic_rw_0/dff_buf_array_0/dff_buf_0_1/pinv_1_0/vdd control_logic_rw_0/dff_buf_array_0/dff_buf_0_0/dff_0/Q 0.05616f
C738 bank_0/replica_bitcell_array_0/dummy_array_3_0/dummy_cell_1rw_10/q bank_0/replica_bitcell_array_0/dummy_array_3_0/dummy_cell_1rw_10/qb 0.28699f
C739 control_logic_rw_0/pand3_0/C clk0 0.11384f
C740 bank_0/port_address_0/hierarchical_decoder_0/hierarchical_predecode2x4_0/pinv_0/Z bank_0/port_address_0/hierarchical_decoder_0/hierarchical_predecode2x4_0/and2_dec_3/pinv_0/w_n127_244# 0.29388f
C741 control_logic_rw_0/delay_chain_0/pinv_11_0/Z control_logic_rw_0/pinv_3_0/A 0.14124f
C742 control_logic_rw_0/delay_chain_0/pinv_11_41/Z control_logic_rw_0/delay_chain_0/pinv_11_40/Z 0.04321f
C743 control_logic_rw_0/delay_chain_0/pinv_11_44/Z control_logic_rw_0/delay_chain_0/pinv_11_44/pmos_m1_w0_840_sli_dli_da_p_0/a_54_0# 0.01702f
C744 bank_0/replica_bitcell_array_0/dummy_array_3_0/dummy_cell_1rw_2/qb bank_0/replica_bitcell_array_0/dummy_array_3_0/dummy_cell_1rw_2/q 0.28699f
C745 control_logic_rw_0/delay_chain_0/pinv_11_8/Z control_logic_rw_0/delay_chain_0/pinv_11_9/Z 0.18896f
C746 row_addr_dff_0/dff_3/clk row_addr_dff_0/dff_1/clkb 0.83335f
C747 bank_0/port_address_0/hierarchical_decoder_0/hierarchical_predecode2x4_1/and2_dec_0/pinv_0/pmos_m1_w0_840_sli_dli_da_p_0/a_54_0# bank_0/port_address_0/hierarchical_decoder_0/predecode_3 0.01558f
C748 bank_0/port_address_0/wordline_driver_array_0/in_4 bank_0/port_address_0/hierarchical_decoder_0/and2_dec_11/pinv_0/w_n127_244# 0.14989f
C749 row_addr_dff_0/dff_2/net3 row_addr_dff_0/dff_3/clk 0.09335f
C750 control_logic_rw_0/pand2_1/pdriver_0/pinv_2_0/nmos_m9_w0_560_sli_dli_da_p_0/a_132_0# control_logic_rw_0/pand2_1/gnd 0.0179f
C751 control_logic_rw_0/dff_buf_array_0/dff_buf_0_1/pinv_1_0/vdd control_logic_rw_0/dff_buf_array_0/dff_buf_0_0/pinv_0_0/pmos_m2_w0_840_sli_dli_da_p_0/a_54_0# 0.01857f
C752 bank_0/replica_bitcell_array_0/bitcell_array_0/cell_1rw_30/qb bank_0/replica_bitcell_array_0/bitcell_array_0/cell_1rw_30/q 0.28699f
C753 control_logic_rw_0/delay_chain_0/pinv_11_24/w_n127_403# control_logic_rw_0/delay_chain_0/pinv_11_19/Z 0.75898f
C754 control_logic_rw_0/pdriver_0_0/gnd control_logic_rw_0/pdriver_0_0/pinv_7_0/A 0.37095f
C755 bank_0/replica_bitcell_array_0/dummy_array_3_0/dummy_cell_1rw_14/a_145_76# bank_0/replica_bitcell_array_0/dummy_array_3_0/dummy_cell_1rw_14/qb 0.0163f
C756 bank_0/replica_bitcell_array_0/bitcell_array_0/cell_1rw_17/q bank_0/port_address_0/wl_14 0.04155f
C757 bank_0/replica_bitcell_array_0/bitcell_array_0/cell_1rw_12/qb bank_0/port_address_0/wl_3 0.03696f
C758 bank_0/replica_bitcell_array_0/dummy_array_0_0/dummy_cell_1rw_0/qb bank_0/replica_bitcell_array_0/dummy_array_0_0/dummy_cell_1rw_1/q 0.02064f
C759 bank_0/port_address_0/hierarchical_decoder_0/hierarchical_predecode2x4_0/and2_dec_2/pinv_0/pmos_m1_w0_840_sli_dli_da_p_0/a_54_0# bank_0/port_address_0/hierarchical_decoder_0/predecode_5 0.01558f
C760 bank_0/port_address_0/hierarchical_decoder_0/hierarchical_predecode2x4_0/and2_dec_3/pinv_0/w_n127_244# bank_0/port_address_0/hierarchical_decoder_0/predecode_5 0.24006f
C761 bank_0/replica_bitcell_array_0/dummy_array_1_0/dummy_cell_1rw_0/a_76_76# bank_0/replica_bitcell_array_0/dummy_array_1_0/dummy_cell_1rw_0/a_145_76# 0.06598f
C762 control_logic_rw_0/dff_buf_array_0/dff_buf_0_0/pinv_1_0/nmos_m3_w0_560_sli_dli_da_p_0/a_0_0# control_logic_rw_0/dff_buf_array_0/dff_buf_0_0/pinv_1_0/gnd 0.01131f
C763 bank_0/replica_bitcell_array_0/replica_column_0/replica_cell_1rw_2/q bank_0/port_address_0/wl_13 0.04211f
C764 bank_0/replica_bitcell_array_0/dummy_array_3_0/dummy_cell_1rw_17/a_76_76# bank_0/replica_bitcell_array_0/dummy_array_3_0/dummy_cell_1rw_17/q 0.01645f
C765 control_logic_rw_0/pand2_0/Z control_logic_rw_0/pand2_0/pdriver_0/pinv_2_0/nmos_m9_w0_560_sli_dli_da_p_0/a_600_0# 0.01136f
C766 bank_0/replica_bitcell_array_0/dummy_array_0_0/dummy_cell_1rw_0/q bank_0/replica_bitcell_array_0/dummy_array_0_0/dummy_cell_1rw_1/qb 0.01651f
C767 control_logic_rw_0/pand3_0_0/pnand3_0_0/pmos_m1_w0_840_sli_dli_2/a_0_0# control_logic_rw_0/pinv_3_0/vdd 0.01407f
C768 control_logic_rw_0/dff_buf_array_0/dff_buf_0_1/pinv_1_0/w_n127_195# control_logic_rw_0/pand3_0_0/C 0.17662f
C769 control_logic_rw_0/dff_buf_array_0/dff_buf_0_1/pinv_1_0/vdd control_logic_rw_0/dff_buf_array_0/dff_buf_0_1/pinv_1_0/w_n127_195# 0.67027f
C770 bank_0/replica_bitcell_array_0/bitcell_array_0/cell_1rw_19/q bank_0/port_address_0/wl_12 0.04029f
C771 control_logic_rw_0/pand2_0/pdriver_0/pinv_2_0/nmos_m9_w0_560_sli_dli_da_p_0/a_522_0# control_logic_rw_0/pand2_1/gnd 0.01066f
C772 control_logic_rw_0/delay_chain_0/pinv_11_38/Z control_logic_rw_0/delay_chain_0/pinv_11_37/Z 0.04321f
C773 bank_0/replica_bitcell_array_0/dummy_array_3_0/dummy_cell_1rw_2/a_76_76# bank_0/replica_bitcell_array_0/dummy_array_3_0/dummy_cell_1rw_2/q 0.01645f
C774 bank_0/port_address_0/hierarchical_decoder_0/predecode_1 bank_0/port_address_0/hierarchical_decoder_0/hierarchical_predecode2x4_1/and2_dec_2/pinv_0/pmos_m1_w0_840_sli_dli_da_p_0/a_54_0# 0.01558f
C775 bank_0/replica_bitcell_array_0/dummy_array_3_0/dummy_cell_1rw_0/a_76_76# bank_0/replica_bitcell_array_0/dummy_array_3_0/dummy_cell_1rw_0/a_145_76# 0.06598f
C776 control_logic_rw_0/delay_chain_0/pinv_11_13/Z control_logic_rw_0/delay_chain_0/pinv_11_9/w_n127_403# 0.20256f
C777 bank_0/port_address_0/hierarchical_decoder_0/predecode_1 bank_0/port_address_0/hierarchical_decoder_0/hierarchical_predecode2x4_1/and2_dec_3/pinv_0/w_n127_244# 0.25677f
C778 bank_0/replica_bitcell_array_0/dummy_array_2_0/dummy_cell_1rw_16/a_76_76# bank_0/replica_bitcell_array_0/dummy_array_2_0/dummy_cell_1rw_16/a_145_76# 0.06598f
C779 data_dff_0/dff_0/net3 data_dff_0/dff_0/net4 0.04611f
C780 bank_0/replica_bitcell_array_0/dummy_array_3_0/dummy_cell_1rw_4/a_145_76# bank_0/port_address_0/wl_12 0.04184f
C781 control_logic_rw_0/pand3_0/C control_logic_rw_0/pdriver_0_0/pinv_7_0/pmos_m11_w1_150_sli_dli_da_p_0/a_0_0# 0.01881f
C782 bank_0/p_en_bar0 bank_0/wl_en0 1.36682f
C783 bank_0/replica_bitcell_array_0/dummy_array_3_0/dummy_cell_1rw_13/q bank_0/replica_bitcell_array_0/bitcell_array_0/cell_1rw_12/qb 0.01651f
C784 bank_0/replica_bitcell_array_0/bitcell_array_0/cell_1rw_8/q bank_0/replica_bitcell_array_0/bitcell_array_0/cell_1rw_8/qb 0.28699f
C785 control_logic_rw_0/dff_buf_array_0/dff_buf_0_1/dff_0/net2 control_logic_rw_0/dff_buf_array_0/dff_buf_0_1/dff_0/net3 0.03271f
C786 row_addr_dff_0/dff_0/clkb row_addr_dff_0/dff_0/net1 0.1543f
C787 bank_0/port_address_0/hierarchical_decoder_0/hierarchical_predecode2x4_0/pinv_1/w_n127_244# bank_0/addr0_2 0.09792f
C788 bank_0/replica_bitcell_array_0/dummy_array_2_0/dummy_cell_1rw_10/a_145_76# bank_0/port_address_0/wl_6 0.04284f
C789 row_addr_dff_0/dff_3/clk row_addr_dff_0/dff_2/net2 0.0716f
C790 bank_0/replica_bitcell_array_0/bitcell_array_0/cell_1rw_9/q bank_0/port_address_0/wl_6 0.04136f
C791 bank_0/replica_bitcell_array_0/dummy_array_2_0/dummy_cell_1rw_0/a_76_76# bank_0/replica_bitcell_array_0/dummy_array_2_0/dummy_cell_1rw_0/a_145_76# 0.06598f
C792 control_logic_rw_0/pand3_0/C control_logic_rw_0/pand2_1/pdriver_0/pinv_2_0/pmos_m9_w1_120_sli_dli_da_p_0/a_288_0# 0.05789f
C793 bank_0/replica_bitcell_array_0/dummy_array_3_0/dummy_cell_1rw_12/a_145_76# bank_0/replica_bitcell_array_0/dummy_array_3_0/dummy_cell_1rw_12/qb 0.0163f
C794 control_logic_rw_0/pand2_0/Z control_logic_rw_0/pand2_0/pdriver_0/pinv_2_0/nmos_m9_w0_560_sli_dli_da_p_0/a_444_0# 0.01112f
C795 bank_0/replica_bitcell_array_0/dummy_array_3_0/dummy_cell_1rw_16/qb bank_0/replica_bitcell_array_0/dummy_array_3_0/dummy_cell_1rw_16/q 0.28699f
C796 control_logic_rw_0/delay_chain_0/pinv_11_30/Z control_logic_rw_0/pinv_3_0/A 0.04231f
C797 control_logic_rw_0/delay_chain_0/pinv_11_19/Z control_logic_rw_0/pinv_3_0/A 0.10996f
C798 bank_0/replica_bitcell_array_0/dummy_array_2_0/dummy_cell_1rw_11/a_76_76# bank_0/replica_bitcell_array_0/dummy_array_2_0/dummy_cell_1rw_11/q 0.01645f
C799 control_logic_rw_0/dff_buf_array_0/dff_buf_0_1/pinv_1_0/nmos_m3_w0_560_sli_dli_da_p_0/a_54_0# control_logic_rw_0/dff_buf_array_0/dout_0 0.01986f
C800 bank_0/port_address_0/rbl_wl bank_0/replica_bitcell_array_0/dummy_array_0/dummy_cell_1rw_1/a_76_76# 0.05224f
C801 bank_0/replica_bitcell_array_0/bitcell_array_0/cell_1rw_13/qb bank_0/port_address_0/wl_2 0.03696f
C802 bank_0/replica_bitcell_array_0/dummy_array_3_0/dummy_cell_1rw_12/q bank_0/port_address_0/wl_4 0.04136f
C803 control_logic_rw_0/pand3_0/C control_logic_rw_0/pand2_1/pdriver_0/pinv_2_0/pmos_m9_w1_120_sli_dli_da_p_0/a_210_0# 0.06363f
C804 bank_0/port_address_0/wl_11 bank_0/replica_bitcell_array_0/dummy_array_2_0/dummy_cell_1rw_5/a_76_76# 0.05228f
C805 bank_0/replica_bitcell_array_0/dummy_array_3_0/dummy_cell_1rw_2/q bank_0/replica_bitcell_array_0/bitcell_array_0/cell_1rw_1/qb 0.01651f
C806 bank_0/replica_bitcell_array_0/bitcell_array_0/cell_1rw_0/q bank_0/port_address_0/wl_15 0.04136f
C807 row_addr_dff_0/dff_2/clkb row_addr_dff_0/dff_3/clkb 0.01354f
C808 bank_0/port_address_0/hierarchical_decoder_0/hierarchical_predecode2x4_1/pinv_1/pmos_m1_w0_840_sli_dli_da_p_0/a_54_0# bank_0/port_address_0/hierarchical_decoder_0/hierarchical_predecode2x4_1/pinv_1/Z 0.01603f
C809 bank_0/replica_bitcell_array_0/dummy_array_1_0/dummy_cell_1rw_1/qb bank_0/replica_bitcell_array_0/dummy_array_1_0/dummy_cell_1rw_1/q 0.28699f
C810 bank_0/replica_bitcell_array_0/dummy_array_3_0/dummy_cell_1rw_14/a_76_76# bank_0/port_address_0/wl_2 0.05176f
C811 bank_0/replica_bitcell_array_0/bitcell_array_0/cell_1rw_5/qb bank_0/replica_bitcell_array_0/bitcell_array_0/cell_1rw_21/q 0.02064f
C812 control_logic_rw_0/pand3_0/C control_logic_rw_0/pand2_0/pdriver_0/pinv_2_0/pmos_m9_w1_120_sli_dli_da_p_0/a_210_0# 0.02223f
C813 control_logic_rw_0/pand3_0/C control_logic_rw_0/pdriver_0_0/pinv_6_0/pmos_m4_w1_050_sli_dli_da_p_0/a_210_0# 0.02474f
C814 bank_0/port_address_0/hierarchical_decoder_0/and2_dec_15/pinv_0/w_n127_244# bank_0/wl_en0 0.29944f
C815 control_logic_rw_0/delay_chain_0/pinv_11_1/Z control_logic_rw_0/delay_chain_0/pinv_11_2/Z 0.04321f
C816 control_logic_rw_0/delay_chain_0/pinv_11_27/Z control_logic_rw_0/delay_chain_0/pinv_11_27/pmos_m1_w0_840_sli_dli_da_p_0/a_54_0# 0.0129f
C817 bank_0/port_address_0/hierarchical_decoder_0/predecode_3 bank_0/port_address_0/hierarchical_decoder_0/predecode_5 0.42912f
C818 addr0[1] addr0[3] 0.80605f
C819 control_logic_rw_0/pand3_0/C control_logic_rw_0/pdriver_0_0/pinv_6_0/pmos_m4_w1_050_sli_dli_da_p_0/a_288_0# 0.01798f
C820 bank_0/port_address_0/wordline_driver_array_0/in_0 bank_0/port_address_0/hierarchical_decoder_0/and2_dec_15/pinv_0/pmos_m1_w0_840_sli_dli_da_p_0/a_54_0# 0.01304f
C821 bank_0/replica_bitcell_array_0/dummy_array_2_0/dummy_cell_1rw_14/qb bank_0/replica_bitcell_array_0/dummy_array_2_0/dummy_cell_1rw_14/q 0.28699f
C822 bank_0/port_address_0/hierarchical_decoder_0/predecode_7 bank_0/port_address_0/hierarchical_decoder_0/predecode_3 0.42359f
C823 control_logic_rw_0/pand3_0/C control_logic_rw_0/pand3_0/pnand3_0_0/nmos_m1_w0_840_sactive_dli_0/S 0.01001f
C824 control_logic_rw_0/pand3_0/C control_logic_rw_0/pdriver_1_0/pinv_4_0/pmos_m2_w0_840_sli_dli_da_p_0/a_54_0# 0.01772f
C825 control_logic_rw_0/pinv_3_0/w_n127_195# control_logic_rw_0/pand3_0_0/C 0.34993f
C826 control_logic_rw_0/delay_chain_0/pinv_11_25/Z control_logic_rw_0/pinv_3_0/A 0.04231f
C827 addr0[1] row_addr_dff_0/dff_2/net1 0.0963f
C828 bank_0/port_address_0/and2_dec_0_0/pinv_0/pmos_m1_w0_840_sli_dli_da_p_0/a_54_0# bank_0/port_address_0/rbl_wl 0.01304f
C829 bank_0/replica_bitcell_array_0/dummy_array_2_0/dummy_cell_1rw_4/a_145_76# bank_0/port_address_0/wl_12 0.04284f
C830 row_addr_dff_0/dff_2/net5 row_addr_dff_0/dff_3/clk 0.03761f
C831 bank_0/port_address_0/wordline_driver_array_0/wordline_driver_10/pinv_0/pmos_m1_w0_840_sli_dli_da_p_0/a_54_0# bank_0/port_address_0/wl_5 0.01304f
C832 bank_0/port_address_0/hierarchical_decoder_0/predecode_1 bank_0/port_address_0/hierarchical_decoder_0/and2_dec_3/pinv_0/w_n127_244# 0.02796f
C833 control_logic_rw_0/pand3_0/C control_logic_rw_0/pand2_0/pdriver_0/pinv_2_0/pmos_m9_w1_120_sli_dli_da_p_0/a_444_0# 0.02775f
C834 control_logic_rw_0/delay_chain_0/pinv_11_0/pmos_m1_w0_840_sli_dli_da_p_0/a_54_0# control_logic_rw_0/delay_chain_0/pinv_11_0/Z 0.0129f
C835 control_logic_rw_0/pand2_0/pdriver_0/pinv_2_0/nmos_m9_w0_560_sli_dli_da_p_0/a_132_0# control_logic_rw_0/pand2_1/gnd 0.0179f
C836 bank_0/replica_bitcell_array_0/dummy_array_3_0/dummy_cell_1rw_14/q bank_0/port_address_0/wl_2 0.04136f
C837 control_logic_rw_0/pdriver_0_0/pinv_5_0/Z control_logic_rw_0/pdriver_0_0/pinv_5_0/pmos_m1_w0_840_sli_dli_da_p_0/a_54_0# 0.0132f
C838 row_addr_dff_0/dff_3/clk row_addr_dff_0/dff_0/net1 0.3125f
C839 bank_0/port_address_0/wordline_driver_array_0/in_0 bank_0/port_address_0/wordline_driver_array_0/in_1 0.01302f
C840 bank_0/replica_bitcell_array_0/dummy_array_2_0/dummy_cell_1rw_15/a_76_76# bank_0/replica_bitcell_array_0/dummy_array_2_0/dummy_cell_1rw_15/q 0.01645f
C841 control_logic_rw_0/delay_chain_0/pinv_11_29/Z control_logic_rw_0/delay_chain_0/pinv_11_24/Z 0.4357f
C842 bank_0/port_address_0/hierarchical_decoder_0/predecode_4 bank_0/port_address_0/hierarchical_decoder_0/predecode_6 0.14601f
C843 bank_0/replica_bitcell_array_0/dummy_array_3_0/dummy_cell_1rw_18/q bank_0/replica_bitcell_array_0/dummy_array_1_0/dummy_cell_1rw_0/qb 0.01651f
C844 control_logic_rw_0/pand2_0/Z control_logic_rw_0/pand2_0/pdriver_0/pinv_2_0/nmos_m9_w0_560_sli_dli_da_p_0/a_678_0# 0.01142f
C845 bank_0/port_address_0/hierarchical_decoder_0/predecode_7 bank_0/port_address_0/hierarchical_decoder_0/and2_dec_1/pinv_0/w_n127_244# 0.44085f
C846 bank_0/port_address_0/wl_10 bank_0/replica_bitcell_array_0/dummy_array_3_0/dummy_cell_1rw_6/a_145_76# 0.04184f
C847 bank_0/replica_bitcell_array_0/bitcell_array_0/cell_1rw_24/q bank_0/port_address_0/wl_7 0.04155f
C848 bank_0/replica_bitcell_array_0/bitcell_array_0/cell_1rw_8/q bank_0/replica_bitcell_array_0/dummy_array_3_0/dummy_cell_1rw_9/qb 0.02064f
C849 control_logic_rw_0/pand3_0/B control_logic_rw_0/pinv_3_0/A 2.50201f
C850 bank_0/replica_bitcell_array_0/dummy_array_3_0/dummy_cell_1rw_8/qb bank_0/port_address_0/wl_8 0.03696f
C851 bank_0/port_address_0/hierarchical_decoder_0/predecode_4 bank_0/port_address_0/hierarchical_decoder_0/and2_dec_13/pinv_0/w_n127_244# 0.29931f
C852 control_logic_rw_0/delay_chain_0/pinv_11_15/Z control_logic_rw_0/delay_chain_0/pinv_11_19/Z 0.11884f
C853 control_logic_rw_0/pnand2_1_0/pmos_m1_w0_840_sli_dli_0/a_0_0# control_logic_rw_0/pinv_3_0/A 0.0224f
C854 bank_0/replica_bitcell_array_0/dummy_array_2_0/dummy_cell_1rw_7/qb bank_0/replica_bitcell_array_0/dummy_array_2_0/dummy_cell_1rw_7/a_145_76# 0.0163f
C855 control_logic_rw_0/pand2_0/Z control_logic_rw_0/pand2_0/pdriver_0/pinv_2_0/pmos_m9_w1_120_sli_dli_da_p_0/a_54_0# 0.03013f
C856 bank_0/replica_bitcell_array_0/bitcell_array_0/cell_1rw_6/q bank_0/replica_bitcell_array_0/bitcell_array_0/cell_1rw_22/qb 0.01651f
C857 bank_0/replica_bitcell_array_0/dummy_array_0/dummy_cell_1rw_0/a_76_76# bank_0/replica_bitcell_array_0/dummy_array_0/dummy_cell_1rw_0/q 0.01645f
C858 bank_0/port_address_0/wl_9 bank_0/replica_bitcell_array_0/bitcell_array_0/cell_1rw_22/q 0.04155f
C859 bank_0/replica_bitcell_array_0/dummy_array_3_0/dummy_cell_1rw_1/q bank_0/port_address_0/wl_15 0.04136f
C860 control_logic_rw_0/dff_buf_array_0/dff_buf_0_0/pinv_1_0/gnd control_logic_rw_0/dff_buf_array_0/dff_buf_0_0/dff_0/Q 0.04884f
C861 bank_0/replica_bitcell_array_0/dummy_array_2_0/dummy_cell_1rw_13/qb bank_0/port_address_0/wl_3 0.03923f
C862 bank_0/replica_bitcell_array_0/bitcell_array_0/cell_1rw_12/q bank_0/replica_bitcell_array_0/dummy_array_3_0/dummy_cell_1rw_13/qb 0.02064f
C863 control_logic_rw_0/dff_buf_array_0/dff_buf_0_0/dff_0/net5 control_logic_rw_0/dff_buf_array_0/dff_buf_0_0/dff_0/Q 0.07645f
C864 control_logic_rw_0/dff_buf_array_0/dff_buf_0_0/dff_0/net3 control_logic_rw_0/dff_buf_array_0/dff_buf_0_0/dff_0/net4 0.04611f
C865 bank_0/replica_bitcell_array_0/dummy_array_3_0/dummy_cell_1rw_11/qb bank_0/port_address_0/wl_5 0.03696f
C866 control_logic_rw_0/delay_chain_0/pinv_11_36/Z control_logic_rw_0/delay_chain_0/pinv_11_39/Z 0.1423f
C867 bank_0/replica_bitcell_array_0/bitcell_array_0/cell_1rw_25/qb bank_0/port_address_0/wl_6 0.03704f
C868 bank_0/port_address_0/and2_dec_0_0/pnand2_0/nmos_m1_w0_840_sli_dactive_0/D bank_0/wl_en0 0.01244f
C869 bank_0/replica_bitcell_array_0/dummy_array_0/dummy_cell_1rw_0/qb bank_0/replica_bitcell_array_0/dummy_array_3_0/dummy_cell_1rw_17/q 0.01651f
C870 bank_0/replica_bitcell_array_0/dummy_array_2_0/dummy_cell_1rw_16/qb bank_0/replica_bitcell_array_0/dummy_array_2_0/dummy_cell_1rw_16/q 0.28699f
C871 bank_0/port_address_0/wordline_driver_array_0/in_12 bank_0/port_address_0/wordline_driver_array_0/in_11 0.01362f
C872 control_logic_rw_0/pdriver_1_0/pinv_8_0/A control_logic_rw_0/pdriver_1_0/pinv_5_0/pmos_m1_w0_840_sli_dli_da_p_0/a_54_0# 0.0132f
C873 bank_0/replica_bitcell_array_0/dummy_array_3_0/dummy_cell_1rw_6/qb bank_0/replica_bitcell_array_0/bitcell_array_0/cell_1rw_5/q 0.02064f
C874 bank_0/port_address_0/hierarchical_decoder_0/predecode_2 bank_0/port_address_0/hierarchical_decoder_0/predecode_0 0.22779f
C875 bank_0/replica_bitcell_array_0/dummy_array_2_0/dummy_cell_1rw_0/qb bank_0/replica_bitcell_array_0/dummy_array_2_0/dummy_cell_1rw_0/q 0.28699f
C876 bank_0/replica_bitcell_array_0/dummy_array_2_0/dummy_cell_1rw_6/a_145_76# bank_0/port_address_0/wl_10 0.04284f
C877 control_logic_rw_0/delay_chain_0/pinv_11_6/Z control_logic_rw_0/delay_chain_0/pinv_11_9/w_n127_403# 0.20256f
C878 bank_0/replica_bitcell_array_0/dummy_array_3_0/dummy_cell_1rw_18/a_145_76# bank_0/replica_bitcell_array_0/dummy_array_3_0/dummy_cell_1rw_18/qb 0.0163f
C879 bank_0/replica_bitcell_array_0/dummy_array_1_0/dummy_cell_1rw_1/a_76_76# bank_0/replica_bitcell_array_0/dummy_array_1_0/dummy_cell_1rw_1/q 0.01645f
C880 bank_0/port_address_0/hierarchical_decoder_0/hierarchical_predecode2x4_0/pinv_1/Z bank_0/addr0_2 0.28914f
C881 control_logic_rw_0/dff_buf_array_0/dff_buf_0_1/pinv_1_0/vdd control_logic_rw_0/dff_buf_array_0/dff_buf_0_0/pinv_0_0/pmos_m2_w0_840_sli_dli_da_p_0/a_132_0# 0.01602f
C882 control_logic_rw_0/dff_buf_array_0/dff_buf_0_0/dff_0/clkb control_logic_rw_0/dff_buf_array_0/dff_buf_0_1/dff_0/clkb 0.01354f
C883 bank_0/replica_bitcell_array_0/dummy_array_2_0/dummy_cell_1rw_12/a_145_76# bank_0/port_address_0/wl_4 0.04284f
C884 control_logic_rw_0/pand3_0/C control_logic_rw_0/pand2_1/pdriver_0/pinv_2_0/pmos_m9_w1_120_sli_dli_da_p_0/a_600_0# 0.05297f
C885 bank_0/replica_bitcell_array_0/dummy_array_2_0/dummy_cell_1rw_17/a_76_76# bank_0/replica_bitcell_array_0/dummy_array_2_0/dummy_cell_1rw_17/q 0.01645f
C886 bank_0/addr0_2 bank_0/addr0_3 8.55517f
C887 bank_0/port_address_0/wl_1 bank_0/replica_bitcell_array_0/dummy_array_3_0/dummy_cell_1rw_15/qb 0.03696f
C888 control_logic_rw_0/delay_chain_0/pinv_11_39/Z control_logic_rw_0/delay_chain_0/pinv_11_39/pmos_m1_w0_840_sli_dli_da_p_0/a_54_0# 0.01414f
C889 control_logic_rw_0/dff_buf_array_0/dff_buf_0_1/pinv_1_0/w_n127_195# control_logic_rw_0/dff_buf_array_0/dff_buf_0_0/pinv_1_0/gnd 0.04571f
C890 control_logic_rw_0/delay_chain_0/pinv_11_30/Z control_logic_rw_0/delay_chain_0/pinv_11_34/w_n127_403# 0.19711f
C891 bank_0/port_address_0/hierarchical_decoder_0/and2_dec_9/pinv_0/w_n127_244# bank_0/port_address_0/wl_6 0.16398f
C892 bank_0/replica_bitcell_array_0/dummy_array_2_0/dummy_cell_1rw_1/a_76_76# bank_0/replica_bitcell_array_0/dummy_array_2_0/dummy_cell_1rw_1/q 0.01645f
C893 control_logic_rw_0/dff_buf_array_0/dff_buf_0_1/pinv_1_0/nmos_m3_w0_560_sli_dli_da_p_0/a_210_0# control_logic_rw_0/dff_buf_array_0/dout_0 0.01406f
C894 control_logic_rw_0/pdriver_0_0/pinv_6_0/A control_logic_rw_0/pdriver_0_0/pinv_5_0/Z 0.11488f
C895 bank_0/replica_bitcell_array_0/dummy_array_3_0/dummy_cell_1rw_8/a_76_76# bank_0/replica_bitcell_array_0/dummy_array_3_0/dummy_cell_1rw_8/a_145_76# 0.06598f
C896 addr0[1] row_addr_dff_0/dff_1/clkb 0.02786f
C897 bank_0/replica_bitcell_array_0/bitcell_array_0/cell_1rw_12/q bank_0/port_address_0/wl_3 0.04136f
C898 control_logic_rw_0/delay_chain_0/pinv_11_18/Z control_logic_rw_0/delay_chain_0/pinv_11_17/Z 0.04321f
C899 control_logic_rw_0/pand2_0/Z control_logic_rw_0/pand2_0/pdriver_0/pinv_2_0/nmos_m9_w0_560_sli_dli_da_p_0/a_54_0# 0.01803f
C900 control_logic_rw_0/delay_chain_0/pinv_11_5/Z control_logic_rw_0/delay_chain_0/pinv_11_9/Z 0.11884f
C901 bank_0/port_address_0/hierarchical_decoder_0/predecode_1 bank_0/port_address_0/hierarchical_decoder_0/and2_dec_11/pinv_0/w_n127_244# 0.02155f
C902 control_logic_rw_0/pdriver_0_0/pinv_7_0/A control_logic_rw_0/pinv_3_1/w_n127_195# 0.27988f
C903 bank_0/port_address_0/hierarchical_decoder_0/and2_dec_5/pinv_0/w_n127_244# bank_0/port_address_0/wordline_driver_array_0/in_11 0.14946f
C904 bank_0/replica_bitcell_array_0/bitcell_array_0/cell_1rw_4/q bank_0/replica_bitcell_array_0/dummy_array_3_0/dummy_cell_1rw_5/qb 0.02064f
C905 control_logic_rw_0/delay_chain_0/pinv_11_19/pmos_m1_w0_840_sli_dli_da_p_0/a_54_0# control_logic_rw_0/delay_chain_0/pinv_11_19/Z 0.01414f
C906 control_logic_rw_0/pdriver_4_0/pinv_8_0/A control_logic_rw_0/pinv_3_0/A 0.42515f
C907 bank_0/port_address_0/wordline_driver_array_0/wordline_driver_12/pinv_0/pmos_m1_w0_840_sli_dli_da_p_0/a_54_0# bank_0/port_address_0/wl_3 0.01304f
C908 bank_0/replica_bitcell_array_0/bitcell_array_0/cell_1rw_17/q bank_0/replica_bitcell_array_0/bitcell_array_0/cell_1rw_1/qb 0.02064f
C909 control_logic_rw_0/pand3_0/C control_logic_rw_0/dff_buf_array_0/dff_buf_0_0/dff_0/Q 0.14562f
C910 control_logic_rw_0/pdriver_0_0/pinv_7_0/A control_logic_rw_0/pdriver_0_0/pinv_6_0/nmos_m4_w0_520_sli_dli_da_p_0/a_54_0# 0.01546f
C911 control_logic_rw_0/delay_chain_0/pinv_11_21/Z control_logic_rw_0/delay_chain_0/pinv_11_21/pmos_m1_w0_840_sli_dli_da_p_0/a_54_0# 0.0129f
C912 control_logic_rw_0/delay_chain_0/pinv_11_34/w_n127_403# control_logic_rw_0/delay_chain_0/pinv_11_25/Z 0.19711f
C913 control_logic_rw_0/pnand2_1_0/pmos_m1_w0_840_sli_dli_0/a_54_0# control_logic_rw_0/pinv_3_0/A 0.02501f
C914 bank_0/replica_bitcell_array_0/dummy_array_0/dummy_cell_1rw_1/a_145_76# bank_0/replica_bitcell_array_0/dummy_array_0/dummy_cell_1rw_1/a_76_76# 0.06598f
C915 bank_0/replica_bitcell_array_0/replica_column_0/replica_cell_1rw_9/q bank_0/replica_bitcell_array_0/dummy_array_2_0/dummy_cell_1rw_10/qb 0.01651f
C916 bank_0/replica_bitcell_array_0/bitcell_array_0/cell_1rw_19/qb bank_0/replica_bitcell_array_0/bitcell_array_0/cell_1rw_3/q 0.01651f
C917 bank_0/replica_bitcell_array_0/dummy_array_3_0/dummy_cell_1rw_13/a_145_76# bank_0/replica_bitcell_array_0/dummy_array_3_0/dummy_cell_1rw_13/qb 0.0163f
C918 bank_0/port_address_0/wl_10 bank_0/replica_bitcell_array_0/bitcell_array_0/cell_1rw_21/q 0.04155f
C919 bank_0/port_address_0/wl_14 bank_0/replica_bitcell_array_0/dummy_array_2_0/dummy_cell_1rw_2/qb 0.03924f
C920 bank_0/replica_bitcell_array_0/dummy_array_2_0/dummy_cell_1rw_11/a_76_76# bank_0/port_address_0/wl_5 0.05228f
C921 bank_0/replica_bitcell_array_0/bitcell_array_0/cell_1rw_13/q bank_0/port_address_0/wl_2 0.04136f
C922 control_logic_rw_0/pand3_0_0/pnand3_0_0/nmos_m1_w0_840_sactive_dli_0/S control_logic_rw_0/pand3_0_0/gnd 0.01146f
C923 bank_0/replica_bitcell_array_0/dummy_array_3_0/dummy_cell_1rw_14/a_76_76# bank_0/replica_bitcell_array_0/dummy_array_3_0/dummy_cell_1rw_14/a_145_76# 0.06598f
C924 bank_0/replica_bitcell_array_0/dummy_array_3_0/dummy_cell_1rw_0/qb bank_0/replica_bitcell_array_0/dummy_array_3_0/dummy_cell_1rw_0/a_145_76# 0.0163f
C925 row_addr_dff_0/dff_3/clkb row_addr_dff_0/dff_3/net4 0.08731f
C926 control_logic_rw_0/pand3_0/C control_logic_rw_0/dff_buf_array_0/dff_buf_0_0/pinv_0_0/pmos_m2_w0_840_sli_dli_da_p_0/a_54_0# 0.02331f
C927 bank_0/replica_bitcell_array_0/bitcell_array_0/cell_1rw_11/qb bank_0/replica_bitcell_array_0/bitcell_array_0/cell_1rw_11/q 0.28699f
C928 bank_0/replica_bitcell_array_0/bitcell_array_0/cell_1rw_2/q bank_0/port_address_0/wl_13 0.04009f
C929 control_logic_rw_0/pand3_0/C control_logic_rw_0/pand2_0/pdriver_0/pinv_2_0/pmos_m9_w1_120_sli_dli_da_p_0/a_522_0# 0.02284f
C930 control_logic_rw_0/delay_chain_0/pinv_11_9/A control_logic_rw_0/delay_chain_0/pinv_11_9/Z 0.361f
C931 bank_0/replica_bitcell_array_0/dummy_array_2_0/dummy_cell_1rw_18/qb bank_0/replica_bitcell_array_0/replica_column_0/dummy_cell_1rw_1/q 0.01651f
C932 control_logic_rw_0/pand3_0/C control_logic_rw_0/pand2_0/pdriver_0/pinv_2_0/pmos_m9_w1_120_sli_dli_da_p_0/a_288_0# 0.02719f
C933 control_logic_rw_0/pand3_0/C control_logic_rw_0/pand3_0/pnand3_0_0/pmos_m1_w0_840_sli_dli_1/a_0_0# 0.021f
C934 bank_0/replica_bitcell_array_0/dummy_array_3_0/dummy_cell_1rw_1/qb bank_0/port_address_0/wl_15 0.03696f
C935 bank_0/replica_bitcell_array_0/dummy_array_2_0/dummy_cell_1rw_5/a_145_76# bank_0/replica_bitcell_array_0/dummy_array_2_0/dummy_cell_1rw_5/qb 0.0163f
C936 control_logic_rw_0/pdriver_0_0/gnd control_logic_rw_0/pdriver_0_0/pinv_7_0/nmos_m11_w0_570_sli_dli_da_p_0/a_132_0# 0.01809f
C937 control_logic_rw_0/pand3_0/C control_logic_rw_0/dff_buf_array_0/dff_buf_0_1/pinv_1_0/w_n127_195# 0.75975f
C938 control_logic_rw_0/delay_chain_0/pinv_11_9/w_n127_403# control_logic_rw_0/delay_chain_0/pinv_11_7/Z 0.20256f
C939 control_logic_rw_0/pand3_0/C control_logic_rw_0/pdriver_0_0/pinv_7_0/pmos_m11_w1_150_sli_dli_da_p_0/a_366_0# 0.02257f
C940 bank_0/replica_bitcell_array_0/bitcell_array_0/cell_1rw_4/q bank_0/replica_bitcell_array_0/bitcell_array_0/cell_1rw_4/qb 0.28699f
C941 bank_0/replica_bitcell_array_0/dummy_array_2_0/dummy_cell_1rw_14/qb bank_0/port_address_0/wl_2 0.03924f
C942 control_logic_rw_0/pinv_3_0/w_n127_195# control_logic_rw_0/pinv_3_0/vdd 0.6523f
C943 bank_0/port_address_0/wordline_driver_array_0/in_14 bank_0/port_address_0/hierarchical_decoder_0/and2_dec_1/pinv_0/w_n127_244# 0.14989f
C944 control_logic_rw_0/pand3_0/C control_logic_rw_0/pdriver_0_0/pinv_7_0/A 0.39832f
C945 control_logic_rw_0/pand3_0_0/C control_logic_rw_0/pinv_3_0/A 0.20032f
C946 bank_0/port_address_0/hierarchical_decoder_0/and2_dec_15/pinv_0/w_n127_244# bank_0/port_address_0/hierarchical_decoder_0/predecode_7 0.14845f
C947 data_dff_0/dff_1/net2 din0[0] 0.01061f
C948 control_logic_rw_0/delay_chain_0/pinv_11_39/Z control_logic_rw_0/delay_chain_0/pinv_11_38/Z 0.18896f
C949 bank_0/replica_bitcell_array_0/replica_column_0/dummy_cell_1rw_0/qb bank_0/replica_bitcell_array_0/replica_column_0/dummy_cell_1rw_0/a_145_76# 0.0163f
C950 bank_0/replica_bitcell_array_0/bitcell_array_0/cell_1rw_31/qb bank_0/replica_bitcell_array_0/bitcell_array_0/cell_1rw_31/q 0.28699f
C951 csb0 control_logic_rw_0/dff_buf_array_0/dff_buf_0_1/dff_0/clkb 0.33766f
C952 control_logic_rw_0/delay_chain_0/pinv_11_35/Z control_logic_rw_0/delay_chain_0/pinv_11_35/pmos_m1_w0_840_sli_dli_da_p_0/a_54_0# 0.0129f
C953 bank_0/replica_bitcell_array_0/bitcell_array_0/cell_1rw_3/q bank_0/port_address_0/wl_12 0.04009f
C954 bank_0/replica_bitcell_array_0/dummy_array_3_0/dummy_cell_1rw_5/a_76_76# bank_0/replica_bitcell_array_0/dummy_array_3_0/dummy_cell_1rw_5/q 0.01645f
C955 bank_0/replica_bitcell_array_0/dummy_array_3_0/dummy_cell_1rw_13/a_145_76# bank_0/port_address_0/wl_3 0.04184f
C956 bank_0/wl_en0 control_logic_rw_0/pand3_0/gnd 0.1638f
C957 row_addr_dff_0/dff_0/clkb row_addr_dff_0/dff_0/net5 0.03696f
C958 bank_0/replica_bitcell_array_0/bitcell_array_0/cell_1rw_24/qb bank_0/replica_bitcell_array_0/replica_column_0/replica_cell_1rw_8/q 0.02064f
C959 bank_0/port_address_0/wl_0 bank_0/replica_bitcell_array_0/dummy_array_3_0/dummy_cell_1rw_16/qb 0.03696f
C960 bank_0/replica_bitcell_array_0/dummy_array_2_0/dummy_cell_1rw_7/qb bank_0/replica_bitcell_array_0/dummy_array_2_0/dummy_cell_1rw_7/q 0.28699f
C961 bank_0/port_address_0/wl_0 bank_0/replica_bitcell_array_0/replica_column_0/replica_cell_1rw_15/q 0.04211f
C962 bank_0/port_address_0/wl_1 bank_0/replica_bitcell_array_0/dummy_array_2_0/dummy_cell_1rw_15/a_145_76# 0.04284f
C963 addr0[1] row_addr_dff_0/dff_0/net1 0.01849f
C964 bank_0/replica_bitcell_array_0/dummy_array_0_0/dummy_cell_1rw_0/a_76_76# bank_0/replica_bitcell_array_0/dummy_array_0_0/dummy_cell_1rw_0/a_145_76# 0.06598f
C965 bank_0/replica_bitcell_array_0/dummy_array_2_0/dummy_cell_1rw_8/qb bank_0/replica_bitcell_array_0/replica_column_0/replica_cell_1rw_7/q 0.01651f
C966 control_logic_rw_0/delay_chain_0/pinv_11_9/Z control_logic_rw_0/delay_chain_0/pinv_11_9/pmos_m1_w0_840_sli_dli_da_p_0/a_54_0# 0.01414f
C967 bank_0/wl_en0 bank_0/port_address_0/wordline_driver_array_0/in_8 0.18688f
C968 bank_0/port_address_0/hierarchical_decoder_0/predecode_6 bank_0/port_address_0/hierarchical_decoder_0/predecode_3 0.41908f
C969 bank_0/replica_bitcell_array_0/dummy_array_2_0/dummy_cell_1rw_8/a_145_76# bank_0/port_address_0/wl_8 0.04284f
C970 control_logic_rw_0/dff_buf_array_0/dout_0 control_logic_rw_0/dff_buf_array_0/dff_buf_0_1/pinv_1_0/gnd 0.2285f
C971 bank_0/port_address_0/hierarchical_decoder_0/predecode_0 bank_0/port_address_0/hierarchical_decoder_0/predecode_5 0.49878f
C972 bank_0/replica_bitcell_array_0/dummy_array_3_0/dummy_cell_1rw_8/q bank_0/port_address_0/wl_8 0.04136f
C973 bank_0/port_address_0/hierarchical_decoder_0/predecode_0 bank_0/port_address_0/hierarchical_decoder_0/predecode_7 0.50304f
C974 bank_0/replica_bitcell_array_0/dummy_array_3_0/dummy_cell_1rw_17/qb bank_0/replica_bitcell_array_0/dummy_array_0/dummy_cell_1rw_0/q 0.02064f
C975 control_logic_rw_0/delay_chain_0/pinv_11_2/pmos_m1_w0_840_sli_dli_da_p_0/a_54_0# control_logic_rw_0/delay_chain_0/pinv_11_2/Z 0.0129f
C976 bank_0/replica_bitcell_array_0/dummy_array_0_0/dummy_cell_1rw_0/q bank_0/replica_bitcell_array_0/dummy_array_0_0/dummy_cell_1rw_0/a_76_76# 0.01645f
C977 bank_0/replica_bitcell_array_0/dummy_array_2_0/dummy_cell_1rw_3/a_76_76# bank_0/replica_bitcell_array_0/dummy_array_2_0/dummy_cell_1rw_3/q 0.01645f
C978 row_addr_dff_0/dff_0/net2 row_addr_dff_0/dff_0/net1 0.12728f
C979 bank_0/replica_bitcell_array_0/dummy_array_2_0/dummy_cell_1rw_9/a_76_76# bank_0/replica_bitcell_array_0/dummy_array_2_0/dummy_cell_1rw_9/q 0.01645f
C980 control_logic_rw_0/delay_chain_0/pinv_11_40/Z control_logic_rw_0/pinv_3_0/A 0.04231f
C981 bank_0/replica_bitcell_array_0/bitcell_array_0/cell_1rw_7/q bank_0/replica_bitcell_array_0/bitcell_array_0/cell_1rw_23/qb 0.01651f
C982 row_addr_dff_0/dff_2/net3 row_addr_dff_0/dff_2/net4 0.04611f
C983 control_logic_rw_0/pand3_0/C control_logic_rw_0/pinv_3_0/w_n127_195# 0.19997f
C984 bank_0/port_address_0/hierarchical_decoder_0/and2_dec_5/pinv_0/w_n127_244# bank_0/port_address_0/wordline_driver_array_0/in_10 0.14989f
C985 row_addr_dff_0/dff_2/clkb row_addr_dff_0/dff_3/clk 0.83355f
C986 bank_0/replica_bitcell_array_0/dummy_array_3_0/dummy_cell_1rw_8/qb bank_0/replica_bitcell_array_0/dummy_array_3_0/dummy_cell_1rw_8/q 0.28699f
C987 control_logic_rw_0/pdriver_0_0/gnd control_logic_rw_0/pdriver_0_0/pinv_6_0/nmos_m4_w0_520_sli_dli_da_p_0/a_132_0# 0.01687f
C988 bank_0/port_address_0/hierarchical_decoder_0/and2_dec_13/pinv_0/w_n127_244# bank_0/port_address_0/hierarchical_decoder_0/predecode_3 0.0453f
C989 bank_0/replica_bitcell_array_0/dummy_array_2_0/dummy_cell_1rw_13/q bank_0/port_address_0/wl_3 0.0474f
C990 control_logic_rw_0/pdriver_0_0/pinv_6_0/pmos_m4_w1_050_sli_dli_da_p_0/a_0_0# control_logic_rw_0/pand3_0/C 0.01845f
C991 bank_0/replica_bitcell_array_0/dummy_array_2_0/dummy_cell_1rw_18/a_145_76# bank_0/replica_bitcell_array_0/dummy_array_2_0/dummy_cell_1rw_18/qb 0.0163f
C992 bank_0/port_address_0/hierarchical_decoder_0/predecode_6 bank_0/port_address_0/hierarchical_decoder_0/and2_dec_1/pinv_0/w_n127_244# 0.03007f
C993 bank_0/replica_bitcell_array_0/dummy_array_3_0/dummy_cell_1rw_11/qb bank_0/replica_bitcell_array_0/bitcell_array_0/cell_1rw_10/q 0.02064f
C994 bank_0/replica_bitcell_array_0/replica_column_0/replica_cell_1rw_6/q bank_0/replica_bitcell_array_0/bitcell_array_0/cell_1rw_22/qb 0.02064f
C995 row_addr_dff_0/dff_1/net2 row_addr_dff_0/dff_1/net1 0.12728f
C996 bank_0/port_address_0/hierarchical_decoder_0/hierarchical_predecode2x4_0/pinv_1/Z bank_0/port_address_0/hierarchical_decoder_0/hierarchical_predecode2x4_0/pinv_1/w_n127_244# 0.41826f
C997 bank_0/replica_bitcell_array_0/bitcell_array_0/cell_1rw_25/q bank_0/port_address_0/wl_6 0.04155f
C998 row_addr_dff_0/dff_3/clkb row_addr_dff_0/dff_3/net2 0.07662f
C999 bank_0/replica_bitcell_array_0/dummy_array_2_0/dummy_cell_1rw_16/qb bank_0/port_address_0/wl_0 0.03924f
C1000 row_addr_dff_0/dff_3/clk row_addr_dff_0/dff_0/net5 0.03761f
C1001 bank_0/port_address_0/hierarchical_decoder_0/hierarchical_predecode2x4_0/pinv_1/w_n127_244# bank_0/addr0_3 0.2155f
C1002 bank_0/replica_bitcell_array_0/dummy_array_2_0/dummy_cell_1rw_13/a_145_76# bank_0/replica_bitcell_array_0/dummy_array_2_0/dummy_cell_1rw_13/qb 0.0163f
C1003 control_logic_rw_0/delay_chain_0/pinv_11_11/Z control_logic_rw_0/delay_chain_0/pinv_11_10/Z 0.04321f
C1004 control_logic_rw_0/dff_buf_array_0/dff_buf_0_0/dff_0/clkb control_logic_rw_0/dff_buf_array_0/dff_buf_0_0/dff_0/net2 0.07662f
C1005 control_logic_rw_0/delay_chain_0/pinv_11_30/Z control_logic_rw_0/delay_chain_0/pinv_11_30/pmos_m1_w0_840_sli_dli_da_p_0/a_54_0# 0.0129f
C1006 control_logic_rw_0/dff_buf_array_0/dff_buf_0_0/dff_0/net4 control_logic_rw_0/dff_buf_array_0/dff_buf_0_0/dff_0/Q 0.23158f
C1007 bank_0/replica_bitcell_array_0/dummy_array_3_0/dummy_cell_1rw_7/a_76_76# bank_0/port_address_0/wl_9 0.05176f
C1008 control_logic_rw_0/delay_chain_0/pinv_11_39/Z control_logic_rw_0/delay_chain_0/pinv_11_37/Z 0.14367f
C1009 control_logic_rw_0/delay_chain_0/pinv_11_29/Z control_logic_rw_0/delay_chain_0/pinv_11_24/w_n127_403# 0.05137f
C1010 bank_0/replica_bitcell_array_0/bitcell_array_0/cell_1rw_25/qb bank_0/replica_bitcell_array_0/bitcell_array_0/cell_1rw_9/q 0.01651f
C1011 bank_0/replica_bitcell_array_0/dummy_array_3_0/dummy_cell_1rw_17/a_145_76# bank_0/port_address_0/rbl_wl 0.04184f
C1012 control_logic_rw_0/delay_chain_0/pinv_11_27/Z control_logic_rw_0/delay_chain_0/pinv_11_26/Z 0.04321f
C1013 control_logic_rw_0/delay_chain_0/pinv_11_40/Z control_logic_rw_0/delay_chain_0/pinv_11_44/w_n127_403# 0.19711f
C1014 bank_0/port_address_0/hierarchical_decoder_0/predecode_4 bank_0/port_address_0/hierarchical_decoder_0/hierarchical_predecode2x4_1/and2_dec_3/pinv_0/w_n127_244# 0.0127f
C1015 control_logic_rw_0/delay_chain_0/pinv_11_3/Z control_logic_rw_0/pinv_3_0/A 0.18584f
C1016 control_logic_rw_0/pand3_0/C control_logic_rw_0/pand2_1/pnand2_0_0/pmos_m1_w0_840_sli_dli_1/a_0_0# 0.02246f
C1017 control_logic_rw_0/pand2_1/pdriver_0/pinv_2_0/nmos_m9_w0_560_sli_dli_da_p_0/a_444_0# control_logic_rw_0/pand2_1/gnd 0.01788f
C1018 row_addr_dff_0/dff_0/clkb row_addr_dff_0/dff_0/net3 0.14179f
C1019 bank_0/replica_bitcell_array_0/replica_column_0/replica_cell_1rw_14/q bank_0/port_address_0/wl_1 0.04211f
C1020 bank_0/replica_bitcell_array_0/dummy_array_2_0/dummy_cell_1rw_17/a_76_76# bank_0/port_address_0/rbl_wl 0.05228f
C1021 row_addr_dff_0/dff_2/clkb addr0[0] 0.01212f
C1022 bank_0/replica_bitcell_array_0/bitcell_array_0/cell_1rw_8/q bank_0/port_address_0/wl_7 0.04136f
C1023 bank_0/replica_bitcell_array_0/dummy_array_3_0/dummy_cell_1rw_4/q bank_0/replica_bitcell_array_0/dummy_array_3_0/dummy_cell_1rw_4/qb 0.28699f
C1024 bank_0/port_address_0/hierarchical_decoder_0/and2_dec_5/pinv_0/w_n127_244# bank_0/port_address_0/wl_11 0.16341f
C1025 bank_0/port_address_0/hierarchical_decoder_0/and2_dec_9/pinv_0/pmos_m1_w0_840_sli_dli_da_p_0/a_54_0# bank_0/port_address_0/wordline_driver_array_0/in_6 0.01304f
C1026 bank_0/port_address_0/wl_1 bank_0/replica_bitcell_array_0/dummy_array_3_0/dummy_cell_1rw_15/q 0.04136f
C1027 control_logic_rw_0/delay_chain_0/pinv_11_28/Z control_logic_rw_0/delay_chain_0/pinv_11_29/Z 0.18896f
C1028 control_logic_rw_0/delay_chain_0/pinv_11_12/Z control_logic_rw_0/delay_chain_0/pinv_11_11/Z 0.04321f
C1029 bank_0/replica_bitcell_array_0/dummy_array_2_0/dummy_cell_1rw_1/a_76_76# bank_0/port_address_0/wl_15 0.05228f
C1030 control_logic_rw_0/pdriver_0_0/gnd control_logic_rw_0/pdriver_0_0/pinv_7_0/nmos_m11_w0_570_sli_dli_da_p_0/a_444_0# 0.01807f
C1031 control_logic_rw_0/pdriver_0_0/pinv_6_0/nmos_m4_w0_520_sli_dli_da_p_0/a_0_0# control_logic_rw_0/pdriver_0_0/gnd 0.01038f
C1032 control_logic_rw_0/delay_chain_0/pinv_11_27/Z control_logic_rw_0/delay_chain_0/pinv_11_29/Z 0.14286f
C1033 control_logic_rw_0/delay_chain_0/pinv_11_41/Z control_logic_rw_0/delay_chain_0/pinv_11_44/Z 0.14222f
C1034 control_logic_rw_0/pand3_0/C control_logic_rw_0/pand2_1/pdriver_0/pinv_2_0/pmos_m9_w1_120_sli_dli_da_p_0/a_444_0# 0.05479f
C1035 bank_0/replica_bitcell_array_0/dummy_array_0_0/dummy_cell_1rw_1/a_145_76# bank_0/replica_bitcell_array_0/dummy_array_0_0/dummy_cell_1rw_1/a_76_76# 0.06598f
C1036 control_logic_rw_0/dff_buf_array_0/dff_buf_0_1/dff_0/net5 control_logic_rw_0/dff_buf_array_0/dff_buf_0_1/dff_0/Q 0.07645f
C1037 control_logic_rw_0/pand3_0_0/pnand3_0_0/nmos_m1_w0_840_sli_dactive_0/D control_logic_rw_0/pand3_0_0/gnd 0.01436f
C1038 bank_0/replica_bitcell_array_0/dummy_array_2_0/dummy_cell_1rw_5/q bank_0/replica_bitcell_array_0/dummy_array_2_0/dummy_cell_1rw_5/qb 0.28699f
C1039 control_logic_rw_0/dff_buf_array_0/dff_buf_0_1/dff_0/net1 csb0 0.08177f
C1040 bank_0/port_address_0/wordline_driver_array_0/wordline_driver_14/pinv_0/pmos_m1_w0_840_sli_dli_da_p_0/a_54_0# bank_0/port_address_0/wl_1 0.01304f
C1041 bank_0/replica_bitcell_array_0/dummy_array_3_0/dummy_cell_1rw_2/a_145_76# bank_0/port_address_0/wl_14 0.04184f
C1042 bank_0/replica_bitcell_array_0/bitcell_array_0/cell_1rw_18/qb bank_0/replica_bitcell_array_0/bitcell_array_0/cell_1rw_18/q 0.28699f
C1043 control_logic_rw_0/pand2_1/gnd control_logic_rw_0/pand2_0/pdriver_0/pinv_2_0/nmos_m9_w0_560_sli_dli_da_p_0/a_366_0# 0.01066f
C1044 control_logic_rw_0/pand2_0/pdriver_0/pinv_2_0/nmos_m9_w0_560_sli_dli_da_p_0/a_522_0# control_logic_rw_0/pand2_0/Z 0.01931f
C1045 bank_0/replica_bitcell_array_0/dummy_array_3_0/dummy_cell_1rw_3/q bank_0/replica_bitcell_array_0/bitcell_array_0/cell_1rw_2/qb 0.01651f
C1046 bank_0/replica_bitcell_array_0/bitcell_array_0/cell_1rw_2/qb bank_0/port_address_0/wl_13 0.03577f
C1047 control_logic_rw_0/delay_chain_0/pinv_11_29/Z control_logic_rw_0/pinv_3_0/A 0.10996f
C1048 bank_0/port_address_0/hierarchical_decoder_0/and2_dec_5/pinv_0/w_n127_244# bank_0/port_address_0/hierarchical_decoder_0/predecode_3 0.0212f
C1049 bank_0/replica_bitcell_array_0/bitcell_array_0/cell_1rw_4/q bank_0/replica_bitcell_array_0/bitcell_array_0/cell_1rw_20/qb 0.01651f
C1050 bank_0/replica_bitcell_array_0/bitcell_array_0/cell_1rw_7/qb bank_0/replica_bitcell_array_0/bitcell_array_0/cell_1rw_7/q 0.28699f
C1051 bank_0/port_address_0/wl_14 bank_0/port_address_0/wl_13 0.13236f
C1052 bank_0/port_address_0/wl_1 bank_0/replica_bitcell_array_0/bitcell_array_0/cell_1rw_30/q 0.04155f
C1053 control_logic_rw_0/dff_buf_array_0/dff_buf_0_1/dff_0/net4 control_logic_rw_0/dff_buf_array_0/dff_buf_0_1/dff_0/net5 0.13677f
C1054 control_logic_rw_0/delay_chain_0/pinv_11_13/Z control_logic_rw_0/delay_chain_0/pinv_11_13/pmos_m1_w0_840_sli_dli_da_p_0/a_54_0# 0.0129f
C1055 data_dff_0/dff_0/net3 data_dff_0/dff_0/net2 0.03271f
C1056 control_logic_rw_0/delay_chain_0/pinv_11_24/w_n127_403# control_logic_rw_0/delay_chain_0/pinv_11_17/Z 0.20256f
C1057 bank_0/replica_bitcell_array_0/dummy_array_3_0/dummy_cell_1rw_17/a_76_76# bank_0/replica_bitcell_array_0/dummy_array_3_0/dummy_cell_1rw_17/a_145_76# 0.06598f
C1058 control_logic_rw_0/pdriver_4_0/pinv_8_0/A control_logic_rw_0/pdriver_4_0/pinv_5_0/pmos_m1_w0_840_sli_dli_da_p_0/a_54_0# 0.0132f
C1059 row_addr_dff_0/dff_2/net5 row_addr_dff_0/dff_2/net4 0.13677f
C1060 control_logic_rw_0/pand3_0/C control_logic_rw_0/pand3_0/pnand3_0_0/nmos_m1_w0_840_sactive_dli_0/a_54_0# 0.01675f
C1061 bank_0/port_address_0/hierarchical_decoder_0/predecode_1 bank_0/port_address_0/hierarchical_decoder_0/hierarchical_predecode2x4_1/and2_dec_1/pinv_0/w_n127_244# 0.02224f
C1062 bank_0/replica_bitcell_array_0/bitcell_array_0/cell_1rw_21/qb bank_0/replica_bitcell_array_0/bitcell_array_0/cell_1rw_5/q 0.01651f
C1063 control_logic_rw_0/pand3_0/C control_logic_rw_0/pand2_0/pnand2_0_0/nmos_m1_w0_840_sactive_dli_0/a_54_0# 0.01675f
C1064 bank_0/port_address_0/wl_14 bank_0/replica_bitcell_array_0/dummy_array_2_0/dummy_cell_1rw_2/q 0.04741f
C1065 bank_0/replica_bitcell_array_0/bitcell_array_0/cell_1rw_17/qb bank_0/replica_bitcell_array_0/bitcell_array_0/cell_1rw_17/q 0.28699f
C1066 row_addr_dff_0/dff_3/clk row_addr_dff_0/dff_0/net3 0.09332f
C1067 bank_0/wl_en0 bank_0/port_address_0/wordline_driver_array_0/in_5 0.18688f
C1068 control_logic_rw_0/pand3_0/C control_logic_rw_0/pdriver_1_0/pinv_5_0/pmos_m1_w0_840_sli_dli_da_p_0/a_0_0# 0.0176f
C1069 control_logic_rw_0/delay_chain_0/pinv_11_40/pmos_m1_w0_840_sli_dli_da_p_0/a_54_0# control_logic_rw_0/delay_chain_0/pinv_11_40/Z 0.0129f
C1070 bank_0/replica_bitcell_array_0/dummy_array_3_0/dummy_cell_1rw_16/a_145_76# bank_0/replica_bitcell_array_0/dummy_array_3_0/dummy_cell_1rw_16/qb 0.0163f
C1071 control_logic_rw_0/delay_chain_0/pinv_11_39/Z control_logic_rw_0/delay_chain_0/pinv_11_44/Z 0.36079f
C1072 bank_0/replica_bitcell_array_0/dummy_array_2_0/dummy_cell_1rw_11/a_76_76# bank_0/replica_bitcell_array_0/dummy_array_2_0/dummy_cell_1rw_11/a_145_76# 0.06598f
C1073 bank_0/port_address_0/hierarchical_decoder_0/hierarchical_predecode2x4_1/pinv_1/w_n127_244# bank_0/addr0_1 0.2155f
C1074 bank_0/port_address_0/hierarchical_decoder_0/and2_dec_7/pinv_0/w_n127_244# bank_0/port_address_0/hierarchical_decoder_0/predecode_0 0.0212f
C1075 control_logic_rw_0/pinv_3_0/pmos_m1_w0_840_sli_dli_da_p_0/a_0_0# control_logic_rw_0/pinv_3_0/vdd 0.01408f
C1076 row_addr_dff_0/dff_2/net5 bank_0/addr0_1 0.08478f
C1077 bank_0/replica_bitcell_array_0/bitcell_array_0/cell_1rw_18/qb bank_0/replica_bitcell_array_0/replica_column_0/replica_cell_1rw_2/q 0.02064f
C1078 control_logic_rw_0/pdriver_1_0/pinv_8_0/A control_logic_rw_0/pand3_0/gnd 0.16606f
C1079 control_logic_rw_0/pand3_0/C control_logic_rw_0/pand2_1/pdriver_0/pinv_2_0/nmos_m9_w0_560_sli_dli_da_p_0/a_210_0# 0.02034f
C1080 control_logic_rw_0/delay_chain_0/pinv_11_42/Z control_logic_rw_0/delay_chain_0/pinv_11_42/pmos_m1_w0_840_sli_dli_da_p_0/a_54_0# 0.0129f
C1081 control_logic_rw_0/delay_chain_0/pinv_11_43/Z control_logic_rw_0/delay_chain_0/pinv_11_43/pmos_m1_w0_840_sli_dli_da_p_0/a_54_0# 0.0129f
C1082 row_addr_dff_0/dff_3/clkb row_addr_dff_0/dff_3/clk 0.83719f
C1083 bank_0/replica_bitcell_array_0/dummy_array_3_0/dummy_cell_1rw_0/q bank_0/replica_bitcell_array_0/dummy_array_0_0/dummy_cell_1rw_0/qb 0.01651f
C1084 bank_0/replica_bitcell_array_0/dummy_array_2_0/dummy_cell_1rw_14/q bank_0/port_address_0/wl_2 0.04741f
C1085 bank_0/port_address_0/hierarchical_decoder_0/and2_dec_7/pinv_0/pmos_m1_w0_840_sli_dli_da_p_0/a_54_0# bank_0/port_address_0/wordline_driver_array_0/in_8 0.01304f
C1086 bank_0/replica_bitcell_array_0/dummy_array_0/dummy_cell_1rw_1/a_76_76# bank_0/replica_bitcell_array_0/dummy_array_0/dummy_cell_1rw_1/q 0.01645f
C1087 control_logic_rw_0/delay_chain_0/pinv_11_9/w_n127_403# control_logic_rw_0/delay_chain_0/pinv_11_10/Z 0.19711f
C1088 control_logic_rw_0/pand3_0/pdriver_2_0/pinv_9_0/pmos_m7_w1_200_sli_dli_da_p_0/a_0_0# control_logic_rw_0/pinv_3_0/A 0.01962f
C1089 control_logic_rw_0/pinv_3_0/vdd control_logic_rw_0/pinv_3_0/A 0.11118f
C1090 bank_0/port_address_0/hierarchical_decoder_0/and2_dec_15/pinv_0/w_n127_244# bank_0/port_address_0/wl_1 0.16341f
C1091 bank_0/replica_bitcell_array_0/bitcell_array_0/cell_1rw_16/qb bank_0/replica_bitcell_array_0/bitcell_array_0/cell_1rw_16/q 0.28699f
C1092 bank_0/replica_bitcell_array_0/dummy_array_3_0/dummy_cell_1rw_12/qb bank_0/port_address_0/wl_4 0.03696f
C1093 control_logic_rw_0/dff_buf_array_0/dff_buf_0_1/pinv_1_0/gnd control_logic_rw_0/dff_buf_array_0/dff_buf_0_1/dff_0/Q 0.04878f
C1094 control_logic_rw_0/pdriver_0_0/pinv_6_0/pmos_m4_w1_050_sli_dli_da_p_0/a_210_0# control_logic_rw_0/pdriver_0_0/pinv_7_0/A 0.02816f
C1095 control_logic_rw_0/pand2_0/Z control_logic_rw_0/pand2_0/pdriver_0/pinv_2_0/nmos_m9_w0_560_sli_dli_da_p_0/a_132_0# 0.01255f
C1096 bank_0/replica_bitcell_array_0/dummy_array_2_0/dummy_cell_1rw_14/a_145_76# bank_0/replica_bitcell_array_0/dummy_array_2_0/dummy_cell_1rw_14/qb 0.0163f
C1097 bank_0/replica_bitcell_array_0/dummy_array_3_0/dummy_cell_1rw_13/qb bank_0/port_address_0/wl_3 0.03696f
C1098 control_logic_rw_0/delay_chain_0/pinv_11_36/Z control_logic_rw_0/delay_chain_0/pinv_11_44/w_n127_403# 0.20256f
C1099 control_logic_rw_0/pand3_0/pnand3_0_0/pmos_m1_w0_840_sli_dli_0/a_0_0# control_logic_rw_0/pinv_3_0/A 0.0151f
C1100 bank_0/port_address_0/hierarchical_decoder_0/predecode_5 bank_0/wl_en0 0.01162f
C1101 control_logic_rw_0/pand3_0/C control_logic_rw_0/pand2_1/pnand2_0_0/pmos_m1_w0_840_sli_dli_0/a_54_0# 0.02569f
C1102 control_logic_rw_0/pnand2_1_0/w_n127_195# control_logic_rw_0/pinv_3_0/A 1.23321f
C1103 bank_0/port_address_0/hierarchical_decoder_0/predecode_7 bank_0/wl_en0 0.01162f
C1104 bank_0/port_address_0/wl_0 bank_0/replica_bitcell_array_0/dummy_array_3_0/dummy_cell_1rw_16/q 0.04136f
C1105 bank_0/port_address_0/wl_9 bank_0/port_address_0/wl_8 0.03867f
C1106 control_logic_rw_0/dff_buf_array_0/dff_buf_0_1/dff_0/net5 control_logic_rw_0/dff_buf_array_0/dff_buf_0_1/dff_0/clkb 0.03696f
C1107 control_logic_rw_0/pand3_0/pdriver_2_0/pinv_9_0/pmos_m7_w1_200_sli_dli_da_p_0/a_444_0# control_logic_rw_0/pinv_3_0/A 0.0288f
C1108 bank_0/replica_bitcell_array_0/dummy_array_2_0/dummy_cell_1rw_7/qb bank_0/port_address_0/wl_9 0.03923f
C1109 bank_0/replica_bitcell_array_0/replica_column_0/dummy_cell_1rw_1/qb bank_0/replica_bitcell_array_0/dummy_array_1_0/dummy_cell_1rw_1/q 0.01651f
C1110 control_logic_rw_0/delay_chain_0/pinv_11_9/w_n127_403# control_logic_rw_0/delay_chain_0/pinv_11_12/Z 0.20256f
C1111 data_dff_0/dff_1/clkb data_dff_0/dff_1/net2 0.07662f
C1112 bank_0/port_address_0/hierarchical_decoder_0/hierarchical_predecode2x4_0/pinv_1/Z bank_0/addr0_3 0.55145f
C1113 bank_0/replica_bitcell_array_0/dummy_array_3_0/dummy_cell_1rw_13/q bank_0/replica_bitcell_array_0/dummy_array_3_0/dummy_cell_1rw_13/qb 0.28699f
C1114 bank_0/replica_bitcell_array_0/dummy_array_2_0/dummy_cell_1rw_15/a_76_76# bank_0/replica_bitcell_array_0/dummy_array_2_0/dummy_cell_1rw_15/a_145_76# 0.06598f
C1115 row_addr_dff_0/dff_3/clkb addr0[0] 0.30049f
C1116 bank_0/replica_bitcell_array_0/dummy_array_2_0/dummy_cell_1rw_3/a_76_76# bank_0/port_address_0/wl_13 0.05228f
C1117 bank_0/port_address_0/hierarchical_decoder_0/and2_dec_15/pinv_0/w_n127_244# bank_0/port_address_0/hierarchical_decoder_0/predecode_6 0.02963f
C1118 bank_0/replica_bitcell_array_0/dummy_array_2_0/dummy_cell_1rw_9/a_76_76# bank_0/port_address_0/wl_7 0.05228f
C1119 row_addr_dff_0/dff_3/net4 row_addr_dff_0/dff_3/clk 0.15119f
C1120 control_logic_rw_0/pand3_0/C control_logic_rw_0/dff_buf_array_0/dff_buf_0_0/pinv_0_0/nmos_m2_w0_420_sli_dli_da_p_0/a_54_0# 0.01142f
C1121 bank_0/port_address_0/wl_9 bank_0/replica_bitcell_array_0/dummy_array_2_0/dummy_cell_1rw_7/a_145_76# 0.04284f
C1122 control_logic_rw_0/pand3_0/C control_logic_rw_0/pdriver_0_0/pinv_6_0/pmos_m4_w1_050_sli_dli_da_p_0/a_54_0# 0.02469f
C1123 control_logic_rw_0/pand3_0/pdriver_2_0/pinv_9_0/nmos_m7_w0_600_sli_dli_da_p_0/a_54_0# control_logic_rw_0/pand3_0/gnd 0.01184f
C1124 control_logic_rw_0/delay_chain_0/pinv_11_34/w_n127_403# control_logic_rw_0/delay_chain_0/pinv_11_26/Z 0.20256f
C1125 control_logic_rw_0/pand3_0/C control_logic_rw_0/pinv_3_0/A 3.45857f
C1126 control_logic_rw_0/pand3_0/C control_logic_rw_0/pand2_1/pdriver_0/pinv_2_0/nmos_m9_w0_560_sli_dli_da_p_0/a_600_0# 0.01136f
C1127 row_addr_dff_0/dff_2/clkb addr0[1] 0.35334f
C1128 bank_0/port_address_0/wl_11 bank_0/replica_bitcell_array_0/dummy_array_3_0/dummy_cell_1rw_5/a_76_76# 0.05176f
C1129 control_logic_rw_0/pand3_0/C control_logic_rw_0/pinv_3_1/pmos_m1_w0_840_sli_dli_da_p_0/a_54_0# 0.01235f
C1130 bank_0/replica_bitcell_array_0/bitcell_array_0/cell_1rw_27/qb bank_0/replica_bitcell_array_0/replica_column_0/replica_cell_1rw_11/q 0.02064f
C1131 bank_0/port_address_0/hierarchical_decoder_0/and2_dec_7/pinv_0/w_n127_244# bank_0/port_address_0/wl_8 0.16398f
C1132 control_logic_rw_0/delay_chain_0/pinv_11_15/pmos_m1_w0_840_sli_dli_da_p_0/a_54_0# control_logic_rw_0/delay_chain_0/pinv_11_15/Z 0.0129f
C1133 addr0[2] row_addr_dff_0/dff_3/clk 0.19194f
C1134 row_addr_dff_0/dff_3/clkb row_addr_dff_0/dff_3/net5 0.03696f
C1135 bank_0/replica_bitcell_array_0/dummy_array_2_0/dummy_cell_1rw_16/q bank_0/port_address_0/wl_0 0.04741f
C1136 bank_0/replica_bitcell_array_0/dummy_array_3_0/dummy_cell_1rw_2/qb bank_0/replica_bitcell_array_0/dummy_array_3_0/dummy_cell_1rw_2/a_145_76# 0.0163f
C1137 bank_0/replica_bitcell_array_0/dummy_array_3_0/dummy_cell_1rw_6/qb bank_0/port_address_0/wl_10 0.03577f
C1138 bank_0/port_address_0/hierarchical_decoder_0/predecode_0 bank_0/port_address_0/hierarchical_decoder_0/predecode_6 0.5242f
C1139 bank_0/replica_bitcell_array_0/dummy_array_3_0/dummy_cell_1rw_17/qb bank_0/replica_bitcell_array_0/dummy_array_3_0/dummy_cell_1rw_17/q 0.28699f
C1140 control_logic_rw_0/dff_buf_array_0/dff_buf_0_0/dff_0/clkb control_logic_rw_0/dff_buf_array_0/dff_buf_0_0/dff_0/net5 0.03696f
C1141 control_logic_rw_0/delay_chain_0/pinv_11_4/w_n127_403# control_logic_rw_0/pinv_3_0/A 0.7248f
C1142 control_logic_rw_0/delay_chain_0/pinv_11_29/Z control_logic_rw_0/delay_chain_0/pinv_11_34/w_n127_403# 0.75262f
C1143 bank_0/replica_bitcell_array_0/dummy_array_3_0/dummy_cell_1rw_12/q bank_0/replica_bitcell_array_0/dummy_array_3_0/dummy_cell_1rw_12/qb 0.28699f
C1144 bank_0/port_address_0/hierarchical_decoder_0/predecode_2 bank_0/port_address_0/hierarchical_decoder_0/predecode_5 0.42835f
C1145 bank_0/replica_bitcell_array_0/dummy_array_3_0/dummy_cell_1rw_13/q bank_0/port_address_0/wl_3 0.04136f
C1146 bank_0/port_address_0/hierarchical_decoder_0/predecode_2 bank_0/port_address_0/hierarchical_decoder_0/predecode_7 0.42769f
C1147 control_logic_rw_0/delay_chain_0/pinv_11_9/Z control_logic_rw_0/pinv_3_0/A 0.48138f
C1148 control_logic_rw_0/pinv_3_0/pmos_m1_w0_840_sli_dli_da_p_0/a_54_0# control_logic_rw_0/pand3_0/B 0.01615f
C1149 row_addr_dff_0/dff_1/net5 row_addr_dff_0/dff_1/clkb 0.03696f
C1150 bank_0/replica_bitcell_array_0/dummy_array_2_0/dummy_cell_1rw_16/a_145_76# bank_0/replica_bitcell_array_0/dummy_array_2_0/dummy_cell_1rw_16/qb 0.0163f
C1151 bank_0/replica_bitcell_array_0/replica_column_0/replica_cell_1rw_1/q bank_0/port_address_0/wl_14 0.04211f
C1152 control_logic_rw_0/delay_chain_0/pinv_11_0/Z control_logic_rw_0/delay_chain_0/pinv_11_1/Z 0.04321f
C1153 bank_0/replica_bitcell_array_0/dummy_array_3_0/dummy_cell_1rw_6/q bank_0/replica_bitcell_array_0/bitcell_array_0/cell_1rw_5/qb 0.01651f
C1154 bank_0/port_address_0/wl_4 bank_0/port_address_0/wl_5 0.03867f
C1155 bank_0/replica_bitcell_array_0/bitcell_array_0/cell_1rw_16/qb bank_0/replica_bitcell_array_0/replica_column_0/replica_cell_1rw_0/q 0.02064f
C1156 bank_0/p_en_bar0 control_logic_rw_0/pdriver_4_0/pinv_8_0/A 0.0875f
C1157 bank_0/replica_bitcell_array_0/dummy_array_3_0/dummy_cell_1rw_7/a_76_76# bank_0/replica_bitcell_array_0/dummy_array_3_0/dummy_cell_1rw_7/q 0.01645f
C1158 bank_0/port_address_0/hierarchical_decoder_0/and2_dec_9/pinv_0/w_n127_244# bank_0/port_address_0/wordline_driver_array_0/in_7 0.14946f
C1159 bank_0/replica_bitcell_array_0/dummy_array_2_0/dummy_cell_1rw_0/a_145_76# bank_0/replica_bitcell_array_0/dummy_array_2_0/dummy_cell_1rw_0/qb 0.0163f
C1160 bank_0/replica_bitcell_array_0/bitcell_array_0/cell_1rw_20/q bank_0/replica_bitcell_array_0/bitcell_array_0/cell_1rw_4/qb 0.02064f
C1161 bank_0/replica_bitcell_array_0/bitcell_array_0/cell_1rw_28/qb bank_0/replica_bitcell_array_0/bitcell_array_0/cell_1rw_12/q 0.01651f
C1162 bank_0/replica_bitcell_array_0/bitcell_array_0/cell_1rw_28/q bank_0/replica_bitcell_array_0/bitcell_array_0/cell_1rw_12/qb 0.02064f
C1163 bank_0/replica_bitcell_array_0/replica_column_0/replica_cell_1rw_13/q bank_0/replica_bitcell_array_0/bitcell_array_0/cell_1rw_29/qb 0.02064f
C1164 bank_0/port_address_0/wordline_driver_array_0/in_4 bank_0/port_address_0/hierarchical_decoder_0/and2_dec_11/pinv_0/pmos_m1_w0_840_sli_dli_da_p_0/a_54_0# 0.01304f
C1165 bank_0/replica_bitcell_array_0/replica_column_0/replica_cell_1rw_5/q bank_0/replica_bitcell_array_0/bitcell_array_0/cell_1rw_21/qb 0.02064f
C1166 control_logic_rw_0/pand2_0/Z control_logic_rw_0/pand2_0/pdriver_0/pinv_2_0/pmos_m9_w1_120_sli_dli_da_p_0/a_366_0# 0.04117f
C1167 control_logic_rw_0/pand3_0/C control_logic_rw_0/pand2_1/pdriver_0/pinv_2_0/pmos_m9_w1_120_sli_dli_da_p_0/a_0_0# 0.02729f
C1168 bank_0/replica_bitcell_array_0/dummy_array_3_0/dummy_cell_1rw_2/a_76_76# bank_0/replica_bitcell_array_0/dummy_array_3_0/dummy_cell_1rw_2/a_145_76# 0.06598f
C1169 bank_0/replica_bitcell_array_0/replica_column_0/replica_cell_1rw_10/q bank_0/replica_bitcell_array_0/dummy_array_2_0/dummy_cell_1rw_11/qb 0.01651f
C1170 bank_0/replica_bitcell_array_0/dummy_array_2_0/dummy_cell_1rw_11/qb bank_0/replica_bitcell_array_0/dummy_array_2_0/dummy_cell_1rw_11/q 0.28699f
C1171 control_logic_rw_0/delay_chain_0/pinv_11_44/Z control_logic_rw_0/delay_chain_0/pinv_11_43/Z 0.18901f
C1172 bank_0/port_address_0/hierarchical_decoder_0/hierarchical_predecode2x4_0/pinv_1/Z bank_0/port_address_0/hierarchical_decoder_0/hierarchical_predecode2x4_0/pinv_1/pmos_m1_w0_840_sli_dli_da_p_0/a_54_0# 0.01603f
C1173 bank_0/port_address_0/hierarchical_decoder_0/and2_dec_9/pinv_0/w_n127_244# bank_0/port_address_0/wordline_driver_array_0/in_6 0.14989f
C1174 bank_0/replica_bitcell_array_0/dummy_array_2_0/dummy_cell_1rw_17/a_76_76# bank_0/replica_bitcell_array_0/dummy_array_2_0/dummy_cell_1rw_17/a_145_76# 0.06598f
C1175 addr0[2] addr0[0] 1.07497f
C1176 bank_0/port_address_0/wl_11 bank_0/replica_bitcell_array_0/dummy_array_2_0/dummy_cell_1rw_5/qb 0.03803f
C1177 bank_0/port_address_0/wordline_driver_array_0/in_7 bank_0/port_address_0/wordline_driver_array_0/in_6 0.01302f
C1178 control_logic_rw_0/pand2_1/gnd control_logic_rw_0/pinv_3_1/w_n127_195# 0.04814f
C1179 bank_0/replica_bitcell_array_0/dummy_array_2_0/dummy_cell_1rw_1/a_76_76# bank_0/replica_bitcell_array_0/dummy_array_2_0/dummy_cell_1rw_1/a_145_76# 0.06598f
C1180 row_addr_dff_0/dff_3/net5 row_addr_dff_0/dff_3/net4 0.13677f
C1181 bank_0/port_address_0/wl_8 bank_0/replica_bitcell_array_0/bitcell_array_0/cell_1rw_23/qb 0.03704f
C1182 bank_0/replica_bitcell_array_0/bitcell_array_0/cell_1rw_14/qb bank_0/replica_bitcell_array_0/dummy_array_3_0/dummy_cell_1rw_15/q 0.01651f
C1183 bank_0/replica_bitcell_array_0/bitcell_array_0/cell_1rw_14/q bank_0/replica_bitcell_array_0/dummy_array_3_0/dummy_cell_1rw_15/qb 0.02064f
C1184 control_logic_rw_0/delay_chain_0/pinv_11_31/Z control_logic_rw_0/delay_chain_0/pinv_11_32/Z 0.04321f
C1185 control_logic_rw_0/pand3_0/B control_logic_rw_0/dff_buf_array_0/dff_buf_0_1/pinv_1_0/gnd 0.01282f
C1186 bank_0/replica_bitcell_array_0/dummy_array_3_0/dummy_cell_1rw_3/a_145_76# bank_0/port_address_0/wl_13 0.04184f
C1187 data_dff_0/dff_0/net1 data_dff_0/dff_0/net2 0.12728f
C1188 control_logic_rw_0/delay_chain_0/pinv_11_38/Z control_logic_rw_0/delay_chain_0/pinv_11_44/w_n127_403# 0.20256f
C1189 bank_0/replica_bitcell_array_0/bitcell_array_0/cell_1rw_26/qb bank_0/replica_bitcell_array_0/replica_column_0/replica_cell_1rw_10/q 0.02064f
C1190 bank_0/replica_bitcell_array_0/dummy_array_3_0/dummy_cell_1rw_11/q bank_0/port_address_0/wl_5 0.04136f
C1191 control_logic_rw_0/pdriver_4_0/pinv_8_0/pmos_m1_w0_840_sli_dli_da_p_0/a_0_0# control_logic_rw_0/pinv_3_0/A 0.01466f
C1192 control_logic_rw_0/dff_buf_array_0/dff_buf_0_1/pinv_1_0/vdd control_logic_rw_0/dff_buf_array_0/dff_buf_0_0/pinv_1_0/pmos_m3_w1_120_sli_dli_da_p_0/a_0_0# 0.0184f
C1193 bank_0/replica_bitcell_array_0/dummy_array_3_0/dummy_cell_1rw_11/q bank_0/replica_bitcell_array_0/bitcell_array_0/cell_1rw_10/qb 0.01651f
C1194 bank_0/addr0_2 row_addr_dff_0/dff_1/clkb 0.02004f
C1195 bank_0/port_address_0/hierarchical_decoder_0/and2_dec_15/pinv_0/w_n127_244# bank_0/port_address_0/wordline_driver_array_0/in_1 0.14946f
C1196 control_logic_rw_0/delay_chain_0/pinv_11_24/Z control_logic_rw_0/delay_chain_0/pinv_11_21/Z 0.14223f
C1197 row_addr_dff_0/dff_3/net2 row_addr_dff_0/dff_3/clk 0.07175f
C1198 bank_0/replica_bitcell_array_0/replica_column_0/replica_cell_1rw_9/q bank_0/port_address_0/wl_6 0.04211f
C1199 control_logic_rw_0/dff_buf_array_0/dff_buf_0_1/pinv_1_0/w_n127_195# control_logic_rw_0/dff_buf_array_0/dff_buf_0_0/dff_0/Q 0.13968f
C1200 control_logic_rw_0/pand3_0/pdriver_2_0/pinv_9_0/nmos_m7_w0_600_sli_dli_da_p_0/a_366_0# control_logic_rw_0/pand3_0/gnd 0.01158f
C1201 bank_0/port_address_0/hierarchical_decoder_0/and2_dec_7/pinv_0/w_n127_244# bank_0/wl_en0 0.29624f
C1202 control_logic_rw_0/pand3_0/C control_logic_rw_0/pand2_1/pdriver_0/pinv_2_0/pmos_m9_w1_120_sli_dli_da_p_0/a_132_0# 0.05646f
C1203 bank_0/replica_bitcell_array_0/replica_column_0/dummy_cell_1rw_0/q bank_0/replica_bitcell_array_0/dummy_array_0_0/dummy_cell_1rw_1/qb 0.02064f
C1204 bank_0/replica_bitcell_array_0/bitcell_array_0/cell_1rw_14/qb bank_0/replica_bitcell_array_0/bitcell_array_0/cell_1rw_30/q 0.02064f
C1205 bank_0/replica_bitcell_array_0/dummy_array_1_0/dummy_cell_1rw_0/q bank_0/replica_bitcell_array_0/dummy_array_1_0/dummy_cell_1rw_1/qb 0.01651f
C1206 bank_0/port_address_0/wl_7 bank_0/port_address_0/wl_6 0.03867f
C1207 bank_0/port_address_0/wordline_driver_array_0/wordline_driver_7/pinv_0/pmos_m1_w0_840_sli_dli_da_p_0/a_54_0# bank_0/port_address_0/wl_8 0.01304f
C1208 control_logic_rw_0/delay_chain_0/pinv_11_34/w_n127_403# control_logic_rw_0/delay_chain_0/pinv_11_31/Z 0.20256f
C1209 control_logic_rw_0/pand2_1/gnd control_logic_rw_0/pdriver_1_0/w_n127_195# 0.07492f
C1210 control_logic_rw_0/pand2_0/Z control_logic_rw_0/pand3_0/B 0.06664f
C1211 bank_0/replica_bitcell_array_0/dummy_array_2_0/dummy_cell_1rw_15/qb bank_0/replica_bitcell_array_0/dummy_array_2_0/dummy_cell_1rw_15/q 0.28699f
C1212 row_addr_dff_0/dff_1/net4 row_addr_dff_0/dff_3/clk 0.15111f
C1213 control_logic_rw_0/pdriver_0_0/pinv_5_0/Z control_logic_rw_0/pdriver_0_0/gnd 0.18149f
C1214 control_logic_rw_0/pand3_0/C control_logic_rw_0/pand2_1/pdriver_0/pinv_2_0/nmos_m9_w0_560_sli_dli_da_p_0/a_54_0# 0.01778f
C1215 bank_0/port_address_0/wordline_driver_array_0/in_15 bank_0/port_address_0/hierarchical_decoder_0/and2_dec_1/pinv_0/w_n127_244# 0.14946f
C1216 bank_0/replica_bitcell_array_0/bitcell_array_0/cell_1rw_26/qb bank_0/replica_bitcell_array_0/bitcell_array_0/cell_1rw_26/q 0.28699f
C1217 bank_0/replica_bitcell_array_0/bitcell_array_0/cell_1rw_27/qb bank_0/port_address_0/wl_4 0.03704f
C1218 bank_0/port_address_0/wordline_driver_array_0/in_14 bank_0/wl_en0 0.18688f
C1219 control_logic_rw_0/pand3_0/pdriver_2_0/pinv_9_0/pmos_m7_w1_200_sli_dli_da_p_0/a_132_0# control_logic_rw_0/pinv_3_0/A 0.02856f
C1220 control_logic_rw_0/delay_chain_0/pinv_11_23/Z control_logic_rw_0/delay_chain_0/pinv_11_24/Z 0.18901f
C1221 control_logic_rw_0/pdriver_1_0/pinv_4_0/nmos_m2_w0_420_sli_dli_da_p_0/a_54_0# control_logic_rw_0/pdriver_1_0/pinv_6_0/A 0.01144f
C1222 control_logic_rw_0/pdriver_0_0/gnd control_logic_rw_0/pdriver_0_0/pinv_7_0/nmos_m11_w0_570_sli_dli_da_p_0/a_0_0# 0.01117f
C1223 bank_0/replica_bitcell_array_0/dummy_array_0_0/dummy_cell_1rw_1/qb bank_0/replica_bitcell_array_0/dummy_array_0_0/dummy_cell_1rw_1/q 0.28699f
C1224 bank_0/port_address_0/hierarchical_decoder_0/hierarchical_predecode2x4_0/and2_dec_3/pinv_0/w_n127_244# bank_0/addr0_2 0.02155f
C1225 bank_0/port_address_0/hierarchical_decoder_0/hierarchical_predecode2x4_1/pinv_1/Z bank_0/addr0_1 0.55118f
C1226 control_logic_rw_0/pand3_0/C control_logic_rw_0/pdriver_0_0/pinv_7_0/pmos_m11_w1_150_sli_dli_da_p_0/a_210_0# 0.02257f
C1227 bank_0/port_address_0/wl_13 bank_0/port_address_0/wl_12 0.03867f
C1228 bank_0/replica_bitcell_array_0/bitcell_array_0/cell_1rw_4/q bank_0/port_address_0/wl_11 0.04136f
C1229 row_addr_dff_0/dff_2/clkb row_addr_dff_0/dff_2/net4 0.08731f
C1230 control_logic_rw_0/pand2_1/A control_logic_rw_0/pinv_3_1/w_n127_195# 0.1823f
C1231 control_logic_rw_0/pand2_1/gnd control_logic_rw_0/pand2_1/pdriver_0/pinv_2_0/nmos_m9_w0_560_sli_dli_da_p_0/a_288_0# 0.01788f
C1232 bank_0/port_address_0/hierarchical_decoder_0/hierarchical_predecode2x4_1/and2_dec_1/pinv_0/pmos_m1_w0_840_sli_dli_da_p_0/a_54_0# bank_0/port_address_0/hierarchical_decoder_0/predecode_2 0.01459f
C1233 row_addr_dff_0/dff_0/net2 row_addr_dff_0/dff_0/net3 0.03271f
C1234 bank_0/replica_bitcell_array_0/dummy_array_3_0/dummy_cell_1rw_3/a_76_76# bank_0/port_address_0/wl_13 0.05176f
C1235 bank_0/replica_bitcell_array_0/dummy_array_3_0/dummy_cell_1rw_3/a_76_76# bank_0/replica_bitcell_array_0/dummy_array_3_0/dummy_cell_1rw_3/q 0.01645f
C1236 control_logic_rw_0/delay_chain_0/pinv_11_33/Z control_logic_rw_0/delay_chain_0/pinv_11_33/pmos_m1_w0_840_sli_dli_da_p_0/a_54_0# 0.0129f
C1237 bank_0/port_address_0/hierarchical_decoder_0/and2_dec_7/pinv_0/w_n127_244# bank_0/port_address_0/wordline_driver_array_0/in_8 0.14989f
C1238 control_logic_rw_0/pand3_0/C control_logic_rw_0/pand2_1/gnd 1.03111f
C1239 control_logic_rw_0/pdriver_1_0/pinv_6_0/pmos_m4_w1_050_sli_dli_da_p_0/a_132_0# bank_0/wl_en0 0.02574f
C1240 control_logic_rw_0/pand3_0/C control_logic_rw_0/pand2_1/pdriver_0/pinv_2_0/nmos_m9_w0_560_sli_dli_da_p_0/a_366_0# 0.023f
C1241 row_addr_dff_0/dff_0/clkb row_addr_dff_0/dff_3/clk 0.83283f
C1242 bank_0/replica_bitcell_array_0/dummy_array_3_0/dummy_cell_1rw_0/q bank_0/replica_bitcell_array_0/dummy_array_3_0/dummy_cell_1rw_0/a_76_76# 0.01645f
C1243 control_logic_rw_0/delay_chain_0/pinv_11_9/w_n127_403# control_logic_rw_0/delay_chain_0/pinv_11_11/Z 0.20256f
C1244 bank_0/replica_bitcell_array_0/bitcell_array_0/cell_1rw_30/qb bank_0/port_address_0/wl_1 0.03704f
C1245 bank_0/replica_bitcell_array_0/bitcell_array_0/cell_1rw_25/qb bank_0/replica_bitcell_array_0/bitcell_array_0/cell_1rw_25/q 0.28699f
C1246 control_logic_rw_0/pand3_0/pdriver_2_0/pinv_9_0/pmos_m7_w1_200_sli_dli_da_p_0/a_522_0# control_logic_rw_0/pinv_3_0/A 0.01376f
C1247 bank_0/p_en_bar0 bank_0/port_data_0/precharge_array_0/precharge_0_2/w_0_0# 0.37311f
C1248 bank_0/replica_bitcell_array_0/bitcell_array_0/cell_1rw_7/qb bank_0/port_address_0/wl_8 0.03696f
C1249 control_logic_rw_0/pand3_0/C control_logic_rw_0/pdriver_1_0/pinv_8_0/pmos_m1_w0_840_sli_dli_da_p_0/a_0_0# 0.01465f
C1250 bank_0/replica_bitcell_array_0/dummy_array_2_0/dummy_cell_1rw_7/q bank_0/port_address_0/wl_9 0.0474f
C1251 control_logic_rw_0/pand2_0/Z control_logic_rw_0/pand2_0/pdriver_0/pinv_2_0/pmos_m9_w1_120_sli_dli_da_p_0/a_678_0# 0.01862f
C1252 control_logic_rw_0/delay_chain_0/pinv_11_44/w_n127_403# control_logic_rw_0/delay_chain_0/pinv_11_37/Z 0.20256f
C1253 bank_0/replica_bitcell_array_0/dummy_array_3_0/dummy_cell_1rw_5/a_76_76# bank_0/replica_bitcell_array_0/dummy_array_3_0/dummy_cell_1rw_5/a_145_76# 0.06598f
C1254 control_logic_rw_0/delay_chain_0/pinv_11_18/Z control_logic_rw_0/delay_chain_0/pinv_11_18/pmos_m1_w0_840_sli_dli_da_p_0/a_54_0# 0.0129f
C1255 data_dff_0/dff_1/clkb data_dff_0/dff_1/net5 0.03696f
C1256 data_dff_0/dff_1/net3 data_dff_0/dff_1/net2 0.03271f
C1257 bank_0/replica_bitcell_array_0/bitcell_array_0/cell_1rw_18/qb bank_0/replica_bitcell_array_0/bitcell_array_0/cell_1rw_2/q 0.01651f
C1258 row_addr_dff_0/dff_2/clkb bank_0/addr0_1 0.02004f
C1259 bank_0/port_address_0/wl_8 bank_0/replica_bitcell_array_0/replica_column_0/replica_cell_1rw_7/q 0.04211f
C1260 control_logic_rw_0/pand3_0/C control_logic_rw_0/pand2_1/pdriver_0/pinv_2_0/pmos_m9_w1_120_sli_dli_da_p_0/a_366_0# 0.06887f
C1261 bank_0/replica_bitcell_array_0/replica_column_0/replica_cell_1rw_0/q bank_0/replica_bitcell_array_0/dummy_array_2_0/dummy_cell_1rw_1/qb 0.01651f
C1262 bank_0/port_address_0/hierarchical_decoder_0/predecode_7 bank_0/port_address_0/hierarchical_decoder_0/predecode_5 0.17274f
C1263 bank_0/port_address_0/hierarchical_decoder_0/predecode_0 bank_0/port_address_0/hierarchical_decoder_0/hierarchical_predecode2x4_0/and2_dec_1/pinv_0/w_n127_244# 0.16776f
C1264 bank_0/replica_bitcell_array_0/dummy_array_3_0/dummy_cell_1rw_6/qb bank_0/replica_bitcell_array_0/dummy_array_3_0/dummy_cell_1rw_6/a_145_76# 0.0163f
C1265 row_addr_dff_0/dff_1/net2 row_addr_dff_0/dff_1/net3 0.03271f
C1266 control_logic_rw_0/pand3_0/C control_logic_rw_0/pdriver_0_0/pinv_7_0/pmos_m11_w1_150_sli_dli_da_p_0/a_600_0# 0.02761f
C1267 bank_0/replica_bitcell_array_0/dummy_array_3_0/dummy_cell_1rw_1/a_145_76# bank_0/port_address_0/wl_15 0.04184f
C1268 control_logic_rw_0/pand2_1/gnd control_logic_rw_0/pand2_0/pnand2_0_0/nmos_m1_w0_840_sli_dactive_0/D 0.01443f
C1269 control_logic_rw_0/pand2_1/gnd control_logic_rw_0/pand2_1/pdriver_0/pinv_2_0/nmos_m9_w0_560_sli_dli_da_p_0/a_522_0# 0.01066f
C1270 bank_0/replica_bitcell_array_0/bitcell_array_0/cell_1rw_20/qb bank_0/replica_bitcell_array_0/bitcell_array_0/cell_1rw_20/q 0.28699f
C1271 bank_0/replica_bitcell_array_0/bitcell_array_0/cell_1rw_24/qb bank_0/replica_bitcell_array_0/bitcell_array_0/cell_1rw_24/q 0.28699f
C1272 row_addr_dff_0/dff_3/clkb row_addr_dff_0/dff_3/net1 0.1543f
C1273 bank_0/replica_bitcell_array_0/replica_column_0/dummy_cell_1rw_1/a_145_76# bank_0/replica_bitcell_array_0/replica_column_0/dummy_cell_1rw_1/qb 0.0163f
C1274 bank_0/replica_bitcell_array_0/dummy_array_3_0/dummy_cell_1rw_8/a_145_76# bank_0/port_address_0/wl_8 0.04184f
C1275 control_logic_rw_0/delay_chain_0/pinv_11_28/Z control_logic_rw_0/delay_chain_0/pinv_11_28/pmos_m1_w0_840_sli_dli_da_p_0/a_54_0# 0.0129f
C1276 bank_0/replica_bitcell_array_0/dummy_array_2_0/dummy_cell_1rw_17/qb bank_0/replica_bitcell_array_0/dummy_array_2_0/dummy_cell_1rw_17/q 0.28699f
C1277 bank_0/port_address_0/hierarchical_decoder_0/predecode_6 bank_0/wl_en0 0.01162f
C1278 bank_0/replica_bitcell_array_0/dummy_array_2_0/dummy_cell_1rw_3/a_76_76# bank_0/replica_bitcell_array_0/dummy_array_2_0/dummy_cell_1rw_3/a_145_76# 0.06598f
C1279 control_logic_rw_0/pand3_0/C control_logic_rw_0/pand2_1/A 0.30859f
C1280 bank_0/replica_bitcell_array_0/dummy_array_2_0/dummy_cell_1rw_9/a_76_76# bank_0/replica_bitcell_array_0/dummy_array_2_0/dummy_cell_1rw_9/a_145_76# 0.06598f
C1281 bank_0/replica_bitcell_array_0/bitcell_array_0/cell_1rw_0/qb bank_0/replica_bitcell_array_0/bitcell_array_0/cell_1rw_0/q 0.28699f
C1282 control_logic_rw_0/pand2_0/pdriver_0/pinv_2_0/nmos_m9_w0_560_sli_dli_da_p_0/a_288_0# control_logic_rw_0/pand2_1/gnd 0.01788f
C1283 bank_0/replica_bitcell_array_0/dummy_array_2_0/dummy_cell_1rw_1/qb bank_0/replica_bitcell_array_0/dummy_array_2_0/dummy_cell_1rw_1/q 0.28699f
C1284 control_logic_rw_0/delay_chain_0/pinv_11_44/Z control_logic_rw_0/pinv_3_0/A 0.11074f
C1285 bank_0/replica_bitcell_array_0/dummy_array_3_0/dummy_cell_1rw_8/a_145_76# bank_0/replica_bitcell_array_0/dummy_array_3_0/dummy_cell_1rw_8/qb 0.0163f
C1286 control_logic_rw_0/pand3_0/B control_logic_rw_0/pand3_0/gnd 0.01541f
C1287 control_logic_rw_0/pand3_0/C control_logic_rw_0/pand2_0/pdriver_0/pinv_2_0/pmos_m9_w1_120_sli_dli_da_p_0/a_132_0# 0.02754f
C1288 bank_0/port_address_0/wl_11 bank_0/port_address_0/wl_10 0.03867f
C1289 bank_0/replica_bitcell_array_0/dummy_array_3_0/dummy_cell_1rw_6/q bank_0/port_address_0/wl_10 0.04009f
C1290 bank_0/replica_bitcell_array_0/dummy_array_2_0/dummy_cell_1rw_13/a_145_76# bank_0/port_address_0/wl_3 0.04284f
C1291 bank_0/port_address_0/hierarchical_decoder_0/and2_dec_13/pinv_0/w_n127_244# bank_0/wl_en0 0.29624f
C1292 addr0[1] addr0[2] 0.23703f
C1293 control_logic_rw_0/pdriver_1_0/pinv_6_0/nmos_m4_w0_520_sli_dli_da_p_0/a_0_0# control_logic_rw_0/pand3_0/gnd 0.01038f
C1294 bank_0/replica_bitcell_array_0/dummy_array_2_0/dummy_cell_1rw_2/a_76_76# bank_0/replica_bitcell_array_0/dummy_array_2_0/dummy_cell_1rw_2/q 0.01645f
C1295 control_logic_rw_0/pdriver_0_0/gnd control_logic_rw_0/pdriver_0_0/pinv_7_0/nmos_m11_w0_570_sli_dli_da_p_0/a_600_0# 0.01807f
C1296 control_logic_rw_0/dff_buf_array_0/dff_buf_0_0/dff_0/clkb control_logic_rw_0/dff_buf_array_0/dff_buf_0_0/dff_0/net4 0.08731f
C1297 bank_0/addr0_3 row_addr_dff_0/dff_0/net4 0.22447f
C1298 control_logic_rw_0/dff_buf_array_0/dff_buf_0_1/pinv_1_0/vdd control_logic_rw_0/dff_buf_array_0/dff_buf_0_1/pinv_1_0/gnd 0.0233f
C1299 bank_0/port_address_0/hierarchical_decoder_0/predecode_4 bank_0/port_address_0/hierarchical_decoder_0/hierarchical_predecode2x4_1/and2_dec_1/pinv_0/w_n127_244# 0.0127f
C1300 bank_0/replica_bitcell_array_0/bitcell_array_0/cell_1rw_2/q bank_0/replica_bitcell_array_0/dummy_array_3_0/dummy_cell_1rw_3/qb 0.02064f
C1301 bank_0/port_address_0/wordline_driver_array_0/in_12 bank_0/wl_en0 0.18688f
C1302 control_logic_rw_0/dff_buf_array_0/dff_buf_0_0/dff_0/net3 control_logic_rw_0/dff_buf_array_0/dff_buf_0_0/dff_0/clkb 0.14179f
C1303 row_addr_dff_0/dff_1/net2 row_addr_dff_0/dff_1/clkb 0.07662f
C1304 bank_0/replica_bitcell_array_0/bitcell_array_0/cell_1rw_9/qb bank_0/port_address_0/wl_6 0.03696f
C1305 control_logic_rw_0/pand2_1/gnd control_logic_rw_0/pand2_0/pnand2_0_0/nmos_m1_w0_840_sli_dactive_0/a_0_0# 0.01544f
C1306 bank_0/port_address_0/hierarchical_decoder_0/hierarchical_predecode2x4_1/pinv_1/w_n127_244# bank_0/port_address_0/hierarchical_decoder_0/hierarchical_predecode2x4_1/pinv_0/Z 0.19953f
C1307 bank_0/port_address_0/hierarchical_decoder_0/hierarchical_predecode2x4_1/pinv_1/Z bank_0/port_address_0/hierarchical_decoder_0/hierarchical_predecode2x4_1/and2_dec_3/pinv_0/w_n127_244# 0.0452f
C1308 bank_0/replica_bitcell_array_0/dummy_array_2_0/dummy_cell_1rw_11/qb bank_0/port_address_0/wl_5 0.03923f
C1309 control_logic_rw_0/delay_chain_0/pinv_11_44/Z control_logic_rw_0/delay_chain_0/pinv_11_44/w_n127_403# 1.16277f
C1310 row_addr_dff_0/dff_3/clk addr0[0] 0.2923f
C1311 control_logic_rw_0/delay_chain_0/pinv_11_30/Z control_logic_rw_0/delay_chain_0/pinv_11_34/Z 0.11884f
C1312 control_logic_rw_0/pand2_0/Z control_logic_rw_0/pand2_0/pdriver_0/pinv_2_0/nmos_m9_w0_560_sli_dli_da_p_0/a_366_0# 0.02356f
C1313 bank_0/port_address_0/wl_1 bank_0/replica_bitcell_array_0/dummy_array_3_0/dummy_cell_1rw_15/a_145_76# 0.04184f
C1314 control_logic_rw_0/delay_chain_0/pinv_11_3/Z control_logic_rw_0/delay_chain_0/pinv_11_2/Z 0.04321f
C1315 control_logic_rw_0/dff_buf_array_0/dff_buf_0_0/pinv_1_0/nmos_m3_w0_560_sli_dli_da_p_0/a_54_0# control_logic_rw_0/pand3_0_0/C 0.0212f
C1316 bank_0/port_address_0/hierarchical_decoder_0/predecode_2 bank_0/port_address_0/hierarchical_decoder_0/predecode_6 0.41211f
C1317 control_logic_rw_0/dff_buf_array_0/dff_buf_0_0/pinv_1_0/pmos_m3_w1_120_sli_dli_da_p_0/a_54_0# control_logic_rw_0/pand3_0_0/C 0.02737f
C1318 bank_0/port_address_0/wl_8 bank_0/replica_bitcell_array_0/bitcell_array_0/cell_1rw_23/q 0.04155f
C1319 bank_0/port_address_0/hierarchical_decoder_0/predecode_0 bank_0/port_address_0/hierarchical_decoder_0/hierarchical_predecode2x4_1/and2_dec_3/pinv_0/pmos_m1_w0_840_sli_dli_da_p_0/a_54_0# 0.01565f
C1320 control_logic_rw_0/dff_buf_array_0/dff_buf_0_1/pinv_1_0/vdd control_logic_rw_0/dff_buf_array_0/dff_buf_0_0/pinv_1_0/pmos_m3_w1_120_sli_dli_da_p_0/a_54_0# 0.02305f
C1321 bank_0/replica_bitcell_array_0/bitcell_array_0/cell_1rw_16/qb bank_0/port_address_0/wl_15 0.03704f
C1322 bank_0/port_address_0/wordline_driver_array_0/in_3 bank_0/wl_en0 0.18688f
C1323 bank_0/replica_bitcell_array_0/bitcell_array_0/cell_1rw_15/q bank_0/replica_bitcell_array_0/dummy_array_3_0/dummy_cell_1rw_16/qb 0.02064f
C1324 bank_0/replica_bitcell_array_0/bitcell_array_0/cell_1rw_15/qb bank_0/replica_bitcell_array_0/dummy_array_3_0/dummy_cell_1rw_16/q 0.01651f
C1325 control_logic_rw_0/pand2_0/Z control_logic_rw_0/pand3_0_0/C 0.14938f
C1326 bank_0/replica_bitcell_array_0/replica_column_0/dummy_cell_1rw_1/q bank_0/replica_bitcell_array_0/dummy_array_1_0/dummy_cell_1rw_1/qb 0.02064f
C1327 control_logic_rw_0/delay_chain_0/pinv_11_6/Z control_logic_rw_0/delay_chain_0/pinv_11_9/Z 0.14223f
C1328 control_logic_rw_0/pdriver_4_0/pinv_8_0/pmos_m1_w0_840_sli_dli_da_p_0/a_54_0# bank_0/p_en_bar0 0.01532f
C1329 bank_0/replica_bitcell_array_0/bitcell_array_0/cell_1rw_21/qb bank_0/port_address_0/wl_10 0.03704f
C1330 bank_0/replica_bitcell_array_0/bitcell_array_0/cell_1rw_26/qb bank_0/port_address_0/wl_5 0.03704f
C1331 bank_0/port_address_0/hierarchical_decoder_0/predecode_1 bank_0/port_address_0/hierarchical_decoder_0/predecode_4 0.4859f
C1332 control_logic_rw_0/pinv_3_0/A control_logic_rw_0/pnand2_1_0/pmos_m1_w0_840_sli_dli_1/a_0_0# 0.02086f
C1333 bank_0/replica_bitcell_array_0/dummy_array_3_0/dummy_cell_1rw_1/q bank_0/replica_bitcell_array_0/bitcell_array_0/cell_1rw_0/qb 0.01651f
C1334 bank_0/port_address_0/wordline_driver_array_0/in_9 bank_0/port_address_0/wordline_driver_array_0/in_10 0.01362f
C1335 row_addr_dff_0/dff_3/net5 row_addr_dff_0/dff_3/clk 0.03761f
C1336 bank_0/port_address_0/hierarchical_decoder_0/predecode_2 bank_0/port_address_0/hierarchical_decoder_0/and2_dec_13/pinv_0/w_n127_244# 0.02587f
C1337 bank_0/port_address_0/hierarchical_decoder_0/predecode_0 bank_0/port_address_0/hierarchical_decoder_0/hierarchical_predecode2x4_1/and2_dec_3/pinv_0/w_n127_244# 0.31967f
C1338 bank_0/port_address_0/hierarchical_decoder_0/and2_dec_5/pinv_0/w_n127_244# bank_0/wl_en0 0.29624f
C1339 bank_0/replica_bitcell_array_0/dummy_array_1_0/dummy_cell_1rw_0/qb bank_0/replica_bitcell_array_0/dummy_array_1_0/dummy_cell_1rw_1/q 0.02064f
C1340 control_logic_rw_0/pand3_0/pdriver_2_0/pinv_9_0/nmos_m7_w0_600_sli_dli_da_p_0/a_444_0# control_logic_rw_0/pand3_0/gnd 0.01901f
C1341 control_logic_rw_0/delay_chain_0/pinv_11_22/Z control_logic_rw_0/delay_chain_0/pinv_11_24/Z 0.14367f
C1342 bank_0/replica_bitcell_array_0/dummy_array_3_0/dummy_cell_1rw_5/qb bank_0/replica_bitcell_array_0/dummy_array_3_0/dummy_cell_1rw_5/q 0.28699f
C1343 bank_0/replica_bitcell_array_0/dummy_array_2_0/dummy_cell_1rw_10/a_76_76# bank_0/replica_bitcell_array_0/dummy_array_2_0/dummy_cell_1rw_10/q 0.01645f
C1344 bank_0/port_address_0/wordline_driver_array_0/in_1 bank_0/wl_en0 0.18736f
C1345 bank_0/replica_bitcell_array_0/dummy_array_3_0/dummy_cell_1rw_10/q bank_0/port_address_0/wl_6 0.04136f
C1346 control_logic_rw_0/pand3_0/pdriver_2_0/pinv_9_0/pmos_m7_w1_200_sli_dli_da_p_0/a_54_0# control_logic_rw_0/pinv_3_0/A 0.02463f
C1347 control_logic_rw_0/pdriver_1_0/pinv_6_0/pmos_m4_w1_050_sli_dli_da_p_0/a_210_0# bank_0/wl_en0 0.02963f
C1348 control_logic_rw_0/delay_chain_0/pinv_11_5/Z control_logic_rw_0/pinv_3_0/A 0.04231f
C1349 bank_0/port_address_0/wl_14 bank_0/replica_bitcell_array_0/dummy_array_2_0/dummy_cell_1rw_2/a_145_76# 0.04284f
C1350 control_logic_rw_0/delay_chain_0/pinv_11_16/Z control_logic_rw_0/delay_chain_0/pinv_11_19/Z 0.14232f
C1351 bank_0/replica_bitcell_array_0/bitcell_array_0/cell_1rw_27/q bank_0/port_address_0/wl_4 0.04155f
C1352 control_logic_rw_0/pnand2_1_0/w_n127_195# bank_0/p_en_bar0 0.24922f
C1353 bank_0/port_address_0/hierarchical_decoder_0/and2_dec_7/pinv_0/w_n127_244# bank_0/port_address_0/hierarchical_decoder_0/predecode_7 0.20528f
C1354 bank_0/replica_bitcell_array_0/dummy_array_3_0/dummy_cell_1rw_14/a_145_76# bank_0/port_address_0/wl_2 0.04184f
C1355 control_logic_rw_0/delay_chain_0/pinv_11_24/w_n127_403# control_logic_rw_0/delay_chain_0/pinv_11_24/Z 1.16289f
C1356 control_logic_rw_0/pdriver_0_0/pinv_5_0/Z control_logic_rw_0/pinv_3_1/w_n127_195# 0.1671f
C1357 bank_0/replica_bitcell_array_0/dummy_array_3_0/dummy_cell_1rw_4/qb bank_0/port_address_0/wl_12 0.03696f
C1358 bank_0/replica_bitcell_array_0/dummy_array_3_0/dummy_cell_1rw_9/a_76_76# bank_0/replica_bitcell_array_0/dummy_array_3_0/dummy_cell_1rw_9/q 0.01645f
C1359 control_logic_rw_0/pand3_0/C control_logic_rw_0/pdriver_1_0/pinv_5_0/pmos_m1_w0_840_sli_dli_da_p_0/a_54_0# 0.01116f
C1360 bank_0/replica_bitcell_array_0/dummy_array_2_0/dummy_cell_1rw_3/qb bank_0/replica_bitcell_array_0/dummy_array_2_0/dummy_cell_1rw_3/q 0.28699f
C1361 bank_0/port_address_0/hierarchical_decoder_0/and2_dec_3/pinv_0/w_n127_244# bank_0/port_address_0/wl_12 0.16398f
C1362 bank_0/replica_bitcell_array_0/dummy_array_2_0/dummy_cell_1rw_9/qb bank_0/replica_bitcell_array_0/dummy_array_2_0/dummy_cell_1rw_9/q 0.28699f
C1363 control_logic_rw_0/delay_chain_0/pinv_11_22/Z control_logic_rw_0/delay_chain_0/pinv_11_21/Z 0.04321f
C1364 control_logic_rw_0/pand3_0/C control_logic_rw_0/pand2_0/pdriver_0/pinv_2_0/pmos_m9_w1_120_sli_dli_da_p_0/a_0_0# 0.02166f
C1365 control_logic_rw_0/pand3_0_0/gnd control_logic_rw_0/pand3_0_0/C 0.12043f
C1366 bank_0/replica_bitcell_array_0/replica_column_0/dummy_cell_1rw_1/a_145_76# bank_0/replica_bitcell_array_0/replica_column_0/dummy_cell_1rw_1/a_76_76# 0.06598f
C1367 control_logic_rw_0/delay_chain_0/pinv_11_3/pmos_m1_w0_840_sli_dli_da_p_0/a_54_0# control_logic_rw_0/delay_chain_0/pinv_11_3/Z 0.0129f
C1368 bank_0/replica_bitcell_array_0/dummy_array_2_0/dummy_cell_1rw_14/a_145_76# bank_0/port_address_0/wl_2 0.04284f
C1369 bank_0/port_address_0/wl_1 bank_0/port_address_0/wl_2 0.13236f
C1370 row_addr_dff_0/dff_3/net2 row_addr_dff_0/dff_3/net1 0.12728f
C1371 control_logic_rw_0/pand3_0/B control_logic_rw_0/dff_buf_array_0/dout_0 0.03374f
C1372 control_logic_rw_0/pand3_0/pdriver_2_0/pinv_9_0/pmos_m7_w1_200_sli_dli_da_p_0/a_366_0# control_logic_rw_0/pinv_3_0/A 0.02356f
C1373 row_addr_dff_0/dff_1/net1 row_addr_dff_0/dff_1/net3 0.14299f
C1374 control_logic_rw_0/delay_chain_0/pinv_11_6/pmos_m1_w0_840_sli_dli_da_p_0/a_54_0# control_logic_rw_0/delay_chain_0/pinv_11_6/Z 0.0129f
C1375 addr0[1] row_addr_dff_0/dff_0/clkb 0.01915f
C1376 bank_0/replica_bitcell_array_0/dummy_array_2_0/dummy_cell_1rw_4/a_76_76# bank_0/replica_bitcell_array_0/dummy_array_2_0/dummy_cell_1rw_4/q 0.01645f
C1377 bank_0/replica_bitcell_array_0/bitcell_array_0/cell_1rw_4/qb bank_0/replica_bitcell_array_0/dummy_array_3_0/dummy_cell_1rw_5/q 0.01651f
C1378 control_logic_rw_0/delay_chain_0/pinv_11_24/w_n127_403# control_logic_rw_0/delay_chain_0/pinv_11_21/Z 0.20256f
C1379 bank_0/port_address_0/hierarchical_decoder_0/predecode_0 bank_0/port_address_0/hierarchical_decoder_0/and2_dec_3/pinv_0/w_n127_244# 0.02797f
C1380 control_logic_rw_0/delay_chain_0/pinv_11_24/Z control_logic_rw_0/pinv_3_0/A 0.10996f
C1381 data_dff_0/dff_1/net1 data_dff_0/dff_1/net2 0.12728f
C1382 control_logic_rw_0/delay_chain_0/pinv_11_9/A control_logic_rw_0/pinv_3_0/A 0.10996f
C1383 bank_0/port_address_0/hierarchical_decoder_0/predecode_2 bank_0/port_address_0/hierarchical_decoder_0/and2_dec_5/pinv_0/w_n127_244# 0.0212f
C1384 control_logic_rw_0/delay_chain_0/pinv_11_24/w_n127_403# control_logic_rw_0/delay_chain_0/pinv_11_18/Z 0.20256f
C1385 bank_0/replica_bitcell_array_0/dummy_array_3_0/dummy_cell_1rw_0/q bank_0/replica_bitcell_array_0/dummy_array_3_0/dummy_cell_1rw_0/qb 0.28699f
C1386 bank_0/replica_bitcell_array_0/dummy_array_3_0/dummy_cell_1rw_10/a_145_76# bank_0/replica_bitcell_array_0/dummy_array_3_0/dummy_cell_1rw_10/a_76_76# 0.06598f
C1387 control_logic_rw_0/delay_chain_0/pinv_11_23/Z control_logic_rw_0/delay_chain_0/pinv_11_22/Z 0.04321f
C1388 row_addr_dff_0/dff_0/clkb row_addr_dff_0/dff_0/net2 0.07662f
C1389 bank_0/replica_bitcell_array_0/dummy_array_3_0/dummy_cell_1rw_8/q bank_0/replica_bitcell_array_0/bitcell_array_0/cell_1rw_7/qb 0.01651f
C1390 bank_0/replica_bitcell_array_0/replica_column_0/replica_cell_1rw_6/q bank_0/replica_bitcell_array_0/dummy_array_2_0/dummy_cell_1rw_7/qb 0.01651f
C1391 bank_0/port_address_0/wl_0 bank_0/replica_bitcell_array_0/dummy_array_3_0/dummy_cell_1rw_16/a_145_76# 0.04184f
C1392 bank_0/replica_bitcell_array_0/dummy_array_3_0/dummy_cell_1rw_1/q bank_0/replica_bitcell_array_0/dummy_array_3_0/dummy_cell_1rw_1/a_76_76# 0.01645f
C1393 control_logic_rw_0/delay_chain_0/pinv_11_41/Z control_logic_rw_0/delay_chain_0/pinv_11_44/w_n127_403# 0.20256f
C1394 bank_0/replica_bitcell_array_0/dummy_array_3_0/dummy_cell_1rw_7/qb bank_0/port_address_0/wl_9 0.03696f
C1395 control_logic_rw_0/delay_chain_0/pinv_11_9/Z control_logic_rw_0/delay_chain_0/pinv_11_7/Z 0.14287f
C1396 control_logic_rw_0/dff_buf_array_0/dff_buf_0_1/pinv_1_0/nmos_m3_w0_560_sli_dli_da_p_0/a_132_0# control_logic_rw_0/dff_buf_array_0/dff_buf_0_1/pinv_1_0/gnd 0.01798f
C1397 control_logic_rw_0/delay_chain_0/pinv_11_9/w_n127_403# control_logic_rw_0/delay_chain_0/pinv_11_19/Z 0.05137f
C1398 control_logic_rw_0/delay_chain_0/pinv_11_31/Z control_logic_rw_0/delay_chain_0/pinv_11_31/pmos_m1_w0_840_sli_dli_da_p_0/a_54_0# 0.0129f
C1399 control_logic_rw_0/delay_chain_0/pinv_11_39/Z control_logic_rw_0/pinv_3_0/A 0.10996f
C1400 bank_0/replica_bitcell_array_0/bitcell_array_0/cell_1rw_6/qb bank_0/replica_bitcell_array_0/bitcell_array_0/cell_1rw_22/q 0.02064f
C1401 bank_0/replica_bitcell_array_0/bitcell_array_0/cell_1rw_28/qb bank_0/port_address_0/wl_3 0.03704f
C1402 bank_0/port_address_0/wordline_driver_array_0/in_13 bank_0/wl_en0 0.18688f
C1403 control_logic_rw_0/delay_chain_0/pinv_11_23/Z control_logic_rw_0/delay_chain_0/pinv_11_24/w_n127_403# 0.20256f
C1404 control_logic_rw_0/pand3_0/C control_logic_rw_0/pdriver_0_0/pinv_5_0/Z 0.18659f
C1405 control_logic_rw_0/pand3_0/C control_logic_rw_0/pdriver_0_0/pinv_5_0/pmos_m1_w0_840_sli_dli_da_p_0/a_0_0# 0.01597f
C1406 bank_0/replica_bitcell_array_0/dummy_array_2_0/dummy_cell_1rw_17/qb bank_0/port_address_0/rbl_wl 0.03923f
C1407 bank_0/replica_bitcell_array_0/dummy_array_2_0/dummy_cell_1rw_18/q bank_0/replica_bitcell_array_0/replica_column_0/dummy_cell_1rw_1/qb 0.02064f
C1408 bank_0/replica_bitcell_array_0/dummy_array_3_0/dummy_cell_1rw_9/a_76_76# bank_0/port_address_0/wl_7 0.05176f
C1409 control_logic_rw_0/pand3_0/pnand3_0_0/pmos_m1_w0_840_sli_dli_1/a_0_0# control_logic_rw_0/pinv_3_0/A 0.01216f
C1410 control_logic_rw_0/dff_buf_array_0/dff_buf_0_1/dff_0/net4 control_logic_rw_0/dff_buf_array_0/dff_buf_0_1/dff_0/Q 0.23158f
C1411 bank_0/replica_bitcell_array_0/dummy_array_2_0/dummy_cell_1rw_1/qb bank_0/port_address_0/wl_15 0.03923f
C1412 control_logic_rw_0/dff_buf_array_0/dff_buf_0_1/pinv_1_0/w_n127_195# control_logic_rw_0/pinv_3_0/A 0.053f
C1413 bank_0/replica_bitcell_array_0/dummy_array_3_0/dummy_cell_1rw_10/a_76_76# bank_0/port_address_0/wl_6 0.05176f
C1414 bank_0/port_address_0/hierarchical_decoder_0/and2_dec_7/pinv_0/w_n127_244# bank_0/port_address_0/wl_9 0.16341f
C1415 bank_0/wl_en0 control_logic_rw_0/pdriver_1_0/pinv_6_0/A 0.21901f
C1416 control_logic_rw_0/pdriver_0_0/pinv_7_0/A control_logic_rw_0/pdriver_0_0/pinv_6_0/pmos_m4_w1_050_sli_dli_da_p_0/a_54_0# 0.02596f
C1417 bank_0/port_address_0/hierarchical_decoder_0/predecode_6 bank_0/port_address_0/hierarchical_decoder_0/predecode_5 5.31855f
C1418 bank_0/port_address_0/hierarchical_decoder_0/predecode_6 bank_0/port_address_0/hierarchical_decoder_0/predecode_7 5.35956f
C1419 bank_0/port_address_0/hierarchical_decoder_0/and2_dec_13/pinv_0/w_n127_244# bank_0/port_address_0/wl_2 0.16398f
C1420 bank_0/replica_bitcell_array_0/dummy_array_3_0/dummy_cell_1rw_11/a_145_76# bank_0/port_address_0/wl_5 0.04184f
C1421 control_logic_rw_0/dff_buf_array_0/dff_buf_0_0/pinv_1_0/nmos_m3_w0_560_sli_dli_da_p_0/a_210_0# control_logic_rw_0/pand3_0_0/C 0.01427f
C1422 addr0[1] row_addr_dff_0/dff_3/clk 0.24101f
C1423 bank_0/port_address_0/hierarchical_decoder_0/and2_dec_8/pinv_0/pmos_m1_w0_840_sli_dli_da_p_0/a_54_0# bank_0/port_address_0/wordline_driver_array_0/in_7 0.01304f
C1424 control_logic_rw_0/pand3_0/gnd control_logic_rw_0/pdriver_1_0/pinv_6_0/A 0.16959f
C1425 row_addr_dff_0/dff_1/net1 row_addr_dff_0/dff_1/clkb 0.1543f
C1426 bank_0/replica_bitcell_array_0/bitcell_array_0/cell_1rw_25/qb bank_0/replica_bitcell_array_0/replica_column_0/replica_cell_1rw_9/q 0.02064f
C1427 bank_0/replica_bitcell_array_0/dummy_array_2_0/dummy_cell_1rw_16/a_145_76# bank_0/port_address_0/wl_0 0.04284f
C1428 bank_0/replica_bitcell_array_0/dummy_array_1_0/dummy_cell_1rw_1/a_145_76# bank_0/replica_bitcell_array_0/dummy_array_1_0/dummy_cell_1rw_1/qb 0.0163f
C1429 control_logic_rw_0/delay_chain_0/pinv_11_39/Z control_logic_rw_0/delay_chain_0/pinv_11_44/w_n127_403# 0.75928f
C1430 bank_0/replica_bitcell_array_0/dummy_array_3_0/dummy_cell_1rw_17/a_145_76# bank_0/replica_bitcell_array_0/dummy_array_3_0/dummy_cell_1rw_17/qb 0.0163f
C1431 bank_0/port_address_0/hierarchical_decoder_0/predecode_1 bank_0/port_address_0/hierarchical_decoder_0/hierarchical_predecode2x4_0/and2_dec_3/pinv_0/w_n127_244# 0.02221f
C1432 control_logic_rw_0/pand2_0/Z control_logic_rw_0/pand2_0/pdriver_0/pinv_2_0/pmos_m9_w1_120_sli_dli_da_p_0/a_600_0# 0.02277f
C1433 row_addr_dff_0/dff_3/clk row_addr_dff_0/dff_0/net2 0.0716f
C1434 bank_0/port_address_0/hierarchical_decoder_0/and2_dec_13/pinv_0/w_n127_244# bank_0/port_address_0/hierarchical_decoder_0/predecode_7 0.14845f
C1435 control_logic_rw_0/delay_chain_0/pinv_11_8/Z control_logic_rw_0/delay_chain_0/pinv_11_7/Z 0.04321f
C1436 bank_0/replica_bitcell_array_0/dummy_array_2_0/dummy_cell_1rw_6/a_76_76# bank_0/replica_bitcell_array_0/dummy_array_2_0/dummy_cell_1rw_6/q 0.01645f
C1437 control_logic_rw_0/dff_buf_array_0/dff_buf_0_0/pinv_1_0/nmos_m3_w0_560_sli_dli_da_p_0/a_54_0# control_logic_rw_0/dff_buf_array_0/dff_buf_0_0/pinv_1_0/gnd 0.011f
C1438 bank_0/replica_bitcell_array_0/bitcell_array_0/cell_1rw_20/q bank_0/port_address_0/wl_11 0.04155f
C1439 control_logic_rw_0/dff_buf_array_0/dff_buf_0_1/pinv_1_0/pmos_m3_w1_120_sli_dli_da_p_0/a_54_0# control_logic_rw_0/dff_buf_array_0/dout_0 0.02737f
C1440 control_logic_rw_0/delay_chain_0/pinv_11_4/w_n127_403# control_logic_rw_0/delay_chain_0/pinv_11_2/Z 0.20256f
C1441 control_logic_rw_0/delay_chain_0/pinv_11_25/pmos_m1_w0_840_sli_dli_da_p_0/a_54_0# control_logic_rw_0/delay_chain_0/pinv_11_25/Z 0.0129f
C1442 bank_0/port_address_0/hierarchical_decoder_0/hierarchical_predecode2x4_0/pinv_1/Z bank_0/port_address_0/hierarchical_decoder_0/hierarchical_predecode2x4_0/and2_dec_3/pinv_0/w_n127_244# 0.0452f
C1443 bank_0/replica_bitcell_array_0/replica_column_0/replica_cell_1rw_10/q bank_0/port_address_0/wl_5 0.04211f
C1444 bank_0/replica_bitcell_array_0/dummy_array_2_0/dummy_cell_1rw_11/q bank_0/port_address_0/wl_5 0.0474f
C1445 control_logic_rw_0/dff_buf_array_0/dff_buf_0_0/pinv_1_0/pmos_m3_w1_120_sli_dli_da_p_0/a_132_0# control_logic_rw_0/pand3_0_0/C 0.02363f
C1446 control_logic_rw_0/dff_buf_array_0/dff_buf_0_1/pinv_1_0/vdd control_logic_rw_0/dff_buf_array_0/dff_buf_0_0/pinv_1_0/pmos_m3_w1_120_sli_dli_da_p_0/a_132_0# 0.02745f
C1447 bank_0/replica_bitcell_array_0/dummy_array_2_0/dummy_cell_1rw_17/qb bank_0/replica_bitcell_array_0/replica_column_0/replica_cell_1rw_16/q 0.01651f
C1448 bank_0/replica_bitcell_array_0/dummy_array_2_0/dummy_cell_1rw_12/a_76_76# bank_0/replica_bitcell_array_0/dummy_array_2_0/dummy_cell_1rw_12/q 0.01645f
C1449 bank_0/port_address_0/hierarchical_decoder_0/hierarchical_predecode2x4_1/and2_dec_1/pinv_0/w_n127_244# bank_0/port_address_0/hierarchical_decoder_0/predecode_3 0.24572f
C1450 bank_0/port_address_0/hierarchical_decoder_0/hierarchical_predecode2x4_0/and2_dec_3/pinv_0/w_n127_244# bank_0/addr0_3 0.12164f
C1451 bank_0/replica_bitcell_array_0/dummy_array_3_0/dummy_cell_1rw_7/a_76_76# bank_0/replica_bitcell_array_0/dummy_array_3_0/dummy_cell_1rw_7/a_145_76# 0.06598f
C1452 control_logic_rw_0/pand2_0/Z control_logic_rw_0/pinv_3_1/w_n127_195# 0.04511f
C1453 bank_0/replica_bitcell_array_0/bitcell_array_0/cell_1rw_24/qb bank_0/replica_bitcell_array_0/bitcell_array_0/cell_1rw_8/q 0.01651f
C1454 bank_0/port_address_0/hierarchical_decoder_0/hierarchical_predecode2x4_1/pinv_1/Z bank_0/port_address_0/hierarchical_decoder_0/hierarchical_predecode2x4_1/pinv_0/Z 1.67081f
C1455 control_logic_rw_0/dff_buf_array_0/dff_buf_0_0/dff_0/clkb control_logic_rw_0/dff_buf_array_0/dff_buf_0_0/dff_0/Q 0.01658f
C1456 bank_0/replica_bitcell_array_0/bitcell_array_0/cell_1rw_9/qb bank_0/replica_bitcell_array_0/bitcell_array_0/cell_1rw_9/q 0.28699f
C1457 control_logic_rw_0/delay_chain_0/pinv_11_13/Z control_logic_rw_0/delay_chain_0/pinv_11_9/A 0.18901f
C1458 row_addr_dff_0/dff_3/net1 row_addr_dff_0/dff_3/clk 0.31285f
C1459 bank_0/replica_bitcell_array_0/dummy_array_2_0/dummy_cell_1rw_11/a_145_76# bank_0/replica_bitcell_array_0/dummy_array_2_0/dummy_cell_1rw_11/qb 0.0163f
C1460 addr0[1] addr0[0] 0.30612f
C1461 control_logic_rw_0/delay_chain_0/pinv_11_32/Z control_logic_rw_0/delay_chain_0/pinv_11_32/pmos_m1_w0_840_sli_dli_da_p_0/a_54_0# 0.0129f
C1462 bank_0/replica_bitcell_array_0/bitcell_array_0/cell_1rw_16/q bank_0/port_address_0/wl_15 0.04155f
C1463 control_logic_rw_0/pinv_3_0/w_n127_195# control_logic_rw_0/pinv_3_0/A 0.21447f
C1464 bank_0/port_address_0/wordline_driver_array_0/wordline_driver_13/pinv_0/pmos_m1_w0_840_sli_dli_da_p_0/a_54_0# bank_0/port_address_0/wl_2 0.01304f
C1465 bank_0/port_address_0/hierarchical_decoder_0/predecode_0 bank_0/port_address_0/hierarchical_decoder_0/and2_dec_11/pinv_0/w_n127_244# 0.02155f
C1466 bank_0/replica_bitcell_array_0/bitcell_array_0/cell_1rw_17/qb bank_0/replica_bitcell_array_0/replica_column_0/replica_cell_1rw_1/q 0.02064f
C1467 control_logic_rw_0/pdriver_0_0/pinv_6_0/A control_logic_rw_0/pdriver_0_0/gnd 0.17609f
C1468 bank_0/port_address_0/wordline_driver_array_0/wordline_driver_3/pinv_0/pmos_m1_w0_840_sli_dli_da_p_0/a_54_0# bank_0/port_address_0/wl_12 0.01304f
C1469 bank_0/replica_bitcell_array_0/replica_column_0/replica_cell_1rw_12/q bank_0/replica_bitcell_array_0/dummy_array_2_0/dummy_cell_1rw_13/qb 0.01651f
C1470 control_logic_rw_0/dff_buf_array_0/dff_buf_0_0/pinv_1_0/nmos_m3_w0_560_sli_dli_da_p_0/a_132_0# control_logic_rw_0/pand3_0_0/C 0.01662f
C1471 bank_0/replica_bitcell_array_0/dummy_array_3_0/dummy_cell_1rw_4/qb bank_0/replica_bitcell_array_0/dummy_array_3_0/dummy_cell_1rw_4/a_145_76# 0.0163f
C1472 bank_0/port_address_0/wordline_driver_array_0/in_11 bank_0/port_address_0/hierarchical_decoder_0/and2_dec_4/pinv_0/pmos_m1_w0_840_sli_dli_da_p_0/a_54_0# 0.01304f
C1473 bank_0/replica_bitcell_array_0/bitcell_array_0/cell_1rw_26/q bank_0/port_address_0/wl_5 0.04155f
C1474 bank_0/port_address_0/hierarchical_decoder_0/and2_dec_9/pinv_0/w_n127_244# bank_0/port_address_0/wl_7 0.16341f
C1475 bank_0/replica_bitcell_array_0/bitcell_array_0/cell_1rw_26/qb bank_0/replica_bitcell_array_0/bitcell_array_0/cell_1rw_10/q 0.01651f
C1476 bank_0/replica_bitcell_array_0/bitcell_array_0/cell_1rw_26/q bank_0/replica_bitcell_array_0/bitcell_array_0/cell_1rw_10/qb 0.02064f
C1477 control_logic_rw_0/dff_buf_array_0/dff_buf_0_1/dff_0/clkb control_logic_rw_0/dff_buf_array_0/dff_buf_0_1/dff_0/Q 0.01658f
C1478 control_logic_rw_0/pand2_0/Z control_logic_rw_0/pnand2_1_0/w_n127_195# 0.06323f
C1479 control_logic_rw_0/pand3_0/pdriver_2_0/pinv_9_0/pmos_m7_w1_200_sli_dli_da_p_0/a_210_0# control_logic_rw_0/pinv_3_0/A 0.02356f
C1480 bank_0/replica_bitcell_array_0/bitcell_array_0/cell_1rw_29/qb bank_0/replica_bitcell_array_0/bitcell_array_0/cell_1rw_29/q 0.28699f
C1481 control_logic_rw_0/pand3_0/C control_logic_rw_0/dff_buf_array_0/dff_buf_0_1/pinv_1_0/gnd 0.18862f
C1482 control_logic_rw_0/pdriver_0_0/pinv_7_0/A control_logic_rw_0/pdriver_0_0/pinv_6_0/nmos_m4_w0_520_sli_dli_da_p_0/a_132_0# 0.0101f
C1483 control_logic_rw_0/delay_chain_0/pinv_11_23/Z control_logic_rw_0/delay_chain_0/pinv_11_23/pmos_m1_w0_840_sli_dli_da_p_0/a_54_0# 0.0129f
C1484 control_logic_rw_0/pand2_0/Z control_logic_rw_0/pdriver_1_0/w_n127_195# 0.57712f
C1485 bank_0/port_address_0/hierarchical_decoder_0/predecode_1 bank_0/port_address_0/hierarchical_decoder_0/predecode_3 0.18468f
C1486 bank_0/port_address_0/hierarchical_decoder_0/and2_dec_11/pinv_0/w_n127_244# bank_0/port_address_0/wl_4 0.16398f
C1487 control_logic_rw_0/dff_buf_array_0/dff_buf_0_1/dff_0/net4 control_logic_rw_0/dff_buf_array_0/dff_buf_0_1/dff_0/clkb 0.08731f
C1488 bank_0/replica_bitcell_array_0/dummy_array_2_0/dummy_cell_1rw_10/a_76_76# bank_0/port_address_0/wl_6 0.05228f
C1489 bank_0/port_address_0/wordline_driver_array_0/in_15 bank_0/wl_en0 0.18688f
C1490 bank_0/replica_bitcell_array_0/bitcell_array_0/cell_1rw_8/qb bank_0/replica_bitcell_array_0/dummy_array_3_0/dummy_cell_1rw_9/q 0.01651f
C1491 control_logic_rw_0/pdriver_0_0/pinv_5_0/Z clk0 0.1132f
C1492 control_logic_rw_0/pand3_0/C control_logic_rw_0/pdriver_0_0/pinv_7_0/pmos_m11_w1_150_sli_dli_da_p_0/a_288_0# 0.02761f
C1493 bank_0/port_address_0/hierarchical_decoder_0/and2_dec_5/pinv_0/w_n127_244# bank_0/port_address_0/hierarchical_decoder_0/predecode_7 0.1498f
C1494 row_addr_dff_0/dff_3/net1 addr0[0] 0.08197f
C1495 bank_0/port_address_0/wordline_driver_array_0/in_9 bank_0/port_address_0/hierarchical_decoder_0/and2_dec_6/pinv_0/pmos_m1_w0_840_sli_dli_da_p_0/a_54_0# 0.01304f
C1496 din0[0] vdd 0.995f
C1497 addr0[0] vdd 1.15028f
C1498 bank_0/replica_bitcell_array_0/dummy_array_0_0/dummy_cell_1rw_1/q vdd 0.72321f
C1499 bank_0/replica_bitcell_array_0/dummy_array_0_0/dummy_cell_1rw_1/qb vdd 0.70129f
C1500 bank_0/replica_bitcell_array_0/dummy_array_0_0/dummy_cell_1rw_1/a_145_76# vdd 0.19158f ; **FLOATING
C1501 bank_0/replica_bitcell_array_0/dummy_array_0_0/dummy_cell_1rw_1/a_76_76# vdd 0.19358f ; **FLOATING
C1502 bank_0/replica_bitcell_array_0/dummy_array_0_0/dummy_cell_1rw_0/q vdd 0.72328f
C1503 bank_0/replica_bitcell_array_0/dummy_array_0_0/dummy_cell_1rw_0/qb vdd 0.7014f
C1504 bank_0/replica_bitcell_array_0/dummy_array_0_0/dummy_cell_1rw_0/a_145_76# vdd 0.19158f ; **FLOATING
C1505 bank_0/replica_bitcell_array_0/dummy_array_0_0/dummy_cell_1rw_0/a_76_76# vdd 0.19624f ; **FLOATING
C1506 bank_0/port_address_0/wl_7 vdd 4.69957f
C1507 bank_0/replica_bitcell_array_0/dummy_array_2_0/dummy_cell_1rw_9/q vdd 0.69402f
C1508 bank_0/replica_bitcell_array_0/dummy_array_2_0/dummy_cell_1rw_9/qb vdd 0.679f
C1509 bank_0/replica_bitcell_array_0/dummy_array_2_0/dummy_cell_1rw_9/a_145_76# vdd 0.15429f ; **FLOATING
C1510 bank_0/replica_bitcell_array_0/dummy_array_2_0/dummy_cell_1rw_9/a_76_76# vdd 0.13853f ; **FLOATING
C1511 bank_0/port_address_0/wl_8 vdd 4.71224f
C1512 bank_0/replica_bitcell_array_0/dummy_array_2_0/dummy_cell_1rw_8/q vdd 0.69404f
C1513 bank_0/replica_bitcell_array_0/dummy_array_2_0/dummy_cell_1rw_8/qb vdd 0.67395f
C1514 bank_0/replica_bitcell_array_0/dummy_array_2_0/dummy_cell_1rw_8/a_145_76# vdd 0.15384f ; **FLOATING
C1515 bank_0/replica_bitcell_array_0/dummy_array_2_0/dummy_cell_1rw_8/a_76_76# vdd 0.13168f ; **FLOATING
C1516 bank_0/port_address_0/wl_9 vdd 4.73561f
C1517 bank_0/replica_bitcell_array_0/dummy_array_2_0/dummy_cell_1rw_7/q vdd 0.69347f
C1518 bank_0/replica_bitcell_array_0/dummy_array_2_0/dummy_cell_1rw_7/qb vdd 0.67253f
C1519 bank_0/replica_bitcell_array_0/dummy_array_2_0/dummy_cell_1rw_7/a_145_76# vdd 0.15513f ; **FLOATING
C1520 bank_0/replica_bitcell_array_0/dummy_array_2_0/dummy_cell_1rw_7/a_76_76# vdd 0.13273f ; **FLOATING
C1521 bank_0/replica_bitcell_array_0/dummy_array_2_0/dummy_cell_1rw_18/q vdd 0.71364f
C1522 bank_0/replica_bitcell_array_0/dummy_array_2_0/dummy_cell_1rw_18/qb vdd 0.70113f
C1523 bank_0/replica_bitcell_array_0/dummy_array_2_0/dummy_cell_1rw_18/a_145_76# vdd 0.19081f ; **FLOATING
C1524 bank_0/replica_bitcell_array_0/dummy_array_2_0/dummy_cell_1rw_18/a_76_76# vdd 0.18908f ; **FLOATING
C1525 bank_0/port_address_0/rbl_wl vdd 4.53203f
C1526 bank_0/replica_bitcell_array_0/dummy_array_2_0/dummy_cell_1rw_17/q vdd 0.69359f
C1527 bank_0/replica_bitcell_array_0/dummy_array_2_0/dummy_cell_1rw_17/qb vdd 0.67261f
C1528 bank_0/replica_bitcell_array_0/dummy_array_2_0/dummy_cell_1rw_17/a_145_76# vdd 0.15251f ; **FLOATING
C1529 bank_0/replica_bitcell_array_0/dummy_array_2_0/dummy_cell_1rw_17/a_76_76# vdd 0.13288f ; **FLOATING
C1530 bank_0/port_address_0/wl_10 vdd 4.66786f
C1531 bank_0/replica_bitcell_array_0/dummy_array_2_0/dummy_cell_1rw_6/q vdd 0.69189f
C1532 bank_0/replica_bitcell_array_0/dummy_array_2_0/dummy_cell_1rw_6/qb vdd 0.67097f
C1533 bank_0/replica_bitcell_array_0/dummy_array_2_0/dummy_cell_1rw_6/a_145_76# vdd 0.15099f ; **FLOATING
C1534 bank_0/replica_bitcell_array_0/dummy_array_2_0/dummy_cell_1rw_6/a_76_76# vdd 0.13033f ; **FLOATING
C1535 bank_0/port_address_0/wl_0 vdd 4.66611f
C1536 bank_0/replica_bitcell_array_0/dummy_array_2_0/dummy_cell_1rw_16/q vdd 0.69314f
C1537 bank_0/replica_bitcell_array_0/dummy_array_2_0/dummy_cell_1rw_16/qb vdd 0.67235f
C1538 bank_0/replica_bitcell_array_0/dummy_array_2_0/dummy_cell_1rw_16/a_145_76# vdd 0.15103f ; **FLOATING
C1539 bank_0/replica_bitcell_array_0/dummy_array_2_0/dummy_cell_1rw_16/a_76_76# vdd 0.13056f ; **FLOATING
C1540 bank_0/port_address_0/wl_11 vdd 4.67182f
C1541 bank_0/replica_bitcell_array_0/dummy_array_2_0/dummy_cell_1rw_5/q vdd 0.69244f
C1542 bank_0/replica_bitcell_array_0/dummy_array_2_0/dummy_cell_1rw_5/qb vdd 0.67211f
C1543 bank_0/replica_bitcell_array_0/dummy_array_2_0/dummy_cell_1rw_5/a_145_76# vdd 0.15156f ; **FLOATING
C1544 bank_0/replica_bitcell_array_0/dummy_array_2_0/dummy_cell_1rw_5/a_76_76# vdd 0.13126f ; **FLOATING
C1545 bank_0/replica_bitcell_array_0/dummy_array_2_0/dummy_cell_1rw_15/q vdd 0.69413f
C1546 bank_0/replica_bitcell_array_0/dummy_array_2_0/dummy_cell_1rw_15/qb vdd 0.67355f
C1547 bank_0/replica_bitcell_array_0/dummy_array_2_0/dummy_cell_1rw_15/a_145_76# vdd 0.15209f ; **FLOATING
C1548 bank_0/replica_bitcell_array_0/dummy_array_2_0/dummy_cell_1rw_15/a_76_76# vdd 0.13222f ; **FLOATING
C1549 bank_0/port_address_0/wl_12 vdd 4.69263f
C1550 bank_0/replica_bitcell_array_0/dummy_array_2_0/dummy_cell_1rw_4/q vdd 0.69364f
C1551 bank_0/replica_bitcell_array_0/dummy_array_2_0/dummy_cell_1rw_4/qb vdd 0.67329f
C1552 bank_0/replica_bitcell_array_0/dummy_array_2_0/dummy_cell_1rw_4/a_145_76# vdd 0.1525f ; **FLOATING
C1553 bank_0/replica_bitcell_array_0/dummy_array_2_0/dummy_cell_1rw_4/a_76_76# vdd 0.14068f ; **FLOATING
C1554 bank_0/port_address_0/wl_2 vdd 4.71411f
C1555 bank_0/replica_bitcell_array_0/dummy_array_2_0/dummy_cell_1rw_14/q vdd 0.69613f
C1556 bank_0/replica_bitcell_array_0/dummy_array_2_0/dummy_cell_1rw_14/qb vdd 0.67395f
C1557 bank_0/replica_bitcell_array_0/dummy_array_2_0/dummy_cell_1rw_14/a_145_76# vdd 0.15258f ; **FLOATING
C1558 bank_0/replica_bitcell_array_0/dummy_array_2_0/dummy_cell_1rw_14/a_76_76# vdd 0.13251f ; **FLOATING
C1559 bank_0/port_address_0/wl_13 vdd 4.73918f
C1560 bank_0/replica_bitcell_array_0/dummy_array_2_0/dummy_cell_1rw_3/q vdd 0.69888f
C1561 bank_0/replica_bitcell_array_0/dummy_array_2_0/dummy_cell_1rw_3/qb vdd 0.67461f
C1562 bank_0/replica_bitcell_array_0/dummy_array_2_0/dummy_cell_1rw_3/a_145_76# vdd 0.15584f ; **FLOATING
C1563 bank_0/replica_bitcell_array_0/dummy_array_2_0/dummy_cell_1rw_3/a_76_76# vdd 0.13405f ; **FLOATING
C1564 bank_0/port_address_0/wl_14 vdd 4.68479f
C1565 bank_0/replica_bitcell_array_0/dummy_array_2_0/dummy_cell_1rw_2/q vdd 0.695f
C1566 bank_0/replica_bitcell_array_0/dummy_array_2_0/dummy_cell_1rw_2/qb vdd 0.67378f
C1567 bank_0/replica_bitcell_array_0/dummy_array_2_0/dummy_cell_1rw_2/a_145_76# vdd 0.15127f ; **FLOATING
C1568 bank_0/replica_bitcell_array_0/dummy_array_2_0/dummy_cell_1rw_2/a_76_76# vdd 0.13092f ; **FLOATING
C1569 bank_0/port_address_0/wl_3 vdd 4.69865f
C1570 bank_0/replica_bitcell_array_0/dummy_array_2_0/dummy_cell_1rw_13/q vdd 0.69952f
C1571 bank_0/replica_bitcell_array_0/dummy_array_2_0/dummy_cell_1rw_13/qb vdd 0.68172f
C1572 bank_0/replica_bitcell_array_0/dummy_array_2_0/dummy_cell_1rw_13/a_145_76# vdd 0.15344f ; **FLOATING
C1573 bank_0/replica_bitcell_array_0/dummy_array_2_0/dummy_cell_1rw_13/a_76_76# vdd 0.13412f ; **FLOATING
C1574 bank_0/port_address_0/wl_15 vdd 4.83357f
C1575 bank_0/replica_bitcell_array_0/dummy_array_2_0/dummy_cell_1rw_1/q vdd 0.69659f
C1576 bank_0/replica_bitcell_array_0/dummy_array_2_0/dummy_cell_1rw_1/qb vdd 0.67389f
C1577 bank_0/replica_bitcell_array_0/dummy_array_2_0/dummy_cell_1rw_1/a_145_76# vdd 0.15135f ; **FLOATING
C1578 bank_0/replica_bitcell_array_0/dummy_array_2_0/dummy_cell_1rw_1/a_76_76# vdd 0.13062f ; **FLOATING
C1579 bank_0/port_address_0/wl_4 vdd 4.69175f
C1580 bank_0/replica_bitcell_array_0/dummy_array_2_0/dummy_cell_1rw_12/q vdd 0.69564f
C1581 bank_0/replica_bitcell_array_0/dummy_array_2_0/dummy_cell_1rw_12/qb vdd 0.67516f
C1582 bank_0/replica_bitcell_array_0/dummy_array_2_0/dummy_cell_1rw_12/a_145_76# vdd 0.15196f ; **FLOATING
C1583 bank_0/replica_bitcell_array_0/dummy_array_2_0/dummy_cell_1rw_12/a_76_76# vdd 0.13181f ; **FLOATING
C1584 bank_0/replica_bitcell_array_0/dummy_array_2_0/dummy_cell_1rw_0/q vdd 0.71236f
C1585 bank_0/replica_bitcell_array_0/dummy_array_2_0/dummy_cell_1rw_0/qb vdd 0.70456f
C1586 bank_0/replica_bitcell_array_0/dummy_array_2_0/dummy_cell_1rw_0/a_145_76# vdd 0.19064f ; **FLOATING
C1587 bank_0/replica_bitcell_array_0/dummy_array_2_0/dummy_cell_1rw_0/a_76_76# vdd 0.19227f ; **FLOATING
C1588 bank_0/port_address_0/wl_5 vdd 4.66713f
C1589 bank_0/replica_bitcell_array_0/dummy_array_2_0/dummy_cell_1rw_11/q vdd 0.69368f
C1590 bank_0/replica_bitcell_array_0/dummy_array_2_0/dummy_cell_1rw_11/qb vdd 0.67279f
C1591 bank_0/replica_bitcell_array_0/dummy_array_2_0/dummy_cell_1rw_11/a_145_76# vdd 0.15104f ; **FLOATING
C1592 bank_0/replica_bitcell_array_0/dummy_array_2_0/dummy_cell_1rw_11/a_76_76# vdd 0.13086f ; **FLOATING
C1593 bank_0/port_address_0/wl_6 vdd 4.67937f
C1594 bank_0/replica_bitcell_array_0/dummy_array_2_0/dummy_cell_1rw_10/q vdd 0.69442f
C1595 bank_0/replica_bitcell_array_0/dummy_array_2_0/dummy_cell_1rw_10/qb vdd 0.67575f
C1596 bank_0/replica_bitcell_array_0/dummy_array_2_0/dummy_cell_1rw_10/a_145_76# vdd 0.15249f ; **FLOATING
C1597 bank_0/replica_bitcell_array_0/dummy_array_2_0/dummy_cell_1rw_10/a_76_76# vdd 0.1325f ; **FLOATING
C1598 bank_0/replica_bitcell_array_0/dummy_array_1_0/dummy_cell_1rw_1/q vdd 0.7236f
C1599 bank_0/replica_bitcell_array_0/dummy_array_1_0/dummy_cell_1rw_1/qb vdd 0.70234f
C1600 bank_0/replica_bitcell_array_0/dummy_array_1_0/dummy_cell_1rw_1/a_145_76# vdd 0.18788f ; **FLOATING
C1601 bank_0/replica_bitcell_array_0/dummy_array_1_0/dummy_cell_1rw_1/a_76_76# vdd 0.19288f ; **FLOATING
C1602 bank_0/replica_bitcell_array_0/dummy_array_1_0/dummy_cell_1rw_0/q vdd 0.72525f
C1603 bank_0/replica_bitcell_array_0/dummy_array_1_0/dummy_cell_1rw_0/qb vdd 0.70278f
C1604 bank_0/replica_bitcell_array_0/dummy_array_1_0/dummy_cell_1rw_0/a_145_76# vdd 0.18894f ; **FLOATING
C1605 bank_0/replica_bitcell_array_0/dummy_array_1_0/dummy_cell_1rw_0/a_76_76# vdd 0.19176f ; **FLOATING
C1606 bank_0/replica_bitcell_array_0/dummy_array_3_0/dummy_cell_1rw_9/q vdd 0.68299f
C1607 bank_0/replica_bitcell_array_0/dummy_array_3_0/dummy_cell_1rw_9/qb vdd 0.66247f
C1608 bank_0/replica_bitcell_array_0/dummy_array_3_0/dummy_cell_1rw_9/a_145_76# vdd 0.14563f ; **FLOATING
C1609 bank_0/replica_bitcell_array_0/dummy_array_3_0/dummy_cell_1rw_9/a_76_76# vdd 0.14698f ; **FLOATING
C1610 bank_0/replica_bitcell_array_0/dummy_array_3_0/dummy_cell_1rw_8/q vdd 0.68465f
C1611 bank_0/replica_bitcell_array_0/dummy_array_3_0/dummy_cell_1rw_8/qb vdd 0.6646f
C1612 bank_0/replica_bitcell_array_0/dummy_array_3_0/dummy_cell_1rw_8/a_145_76# vdd 0.14542f ; **FLOATING
C1613 bank_0/replica_bitcell_array_0/dummy_array_3_0/dummy_cell_1rw_8/a_76_76# vdd 0.14885f ; **FLOATING
C1614 bank_0/replica_bitcell_array_0/dummy_array_3_0/dummy_cell_1rw_7/q vdd 0.68327f
C1615 bank_0/replica_bitcell_array_0/dummy_array_3_0/dummy_cell_1rw_7/qb vdd 0.66237f
C1616 bank_0/replica_bitcell_array_0/dummy_array_3_0/dummy_cell_1rw_7/a_145_76# vdd 0.14582f ; **FLOATING
C1617 bank_0/replica_bitcell_array_0/dummy_array_3_0/dummy_cell_1rw_7/a_76_76# vdd 0.15049f ; **FLOATING
C1618 bank_0/replica_bitcell_array_0/dummy_array_3_0/dummy_cell_1rw_18/q vdd 0.72899f
C1619 bank_0/replica_bitcell_array_0/dummy_array_3_0/dummy_cell_1rw_18/qb vdd 0.7001f
C1620 bank_0/replica_bitcell_array_0/dummy_array_3_0/dummy_cell_1rw_18/a_145_76# vdd 0.19081f ; **FLOATING
C1621 bank_0/replica_bitcell_array_0/dummy_array_3_0/dummy_cell_1rw_18/a_76_76# vdd 0.19298f ; **FLOATING
C1622 bank_0/replica_bitcell_array_0/dummy_array_3_0/dummy_cell_1rw_17/q vdd 0.68396f
C1623 bank_0/replica_bitcell_array_0/dummy_array_3_0/dummy_cell_1rw_17/qb vdd 0.66389f
C1624 bank_0/replica_bitcell_array_0/dummy_array_3_0/dummy_cell_1rw_17/a_145_76# vdd 0.14889f ; **FLOATING
C1625 bank_0/replica_bitcell_array_0/dummy_array_3_0/dummy_cell_1rw_17/a_76_76# vdd 0.14023f ; **FLOATING
C1626 bank_0/replica_bitcell_array_0/dummy_array_3_0/dummy_cell_1rw_6/q vdd 0.68289f
C1627 bank_0/replica_bitcell_array_0/dummy_array_3_0/dummy_cell_1rw_6/qb vdd 0.66156f
C1628 bank_0/replica_bitcell_array_0/dummy_array_3_0/dummy_cell_1rw_6/a_145_76# vdd 0.14397f ; **FLOATING
C1629 bank_0/replica_bitcell_array_0/dummy_array_3_0/dummy_cell_1rw_6/a_76_76# vdd 0.14687f ; **FLOATING
C1630 bank_0/replica_bitcell_array_0/dummy_array_3_0/dummy_cell_1rw_16/q vdd 0.68449f
C1631 bank_0/replica_bitcell_array_0/dummy_array_3_0/dummy_cell_1rw_16/qb vdd 0.66383f
C1632 bank_0/replica_bitcell_array_0/dummy_array_3_0/dummy_cell_1rw_16/a_145_76# vdd 0.14424f ; **FLOATING
C1633 bank_0/replica_bitcell_array_0/dummy_array_3_0/dummy_cell_1rw_16/a_76_76# vdd 0.1461f ; **FLOATING
C1634 bank_0/replica_bitcell_array_0/dummy_array_3_0/dummy_cell_1rw_5/q vdd 0.6887f
C1635 bank_0/replica_bitcell_array_0/dummy_array_3_0/dummy_cell_1rw_5/qb vdd 0.6619f
C1636 bank_0/replica_bitcell_array_0/dummy_array_3_0/dummy_cell_1rw_5/a_145_76# vdd 0.14459f ; **FLOATING
C1637 bank_0/replica_bitcell_array_0/dummy_array_3_0/dummy_cell_1rw_5/a_76_76# vdd 0.14927f ; **FLOATING
C1638 bank_0/replica_bitcell_array_0/dummy_array_3_0/dummy_cell_1rw_15/q vdd 0.68222f
C1639 bank_0/replica_bitcell_array_0/dummy_array_3_0/dummy_cell_1rw_15/qb vdd 0.66237f
C1640 bank_0/replica_bitcell_array_0/dummy_array_3_0/dummy_cell_1rw_15/a_145_76# vdd 0.14424f ; **FLOATING
C1641 bank_0/replica_bitcell_array_0/dummy_array_3_0/dummy_cell_1rw_15/a_76_76# vdd 0.14654f ; **FLOATING
C1642 bank_0/replica_bitcell_array_0/dummy_array_3_0/dummy_cell_1rw_4/q vdd 0.68883f
C1643 bank_0/replica_bitcell_array_0/dummy_array_3_0/dummy_cell_1rw_4/qb vdd 0.66294f
C1644 bank_0/replica_bitcell_array_0/dummy_array_3_0/dummy_cell_1rw_4/a_145_76# vdd 0.14797f ; **FLOATING
C1645 bank_0/replica_bitcell_array_0/dummy_array_3_0/dummy_cell_1rw_4/a_76_76# vdd 0.14851f ; **FLOATING
C1646 bank_0/replica_bitcell_array_0/dummy_array_3_0/dummy_cell_1rw_14/q vdd 0.68327f
C1647 bank_0/replica_bitcell_array_0/dummy_array_3_0/dummy_cell_1rw_14/qb vdd 0.66265f
C1648 bank_0/replica_bitcell_array_0/dummy_array_3_0/dummy_cell_1rw_14/a_145_76# vdd 0.146f ; **FLOATING
C1649 bank_0/replica_bitcell_array_0/dummy_array_3_0/dummy_cell_1rw_14/a_76_76# vdd 0.14992f ; **FLOATING
C1650 bank_0/replica_bitcell_array_0/dummy_array_3_0/dummy_cell_1rw_3/q vdd 0.68585f
C1651 bank_0/replica_bitcell_array_0/dummy_array_3_0/dummy_cell_1rw_3/qb vdd 0.66555f
C1652 bank_0/replica_bitcell_array_0/dummy_array_3_0/dummy_cell_1rw_3/a_145_76# vdd 0.14898f ; **FLOATING
C1653 bank_0/replica_bitcell_array_0/dummy_array_3_0/dummy_cell_1rw_3/a_76_76# vdd 0.15123f ; **FLOATING
C1654 bank_0/replica_bitcell_array_0/dummy_array_3_0/dummy_cell_1rw_2/q vdd 0.68326f
C1655 bank_0/replica_bitcell_array_0/dummy_array_3_0/dummy_cell_1rw_2/qb vdd 0.66326f
C1656 bank_0/replica_bitcell_array_0/dummy_array_3_0/dummy_cell_1rw_2/a_145_76# vdd 0.14423f ; **FLOATING
C1657 bank_0/replica_bitcell_array_0/dummy_array_3_0/dummy_cell_1rw_2/a_76_76# vdd 0.14615f ; **FLOATING
C1658 bank_0/replica_bitcell_array_0/dummy_array_3_0/dummy_cell_1rw_13/q vdd 0.68429f
C1659 bank_0/replica_bitcell_array_0/dummy_array_3_0/dummy_cell_1rw_13/qb vdd 0.66306f
C1660 bank_0/replica_bitcell_array_0/dummy_array_3_0/dummy_cell_1rw_13/a_145_76# vdd 0.14566f ; **FLOATING
C1661 bank_0/replica_bitcell_array_0/dummy_array_3_0/dummy_cell_1rw_13/a_76_76# vdd 0.14983f ; **FLOATING
C1662 bank_0/replica_bitcell_array_0/dummy_array_3_0/dummy_cell_1rw_1/q vdd 0.68333f
C1663 bank_0/replica_bitcell_array_0/dummy_array_3_0/dummy_cell_1rw_1/qb vdd 0.66285f
C1664 bank_0/replica_bitcell_array_0/dummy_array_3_0/dummy_cell_1rw_1/a_145_76# vdd 0.14413f ; **FLOATING
C1665 bank_0/replica_bitcell_array_0/dummy_array_3_0/dummy_cell_1rw_1/a_76_76# vdd 0.14615f ; **FLOATING
C1666 bank_0/replica_bitcell_array_0/dummy_array_3_0/dummy_cell_1rw_12/q vdd 0.68312f
C1667 bank_0/replica_bitcell_array_0/dummy_array_3_0/dummy_cell_1rw_12/qb vdd 0.66254f
C1668 bank_0/replica_bitcell_array_0/dummy_array_3_0/dummy_cell_1rw_12/a_145_76# vdd 0.14423f ; **FLOATING
C1669 bank_0/replica_bitcell_array_0/dummy_array_3_0/dummy_cell_1rw_12/a_76_76# vdd 0.14628f ; **FLOATING
C1670 bank_0/replica_bitcell_array_0/dummy_array_3_0/dummy_cell_1rw_0/q vdd 0.72442f
C1671 bank_0/replica_bitcell_array_0/dummy_array_3_0/dummy_cell_1rw_0/qb vdd 0.69899f
C1672 bank_0/replica_bitcell_array_0/dummy_array_3_0/dummy_cell_1rw_0/a_145_76# vdd 0.19166f ; **FLOATING
C1673 bank_0/replica_bitcell_array_0/dummy_array_3_0/dummy_cell_1rw_0/a_76_76# vdd 0.19625f ; **FLOATING
C1674 bank_0/replica_bitcell_array_0/dummy_array_3_0/dummy_cell_1rw_11/q vdd 0.68549f
C1675 bank_0/replica_bitcell_array_0/dummy_array_3_0/dummy_cell_1rw_11/qb vdd 0.66047f
C1676 bank_0/replica_bitcell_array_0/dummy_array_3_0/dummy_cell_1rw_11/a_145_76# vdd 0.14369f ; **FLOATING
C1677 bank_0/replica_bitcell_array_0/dummy_array_3_0/dummy_cell_1rw_11/a_76_76# vdd 0.14653f ; **FLOATING
C1678 bank_0/replica_bitcell_array_0/dummy_array_3_0/dummy_cell_1rw_10/q vdd 0.68207f
C1679 bank_0/replica_bitcell_array_0/dummy_array_3_0/dummy_cell_1rw_10/qb vdd 0.66104f
C1680 bank_0/replica_bitcell_array_0/dummy_array_3_0/dummy_cell_1rw_10/a_145_76# vdd 0.14581f ; **FLOATING
C1681 bank_0/replica_bitcell_array_0/dummy_array_3_0/dummy_cell_1rw_10/a_76_76# vdd 0.1476f ; **FLOATING
C1682 bank_0/replica_bitcell_array_0/bitcell_array_0/cell_1rw_29/q vdd 0.71505f
C1683 bank_0/replica_bitcell_array_0/bitcell_array_0/cell_1rw_29/qb vdd 0.68818f
C1684 bank_0/replica_bitcell_array_0/bitcell_array_0/cell_1rw_19/q vdd 0.71266f
C1685 bank_0/replica_bitcell_array_0/bitcell_array_0/cell_1rw_19/qb vdd 0.68565f
C1686 bank_0/replica_bitcell_array_0/bitcell_array_0/cell_1rw_18/q vdd 0.71296f
C1687 bank_0/replica_bitcell_array_0/bitcell_array_0/cell_1rw_18/qb vdd 0.68576f
C1688 bank_0/replica_bitcell_array_0/bitcell_array_0/cell_1rw_28/q vdd 0.71402f
C1689 bank_0/replica_bitcell_array_0/bitcell_array_0/cell_1rw_28/qb vdd 0.68714f
C1690 bank_0/replica_bitcell_array_0/bitcell_array_0/cell_1rw_17/q vdd 0.71412f
C1691 bank_0/replica_bitcell_array_0/bitcell_array_0/cell_1rw_17/qb vdd 0.687f
C1692 bank_0/replica_bitcell_array_0/bitcell_array_0/cell_1rw_27/q vdd 0.71402f
C1693 bank_0/replica_bitcell_array_0/bitcell_array_0/cell_1rw_27/qb vdd 0.68725f
C1694 bank_0/replica_bitcell_array_0/bitcell_array_0/cell_1rw_16/q vdd 0.71442f
C1695 bank_0/replica_bitcell_array_0/bitcell_array_0/cell_1rw_16/qb vdd 0.68757f
C1696 bank_0/replica_bitcell_array_0/bitcell_array_0/cell_1rw_15/q vdd 0.6972f
C1697 bank_0/replica_bitcell_array_0/bitcell_array_0/cell_1rw_15/qb vdd 0.67936f
C1698 bank_0/replica_bitcell_array_0/bitcell_array_0/cell_1rw_26/q vdd 0.71358f
C1699 bank_0/replica_bitcell_array_0/bitcell_array_0/cell_1rw_26/qb vdd 0.68667f
C1700 bank_0/replica_bitcell_array_0/bitcell_array_0/cell_1rw_14/q vdd 0.69798f
C1701 bank_0/replica_bitcell_array_0/bitcell_array_0/cell_1rw_14/qb vdd 0.68007f
C1702 bank_0/replica_bitcell_array_0/bitcell_array_0/cell_1rw_25/q vdd 0.71365f
C1703 bank_0/replica_bitcell_array_0/bitcell_array_0/cell_1rw_25/qb vdd 0.68672f
C1704 bank_0/replica_bitcell_array_0/bitcell_array_0/cell_1rw_13/q vdd 0.6995f
C1705 bank_0/replica_bitcell_array_0/bitcell_array_0/cell_1rw_13/qb vdd 0.68193f
C1706 bank_0/replica_bitcell_array_0/bitcell_array_0/cell_1rw_24/q vdd 0.71391f
C1707 bank_0/replica_bitcell_array_0/bitcell_array_0/cell_1rw_24/qb vdd 0.68681f
C1708 bank_0/replica_bitcell_array_0/bitcell_array_0/cell_1rw_12/q vdd 0.69859f
C1709 bank_0/replica_bitcell_array_0/bitcell_array_0/cell_1rw_12/qb vdd 0.68106f
C1710 bank_0/replica_bitcell_array_0/bitcell_array_0/cell_1rw_23/q vdd 0.71439f
C1711 bank_0/replica_bitcell_array_0/bitcell_array_0/cell_1rw_23/qb vdd 0.68734f
C1712 bank_0/replica_bitcell_array_0/bitcell_array_0/cell_1rw_11/q vdd 0.6977f
C1713 bank_0/replica_bitcell_array_0/bitcell_array_0/cell_1rw_11/qb vdd 0.6801f
C1714 bank_0/replica_bitcell_array_0/bitcell_array_0/cell_1rw_22/q vdd 0.71428f
C1715 bank_0/replica_bitcell_array_0/bitcell_array_0/cell_1rw_22/qb vdd 0.68704f
C1716 bank_0/replica_bitcell_array_0/bitcell_array_0/cell_1rw_31/q vdd 0.71368f
C1717 bank_0/replica_bitcell_array_0/bitcell_array_0/cell_1rw_31/qb vdd 0.68682f
C1718 bank_0/replica_bitcell_array_0/bitcell_array_0/cell_1rw_10/q vdd 0.69698f
C1719 bank_0/replica_bitcell_array_0/bitcell_array_0/cell_1rw_10/qb vdd 0.67903f
C1720 bank_0/replica_bitcell_array_0/bitcell_array_0/cell_1rw_21/q vdd 0.7139f
C1721 bank_0/replica_bitcell_array_0/bitcell_array_0/cell_1rw_21/qb vdd 0.68681f
C1722 bank_0/replica_bitcell_array_0/bitcell_array_0/cell_1rw_20/q vdd 0.7138f
C1723 bank_0/replica_bitcell_array_0/bitcell_array_0/cell_1rw_20/qb vdd 0.68683f
C1724 bank_0/replica_bitcell_array_0/bitcell_array_0/cell_1rw_30/q vdd 0.71431f
C1725 bank_0/replica_bitcell_array_0/bitcell_array_0/cell_1rw_30/qb vdd 0.68733f
C1726 bank_0/replica_bitcell_array_0/bitcell_array_0/cell_1rw_9/q vdd 0.69724f
C1727 bank_0/replica_bitcell_array_0/bitcell_array_0/cell_1rw_9/qb vdd 0.67921f
C1728 bank_0/replica_bitcell_array_0/bitcell_array_0/cell_1rw_8/q vdd 0.69752f
C1729 bank_0/replica_bitcell_array_0/bitcell_array_0/cell_1rw_8/qb vdd 0.67941f
C1730 bank_0/replica_bitcell_array_0/bitcell_array_0/cell_1rw_7/q vdd 0.69803f
C1731 bank_0/replica_bitcell_array_0/bitcell_array_0/cell_1rw_7/qb vdd 0.6801f
C1732 bank_0/replica_bitcell_array_0/bitcell_array_0/cell_1rw_6/q vdd 0.69783f
C1733 bank_0/replica_bitcell_array_0/bitcell_array_0/cell_1rw_6/qb vdd 0.67961f
C1734 bank_0/replica_bitcell_array_0/bitcell_array_0/cell_1rw_5/q vdd 0.69847f
C1735 bank_0/replica_bitcell_array_0/bitcell_array_0/cell_1rw_5/qb vdd 0.68072f
C1736 bank_0/replica_bitcell_array_0/bitcell_array_0/cell_1rw_4/q vdd 0.69828f
C1737 bank_0/replica_bitcell_array_0/bitcell_array_0/cell_1rw_4/qb vdd 0.68058f
C1738 bank_0/replica_bitcell_array_0/bitcell_array_0/cell_1rw_3/q vdd 0.69623f
C1739 bank_0/replica_bitcell_array_0/bitcell_array_0/cell_1rw_3/qb vdd 0.67812f
C1740 bank_0/replica_bitcell_array_0/bitcell_array_0/cell_1rw_2/q vdd 0.69651f
C1741 bank_0/replica_bitcell_array_0/bitcell_array_0/cell_1rw_2/qb vdd 0.67832f
C1742 bank_0/replica_bitcell_array_0/bitcell_array_0/cell_1rw_1/q vdd 0.6977f
C1743 bank_0/replica_bitcell_array_0/bitcell_array_0/cell_1rw_1/qb vdd 0.67956f
C1744 bank_0/replica_bitcell_array_0/bitcell_array_0/cell_1rw_0/q vdd 0.6982f
C1745 bank_0/replica_bitcell_array_0/bitcell_array_0/cell_1rw_0/qb vdd 0.68044f
C1746 bank_0/replica_bitcell_array_0/replica_column_0/replica_cell_1rw_12/q vdd 0.9864f
C1747 bank_0/replica_bitcell_array_0/replica_column_0/replica_cell_1rw_0/q vdd 0.98667f
C1748 bank_0/replica_bitcell_array_0/replica_column_0/replica_cell_1rw_11/q vdd 0.98634f
C1749 bank_0/replica_bitcell_array_0/replica_column_0/replica_cell_1rw_10/q vdd 0.98606f
C1750 bank_0/replica_bitcell_array_0/replica_column_0/replica_cell_1rw_9/q vdd 0.986f
C1751 bank_0/replica_bitcell_array_0/replica_column_0/replica_cell_1rw_8/q vdd 0.98624f
C1752 bank_0/replica_bitcell_array_0/replica_column_0/replica_cell_1rw_7/q vdd 0.98677f
C1753 bank_0/replica_bitcell_array_0/replica_column_0/dummy_cell_1rw_1/q vdd 0.72561f
C1754 bank_0/replica_bitcell_array_0/replica_column_0/dummy_cell_1rw_1/qb vdd 0.7132f
C1755 bank_0/replica_bitcell_array_0/replica_column_0/dummy_cell_1rw_1/a_145_76# vdd 0.18836f ; **FLOATING
C1756 bank_0/replica_bitcell_array_0/replica_column_0/dummy_cell_1rw_1/a_76_76# vdd 0.19503f ; **FLOATING
C1757 bank_0/replica_bitcell_array_0/replica_column_0/replica_cell_1rw_6/q vdd 0.98672f
C1758 bank_0/replica_bitcell_array_0/replica_column_0/replica_cell_1rw_5/q vdd 0.98501f
C1759 bank_0/replica_bitcell_array_0/replica_column_0/dummy_cell_1rw_0/q vdd 0.72334f
C1760 bank_0/replica_bitcell_array_0/replica_column_0/dummy_cell_1rw_0/qb vdd 0.70162f
C1761 bank_0/replica_bitcell_array_0/replica_column_0/dummy_cell_1rw_0/a_145_76# vdd 0.18878f ; **FLOATING
C1762 bank_0/replica_bitcell_array_0/replica_column_0/dummy_cell_1rw_0/a_76_76# vdd 0.19292f ; **FLOATING
C1763 bank_0/replica_bitcell_array_0/replica_column_0/replica_cell_1rw_4/q vdd 0.98501f
C1764 bank_0/replica_bitcell_array_0/replica_column_0/replica_cell_1rw_16/q vdd 0.98678f
C1765 bank_0/replica_bitcell_array_0/replica_column_0/replica_cell_1rw_15/q vdd 0.98632f
C1766 bank_0/replica_bitcell_array_0/replica_column_0/replica_cell_1rw_3/q vdd 0.98626f
C1767 bank_0/replica_bitcell_array_0/replica_column_0/replica_cell_1rw_14/q vdd 0.98654f
C1768 bank_0/replica_bitcell_array_0/replica_column_0/replica_cell_1rw_2/q vdd 0.9866f
C1769 bank_0/replica_bitcell_array_0/replica_column_0/replica_cell_1rw_13/q vdd 0.98749f
C1770 bank_0/replica_bitcell_array_0/replica_column_0/replica_cell_1rw_1/q vdd 0.98658f
C1771 bank_0/replica_bitcell_array_0/dummy_array_0/dummy_cell_1rw_1/q vdd 0.69806f
C1772 bank_0/replica_bitcell_array_0/dummy_array_0/dummy_cell_1rw_1/qb vdd 0.67179f
C1773 bank_0/replica_bitcell_array_0/dummy_array_0/dummy_cell_1rw_1/a_145_76# vdd 0.14321f ; **FLOATING
C1774 bank_0/replica_bitcell_array_0/dummy_array_0/dummy_cell_1rw_1/a_76_76# vdd 0.14496f ; **FLOATING
C1775 bank_0/replica_bitcell_array_0/dummy_array_0/dummy_cell_1rw_0/q vdd 0.68227f
C1776 bank_0/replica_bitcell_array_0/dummy_array_0/dummy_cell_1rw_0/qb vdd 0.66458f
C1777 bank_0/replica_bitcell_array_0/dummy_array_0/dummy_cell_1rw_0/a_145_76# vdd 0.14321f ; **FLOATING
C1778 bank_0/replica_bitcell_array_0/dummy_array_0/dummy_cell_1rw_0/a_76_76# vdd 0.13799f ; **FLOATING
C1779 bank_0/port_address_0/wordline_driver_array_0/wordline_driver_9/pnand2_0/nmos_m1_w0_840_sactive_dli_0/a_54_0# vdd 0.02613f ; **FLOATING
C1780 bank_0/port_address_0/wordline_driver_array_0/wordline_driver_9/pnand2_0/nmos_m1_w0_840_sli_dactive_0/D vdd 0.02926f ; **FLOATING
C1781 bank_0/port_address_0/wordline_driver_array_0/in_6 vdd 0.9291f ; **FLOATING
C1782 bank_0/port_address_0/wordline_driver_array_0/wordline_driver_9/pnand2_0/nmos_m1_w0_840_sli_dactive_0/a_0_0# vdd 0.02005f ; **FLOATING
C1783 bank_0/port_address_0/wordline_driver_array_0/wordline_driver_9/pnand2_0/pmos_m1_w0_840_sli_dli_1/a_0_0# vdd 0.02022f ; **FLOATING
C1784 bank_0/port_address_0/wordline_driver_array_0/wordline_driver_9/pnand2_0/pmos_m1_w0_840_sli_dli_0/a_0_0# vdd 0.0305f ; **FLOATING
C1785 bank_0/port_address_0/wordline_driver_array_0/wordline_driver_9/pnand2_0/pmos_m1_w0_840_sli_dli_0/a_54_0# vdd 0.02451f ; **FLOATING
C1786 bank_0/port_address_0/wordline_driver_array_0/wordline_driver_9/pinv_0/pmos_m1_w0_840_sli_dli_da_p_0/a_0_0# vdd 0.01791f ; **FLOATING
C1787 bank_0/port_address_0/wordline_driver_array_0/wordline_driver_9/pinv_0/pmos_m1_w0_840_sli_dli_da_p_0/a_54_0# vdd 0.01289f ; **FLOATING
C1788 bank_0/port_address_0/wordline_driver_array_0/wordline_driver_8/pnand2_0/nmos_m1_w0_840_sactive_dli_0/a_54_0# vdd 0.02671f ; **FLOATING
C1789 bank_0/port_address_0/wordline_driver_array_0/wordline_driver_8/pnand2_0/nmos_m1_w0_840_sli_dactive_0/D vdd 0.02987f ; **FLOATING
C1790 bank_0/port_address_0/wordline_driver_array_0/in_7 vdd 0.9315f ; **FLOATING
C1791 bank_0/port_address_0/wordline_driver_array_0/wordline_driver_8/pnand2_0/nmos_m1_w0_840_sli_dactive_0/a_0_0# vdd 0.02049f ; **FLOATING
C1792 bank_0/port_address_0/wordline_driver_array_0/wordline_driver_8/pnand2_0/pmos_m1_w0_840_sli_dli_1/a_0_0# vdd 0.02027f ; **FLOATING
C1793 bank_0/port_address_0/wordline_driver_array_0/wordline_driver_8/pnand2_0/pmos_m1_w0_840_sli_dli_0/a_0_0# vdd 0.03005f ; **FLOATING
C1794 bank_0/port_address_0/wordline_driver_array_0/wordline_driver_8/pnand2_0/pmos_m1_w0_840_sli_dli_0/a_54_0# vdd 0.02467f ; **FLOATING
C1795 bank_0/port_address_0/wordline_driver_array_0/wordline_driver_8/pinv_0/nmos_m1_w0_420_sli_dli_da_p_0/a_0_0# vdd 0.01015f ; **FLOATING
C1796 bank_0/port_address_0/wordline_driver_array_0/wordline_driver_8/pinv_0/pmos_m1_w0_840_sli_dli_da_p_0/a_0_0# vdd 0.01804f ; **FLOATING
C1797 bank_0/port_address_0/wordline_driver_array_0/wordline_driver_8/pinv_0/pmos_m1_w0_840_sli_dli_da_p_0/a_54_0# vdd 0.01223f ; **FLOATING
C1798 bank_0/port_address_0/wordline_driver_array_0/wordline_driver_7/pnand2_0/nmos_m1_w0_840_sactive_dli_0/a_54_0# vdd 0.02514f ; **FLOATING
C1799 bank_0/port_address_0/wordline_driver_array_0/wordline_driver_7/pnand2_0/nmos_m1_w0_840_sli_dactive_0/D vdd 0.02759f ; **FLOATING
C1800 bank_0/port_address_0/wordline_driver_array_0/in_8 vdd 0.92626f ; **FLOATING
C1801 bank_0/port_address_0/wordline_driver_array_0/wordline_driver_7/pnand2_0/nmos_m1_w0_840_sli_dactive_0/a_0_0# vdd 0.01984f ; **FLOATING
C1802 bank_0/port_address_0/wordline_driver_array_0/wordline_driver_7/pnand2_0/pmos_m1_w0_840_sli_dli_1/a_0_0# vdd 0.01971f ; **FLOATING
C1803 bank_0/port_address_0/wordline_driver_array_0/wordline_driver_7/pnand2_0/pmos_m1_w0_840_sli_dli_0/a_0_0# vdd 0.02965f ; **FLOATING
C1804 bank_0/port_address_0/wordline_driver_array_0/wordline_driver_7/pnand2_0/pmos_m1_w0_840_sli_dli_0/a_54_0# vdd 0.02411f ; **FLOATING
C1805 bank_0/port_address_0/wordline_driver_array_0/wordline_driver_7/pinv_0/pmos_m1_w0_840_sli_dli_da_p_0/a_0_0# vdd 0.01762f ; **FLOATING
C1806 bank_0/port_address_0/wordline_driver_array_0/wordline_driver_7/pinv_0/pmos_m1_w0_840_sli_dli_da_p_0/a_54_0# vdd 0.01211f ; **FLOATING
C1807 bank_0/port_address_0/wordline_driver_array_0/wordline_driver_6/pnand2_0/nmos_m1_w0_840_sactive_dli_0/a_54_0# vdd 0.02575f ; **FLOATING
C1808 bank_0/port_address_0/wordline_driver_array_0/wordline_driver_6/pnand2_0/nmos_m1_w0_840_sli_dactive_0/D vdd 0.02799f ; **FLOATING
C1809 bank_0/port_address_0/wordline_driver_array_0/in_9 vdd 0.92653f ; **FLOATING
C1810 bank_0/port_address_0/wordline_driver_array_0/wordline_driver_6/pnand2_0/nmos_m1_w0_840_sli_dactive_0/a_0_0# vdd 0.01977f ; **FLOATING
C1811 bank_0/port_address_0/wordline_driver_array_0/wordline_driver_6/pnand2_0/pmos_m1_w0_840_sli_dli_1/a_0_0# vdd 0.01973f ; **FLOATING
C1812 bank_0/port_address_0/wordline_driver_array_0/wordline_driver_6/pnand2_0/pmos_m1_w0_840_sli_dli_0/a_0_0# vdd 0.03009f ; **FLOATING
C1813 bank_0/port_address_0/wordline_driver_array_0/wordline_driver_6/pnand2_0/pmos_m1_w0_840_sli_dli_0/a_54_0# vdd 0.02409f ; **FLOATING
C1814 bank_0/port_address_0/wordline_driver_array_0/wordline_driver_6/pinv_0/pmos_m1_w0_840_sli_dli_da_p_0/a_0_0# vdd 0.01762f ; **FLOATING
C1815 bank_0/port_address_0/wordline_driver_array_0/wordline_driver_6/pinv_0/pmos_m1_w0_840_sli_dli_da_p_0/a_54_0# vdd 0.01247f ; **FLOATING
C1816 bank_0/port_address_0/wordline_driver_array_0/wordline_driver_5/pnand2_0/nmos_m1_w0_840_sactive_dli_0/a_54_0# vdd 0.02485f ; **FLOATING
C1817 bank_0/port_address_0/wordline_driver_array_0/wordline_driver_5/pnand2_0/nmos_m1_w0_840_sli_dactive_0/D vdd 0.02702f ; **FLOATING
C1818 bank_0/port_address_0/wordline_driver_array_0/in_10 vdd 0.91483f ; **FLOATING
C1819 bank_0/port_address_0/wordline_driver_array_0/wordline_driver_5/pnand2_0/nmos_m1_w0_840_sli_dactive_0/a_0_0# vdd 0.01952f ; **FLOATING
C1820 bank_0/port_address_0/wordline_driver_array_0/wordline_driver_5/pnand2_0/pmos_m1_w0_840_sli_dli_1/a_0_0# vdd 0.01948f ; **FLOATING
C1821 bank_0/port_address_0/wordline_driver_array_0/wordline_driver_5/pnand2_0/pmos_m1_w0_840_sli_dli_0/a_0_0# vdd 0.02966f ; **FLOATING
C1822 bank_0/port_address_0/wordline_driver_array_0/wordline_driver_5/pnand2_0/pmos_m1_w0_840_sli_dli_0/a_54_0# vdd 0.02387f ; **FLOATING
C1823 bank_0/port_address_0/wordline_driver_array_0/wordline_driver_5/pinv_0/pmos_m1_w0_840_sli_dli_da_p_0/a_0_0# vdd 0.01716f ; **FLOATING
C1824 bank_0/port_address_0/wordline_driver_array_0/wordline_driver_5/pinv_0/pmos_m1_w0_840_sli_dli_da_p_0/a_54_0# vdd 0.01172f ; **FLOATING
C1825 bank_0/port_address_0/wordline_driver_array_0/wordline_driver_4/pnand2_0/nmos_m1_w0_840_sactive_dli_0/a_54_0# vdd 0.02546f ; **FLOATING
C1826 bank_0/port_address_0/wordline_driver_array_0/wordline_driver_4/pnand2_0/nmos_m1_w0_840_sli_dactive_0/D vdd 0.02723f ; **FLOATING
C1827 bank_0/port_address_0/wordline_driver_array_0/in_11 vdd 0.90696f ; **FLOATING
C1828 bank_0/port_address_0/wordline_driver_array_0/wordline_driver_4/pnand2_0/nmos_m1_w0_840_sli_dactive_0/a_0_0# vdd 0.01935f ; **FLOATING
C1829 bank_0/port_address_0/wordline_driver_array_0/wordline_driver_4/pnand2_0/pmos_m1_w0_840_sli_dli_1/a_0_0# vdd 0.01927f ; **FLOATING
C1830 bank_0/port_address_0/wordline_driver_array_0/wordline_driver_4/pnand2_0/pmos_m1_w0_840_sli_dli_0/a_0_0# vdd 0.02954f ; **FLOATING
C1831 bank_0/port_address_0/wordline_driver_array_0/wordline_driver_4/pnand2_0/pmos_m1_w0_840_sli_dli_0/a_54_0# vdd 0.02374f ; **FLOATING
C1832 bank_0/port_address_0/wordline_driver_array_0/wordline_driver_4/pinv_0/pmos_m1_w0_840_sli_dli_da_p_0/a_0_0# vdd 0.01735f ; **FLOATING
C1833 bank_0/port_address_0/wordline_driver_array_0/wordline_driver_4/pinv_0/pmos_m1_w0_840_sli_dli_da_p_0/a_54_0# vdd 0.01195f ; **FLOATING
C1834 bank_0/port_address_0/wordline_driver_array_0/wordline_driver_3/pnand2_0/nmos_m1_w0_840_sactive_dli_0/a_54_0# vdd 0.02489f ; **FLOATING
C1835 bank_0/port_address_0/wordline_driver_array_0/wordline_driver_3/pnand2_0/nmos_m1_w0_840_sli_dactive_0/D vdd 0.02693f ; **FLOATING
C1836 bank_0/port_address_0/wordline_driver_array_0/in_12 vdd 0.90829f ; **FLOATING
C1837 bank_0/port_address_0/wordline_driver_array_0/wordline_driver_3/pnand2_0/nmos_m1_w0_840_sli_dactive_0/a_0_0# vdd 0.01935f ; **FLOATING
C1838 bank_0/port_address_0/wordline_driver_array_0/wordline_driver_3/pnand2_0/pmos_m1_w0_840_sli_dli_1/a_0_0# vdd 0.01924f ; **FLOATING
C1839 bank_0/port_address_0/wordline_driver_array_0/wordline_driver_3/pnand2_0/pmos_m1_w0_840_sli_dli_0/a_0_0# vdd 0.02933f ; **FLOATING
C1840 bank_0/port_address_0/wordline_driver_array_0/wordline_driver_3/pnand2_0/pmos_m1_w0_840_sli_dli_0/a_54_0# vdd 0.02372f ; **FLOATING
C1841 bank_0/port_address_0/wordline_driver_array_0/wordline_driver_3/pinv_0/pmos_m1_w0_840_sli_dli_da_p_0/a_0_0# vdd 0.01749f ; **FLOATING
C1842 bank_0/port_address_0/wordline_driver_array_0/wordline_driver_3/pinv_0/pmos_m1_w0_840_sli_dli_da_p_0/a_54_0# vdd 0.01191f ; **FLOATING
C1843 bank_0/port_address_0/wordline_driver_array_0/wordline_driver_2/pnand2_0/nmos_m1_w0_840_sactive_dli_0/a_54_0# vdd 0.02534f ; **FLOATING
C1844 bank_0/port_address_0/wordline_driver_array_0/wordline_driver_2/pnand2_0/nmos_m1_w0_840_sli_dactive_0/D vdd 0.02762f ; **FLOATING
C1845 bank_0/port_address_0/wordline_driver_array_0/in_13 vdd 0.92543f ; **FLOATING
C1846 bank_0/port_address_0/wordline_driver_array_0/wordline_driver_2/pnand2_0/nmos_m1_w0_840_sli_dactive_0/a_0_0# vdd 0.01976f ; **FLOATING
C1847 bank_0/port_address_0/wordline_driver_array_0/wordline_driver_2/pnand2_0/pmos_m1_w0_840_sli_dli_1/a_0_0# vdd 0.0199f ; **FLOATING
C1848 bank_0/port_address_0/wordline_driver_array_0/wordline_driver_2/pnand2_0/pmos_m1_w0_840_sli_dli_0/a_0_0# vdd 0.03053f ; **FLOATING
C1849 bank_0/port_address_0/wordline_driver_array_0/wordline_driver_2/pnand2_0/pmos_m1_w0_840_sli_dli_0/a_54_0# vdd 0.02425f ; **FLOATING
C1850 bank_0/port_address_0/wordline_driver_array_0/wordline_driver_2/pinv_0/pmos_m1_w0_840_sli_dli_da_p_0/a_0_0# vdd 0.01778f ; **FLOATING
C1851 bank_0/port_address_0/wordline_driver_array_0/wordline_driver_2/pinv_0/pmos_m1_w0_840_sli_dli_da_p_0/a_54_0# vdd 0.01277f ; **FLOATING
C1852 bank_0/port_address_0/wordline_driver_array_0/wordline_driver_1/pnand2_0/nmos_m1_w0_840_sactive_dli_0/a_54_0# vdd 0.02558f ; **FLOATING
C1853 bank_0/port_address_0/wordline_driver_array_0/wordline_driver_1/pnand2_0/nmos_m1_w0_840_sli_dactive_0/D vdd 0.02798f ; **FLOATING
C1854 bank_0/port_address_0/wordline_driver_array_0/in_14 vdd 0.92256f ; **FLOATING
C1855 bank_0/port_address_0/wordline_driver_array_0/wordline_driver_1/pnand2_0/nmos_m1_w0_840_sli_dactive_0/a_0_0# vdd 0.01985f ; **FLOATING
C1856 bank_0/port_address_0/wordline_driver_array_0/wordline_driver_1/pnand2_0/pmos_m1_w0_840_sli_dli_1/a_0_0# vdd 0.01963f ; **FLOATING
C1857 bank_0/port_address_0/wordline_driver_array_0/wordline_driver_1/pnand2_0/pmos_m1_w0_840_sli_dli_0/a_0_0# vdd 0.03f ; **FLOATING
C1858 bank_0/port_address_0/wordline_driver_array_0/wordline_driver_1/pnand2_0/pmos_m1_w0_840_sli_dli_0/a_54_0# vdd 0.02406f ; **FLOATING
C1859 bank_0/port_address_0/wordline_driver_array_0/wordline_driver_1/pinv_0/pmos_m1_w0_840_sli_dli_da_p_0/a_0_0# vdd 0.01758f ; **FLOATING
C1860 bank_0/port_address_0/wordline_driver_array_0/wordline_driver_1/pinv_0/pmos_m1_w0_840_sli_dli_da_p_0/a_54_0# vdd 0.01243f ; **FLOATING
C1861 bank_0/port_address_0/wordline_driver_array_0/wordline_driver_0/pnand2_0/nmos_m1_w0_840_sactive_dli_0/a_54_0# vdd 0.02454f ; **FLOATING
C1862 bank_0/port_address_0/wordline_driver_array_0/wordline_driver_0/pnand2_0/nmos_m1_w0_840_sli_dactive_0/D vdd 0.02626f ; **FLOATING
C1863 bank_0/port_address_0/wordline_driver_array_0/in_15 vdd 0.91528f ; **FLOATING
C1864 bank_0/port_address_0/wordline_driver_array_0/wordline_driver_0/pnand2_0/nmos_m1_w0_840_sli_dactive_0/a_0_0# vdd 0.01912f ; **FLOATING
C1865 bank_0/port_address_0/wordline_driver_array_0/wordline_driver_0/pnand2_0/pmos_m1_w0_840_sli_dli_1/a_0_0# vdd 0.02005f ; **FLOATING
C1866 bank_0/port_address_0/wordline_driver_array_0/wordline_driver_0/pnand2_0/pmos_m1_w0_840_sli_dli_0/a_0_0# vdd 0.03024f ; **FLOATING
C1867 bank_0/port_address_0/wordline_driver_array_0/wordline_driver_0/pnand2_0/pmos_m1_w0_840_sli_dli_0/a_54_0# vdd 0.02445f ; **FLOATING
C1868 bank_0/port_address_0/wordline_driver_array_0/wordline_driver_0/pinv_0/pmos_m1_w0_840_sli_dli_da_p_0/a_0_0# vdd 0.01822f ; **FLOATING
C1869 bank_0/port_address_0/wordline_driver_array_0/wordline_driver_0/pinv_0/pmos_m1_w0_840_sli_dli_da_p_0/a_54_0# vdd 0.01274f ; **FLOATING
C1870 bank_0/wl_en0 vdd 18.94156f ; **FLOATING
C1871 bank_0/port_address_0/wordline_driver_array_0/wordline_driver_15/pnand2_0/nmos_m1_w0_840_sactive_dli_0/a_54_0# vdd 0.02514f ; **FLOATING
C1872 bank_0/port_address_0/wordline_driver_array_0/wordline_driver_15/pnand2_0/nmos_m1_w0_840_sli_dactive_0/D vdd 0.02744f ; **FLOATING
C1873 bank_0/port_address_0/wordline_driver_array_0/in_0 vdd 0.931f ; **FLOATING
C1874 bank_0/port_address_0/wordline_driver_array_0/wordline_driver_15/pnand2_0/nmos_m1_w0_840_sli_dactive_0/a_0_0# vdd 0.01968f ; **FLOATING
C1875 bank_0/port_address_0/wordline_driver_array_0/wordline_driver_15/pnand2_0/pmos_m1_w0_840_sli_dli_1/a_0_0# vdd 0.02038f ; **FLOATING
C1876 bank_0/port_address_0/wordline_driver_array_0/wordline_driver_15/pnand2_0/pmos_m1_w0_840_sli_dli_0/a_0_0# vdd 0.03026f ; **FLOATING
C1877 bank_0/port_address_0/wordline_driver_array_0/wordline_driver_15/pnand2_0/pmos_m1_w0_840_sli_dli_0/a_54_0# vdd 0.02454f ; **FLOATING
C1878 bank_0/port_address_0/wordline_driver_array_0/wordline_driver_15/pinv_0/pmos_m1_w0_840_sli_dli_da_p_0/a_0_0# vdd 0.0178f ; **FLOATING
C1879 bank_0/port_address_0/wordline_driver_array_0/wordline_driver_15/pinv_0/pmos_m1_w0_840_sli_dli_da_p_0/a_54_0# vdd 0.0122f ; **FLOATING
C1880 bank_0/port_address_0/wordline_driver_array_0/wordline_driver_14/pnand2_0/nmos_m1_w0_840_sactive_dli_0/a_54_0# vdd 0.02473f ; **FLOATING
C1881 bank_0/port_address_0/wordline_driver_array_0/wordline_driver_14/pnand2_0/nmos_m1_w0_840_sli_dactive_0/D vdd 0.02652f ; **FLOATING
C1882 bank_0/port_address_0/wordline_driver_array_0/wordline_driver_14/pnand2_0/nmos_m1_w0_840_sli_dactive_0/a_0_0# vdd 0.01922f ; **FLOATING
C1883 bank_0/port_address_0/wordline_driver_array_0/wordline_driver_14/pnand2_0/pmos_m1_w0_840_sli_dli_1/a_0_0# vdd 0.01985f ; **FLOATING
C1884 bank_0/port_address_0/wordline_driver_array_0/wordline_driver_14/pnand2_0/pmos_m1_w0_840_sli_dli_0/a_0_0# vdd 0.03021f ; **FLOATING
C1885 bank_0/port_address_0/wordline_driver_array_0/wordline_driver_14/pnand2_0/pmos_m1_w0_840_sli_dli_0/a_54_0# vdd 0.02426f ; **FLOATING
C1886 bank_0/port_address_0/wl_1 vdd 4.70828f
C1887 bank_0/port_address_0/wordline_driver_array_0/wordline_driver_14/pinv_0/pmos_m1_w0_840_sli_dli_da_p_0/a_0_0# vdd 0.01802f ; **FLOATING
C1888 bank_0/port_address_0/wordline_driver_array_0/wordline_driver_14/pinv_0/pmos_m1_w0_840_sli_dli_da_p_0/a_54_0# vdd 0.01274f ; **FLOATING
C1889 bank_0/port_address_0/wordline_driver_array_0/wordline_driver_13/pnand2_0/nmos_m1_w0_840_sactive_dli_0/a_54_0# vdd 0.02601f ; **FLOATING
C1890 bank_0/port_address_0/wordline_driver_array_0/wordline_driver_13/pnand2_0/nmos_m1_w0_840_sli_dactive_0/D vdd 0.02891f ; **FLOATING
C1891 bank_0/port_address_0/wordline_driver_array_0/in_2 vdd 0.91252f ; **FLOATING
C1892 bank_0/port_address_0/wordline_driver_array_0/wordline_driver_13/pnand2_0/nmos_m1_w0_840_sli_dactive_0/a_0_0# vdd 0.01998f ; **FLOATING
C1893 bank_0/port_address_0/wordline_driver_array_0/wordline_driver_13/pnand2_0/pmos_m1_w0_840_sli_dli_1/a_0_0# vdd 0.0194f ; **FLOATING
C1894 bank_0/port_address_0/wordline_driver_array_0/wordline_driver_13/pnand2_0/pmos_m1_w0_840_sli_dli_0/a_0_0# vdd 0.02941f ; **FLOATING
C1895 bank_0/port_address_0/wordline_driver_array_0/wordline_driver_13/pnand2_0/pmos_m1_w0_840_sli_dli_0/a_54_0# vdd 0.02392f ; **FLOATING
C1896 bank_0/port_address_0/wordline_driver_array_0/wordline_driver_13/pinv_0/nmos_m1_w0_420_sli_dli_da_p_0/a_0_0# vdd 0.01027f ; **FLOATING
C1897 bank_0/port_address_0/wordline_driver_array_0/wordline_driver_13/pinv_0/pmos_m1_w0_840_sli_dli_da_p_0/a_0_0# vdd 0.01754f ; **FLOATING
C1898 bank_0/port_address_0/wordline_driver_array_0/wordline_driver_13/pinv_0/pmos_m1_w0_840_sli_dli_da_p_0/a_54_0# vdd 0.01197f ; **FLOATING
C1899 bank_0/port_address_0/wordline_driver_array_0/wordline_driver_12/pnand2_0/nmos_m1_w0_840_sactive_dli_0/a_54_0# vdd 0.02506f ; **FLOATING
C1900 bank_0/port_address_0/wordline_driver_array_0/wordline_driver_12/pnand2_0/nmos_m1_w0_840_sli_dactive_0/D vdd 0.02726f ; **FLOATING
C1901 bank_0/port_address_0/wordline_driver_array_0/in_3 vdd 0.92202f ; **FLOATING
C1902 bank_0/port_address_0/wordline_driver_array_0/wordline_driver_12/pnand2_0/nmos_m1_w0_840_sli_dactive_0/a_0_0# vdd 0.01955f ; **FLOATING
C1903 bank_0/port_address_0/wordline_driver_array_0/wordline_driver_12/pnand2_0/pmos_m1_w0_840_sli_dli_1/a_0_0# vdd 0.01967f ; **FLOATING
C1904 bank_0/port_address_0/wordline_driver_array_0/wordline_driver_12/pnand2_0/pmos_m1_w0_840_sli_dli_0/a_0_0# vdd 0.03035f ; **FLOATING
C1905 bank_0/port_address_0/wordline_driver_array_0/wordline_driver_12/pnand2_0/pmos_m1_w0_840_sli_dli_0/a_54_0# vdd 0.02416f ; **FLOATING
C1906 bank_0/port_address_0/wordline_driver_array_0/wordline_driver_12/pinv_0/pmos_m1_w0_840_sli_dli_da_p_0/a_0_0# vdd 0.01783f ; **FLOATING
C1907 bank_0/port_address_0/wordline_driver_array_0/wordline_driver_12/pinv_0/pmos_m1_w0_840_sli_dli_da_p_0/a_54_0# vdd 0.01294f ; **FLOATING
C1908 bank_0/port_address_0/wordline_driver_array_0/wordline_driver_11/pnand2_0/nmos_m1_w0_840_sactive_dli_0/a_54_0# vdd 0.02556f ; **FLOATING
C1909 bank_0/port_address_0/wordline_driver_array_0/wordline_driver_11/pnand2_0/nmos_m1_w0_840_sli_dactive_0/D vdd 0.02757f ; **FLOATING
C1910 bank_0/port_address_0/wordline_driver_array_0/in_4 vdd 0.91572f ; **FLOATING
C1911 bank_0/port_address_0/wordline_driver_array_0/wordline_driver_11/pnand2_0/nmos_m1_w0_840_sli_dactive_0/a_0_0# vdd 0.01955f ; **FLOATING
C1912 bank_0/port_address_0/wordline_driver_array_0/wordline_driver_11/pnand2_0/pmos_m1_w0_840_sli_dli_1/a_0_0# vdd 0.02034f ; **FLOATING
C1913 bank_0/port_address_0/wordline_driver_array_0/wordline_driver_11/pnand2_0/pmos_m1_w0_840_sli_dli_0/a_0_0# vdd 0.03057f ; **FLOATING
C1914 bank_0/port_address_0/wordline_driver_array_0/wordline_driver_11/pnand2_0/pmos_m1_w0_840_sli_dli_0/a_54_0# vdd 0.02483f ; **FLOATING
C1915 bank_0/port_address_0/wordline_driver_array_0/wordline_driver_11/pinv_0/pmos_m1_w0_840_sli_dli_da_p_0/a_0_0# vdd 0.01862f ; **FLOATING
C1916 bank_0/port_address_0/wordline_driver_array_0/wordline_driver_11/pinv_0/pmos_m1_w0_840_sli_dli_da_p_0/a_54_0# vdd 0.01318f ; **FLOATING
C1917 bank_0/port_address_0/wordline_driver_array_0/wordline_driver_10/pnand2_0/nmos_m1_w0_840_sactive_dli_0/a_54_0# vdd 0.02496f ; **FLOATING
C1918 bank_0/port_address_0/wordline_driver_array_0/wordline_driver_10/pnand2_0/nmos_m1_w0_840_sli_dactive_0/D vdd 0.02706f ; **FLOATING
C1919 bank_0/port_address_0/wordline_driver_array_0/wordline_driver_10/pnand2_0/nmos_m1_w0_840_sli_dactive_0/a_0_0# vdd 0.0195f ; **FLOATING
C1920 bank_0/port_address_0/wordline_driver_array_0/wordline_driver_10/pnand2_0/pmos_m1_w0_840_sli_dli_1/a_0_0# vdd 0.01939f ; **FLOATING
C1921 bank_0/port_address_0/wordline_driver_array_0/wordline_driver_10/pnand2_0/pmos_m1_w0_840_sli_dli_0/a_0_0# vdd 0.02934f ; **FLOATING
C1922 bank_0/port_address_0/wordline_driver_array_0/wordline_driver_10/pnand2_0/pmos_m1_w0_840_sli_dli_0/a_54_0# vdd 0.02392f ; **FLOATING
C1923 bank_0/port_address_0/wordline_driver_array_0/wordline_driver_10/pinv_0/pmos_m1_w0_840_sli_dli_da_p_0/a_0_0# vdd 0.01757f ; **FLOATING
C1924 bank_0/port_address_0/wordline_driver_array_0/wordline_driver_10/pinv_0/pmos_m1_w0_840_sli_dli_da_p_0/a_54_0# vdd 0.01225f ; **FLOATING
C1925 bank_0/port_address_0/hierarchical_decoder_0/predecode_2 vdd 4.53124f ; **FLOATING
C1926 bank_0/port_address_0/hierarchical_decoder_0/predecode_0 vdd 6.97013f ; **FLOATING
C1927 bank_0/port_address_0/hierarchical_decoder_0/predecode_1 vdd 4.67511f ; **FLOATING
C1928 bank_0/port_address_0/hierarchical_decoder_0/and2_dec_15/pnand2_0/nmos_m1_w0_840_sactive_dli_0/a_54_0# vdd 0.02376f ; **FLOATING
C1929 bank_0/port_address_0/hierarchical_decoder_0/and2_dec_15/pnand2_0/nmos_m1_w0_840_sli_dactive_0/D vdd 0.02518f ; **FLOATING
C1930 bank_0/port_address_0/hierarchical_decoder_0/and2_dec_15/pnand2_0/nmos_m1_w0_840_sli_dactive_0/a_0_0# vdd 0.01827f ; **FLOATING
C1931 bank_0/port_address_0/hierarchical_decoder_0/and2_dec_15/pnand2_0/pmos_m1_w0_840_sli_dli_1/a_0_0# vdd 0.01916f ; **FLOATING
C1932 bank_0/port_address_0/hierarchical_decoder_0/and2_dec_15/pnand2_0/pmos_m1_w0_840_sli_dli_0/a_0_0# vdd 0.03012f ; **FLOATING
C1933 bank_0/port_address_0/hierarchical_decoder_0/and2_dec_15/pnand2_0/pmos_m1_w0_840_sli_dli_0/a_54_0# vdd 0.02397f ; **FLOATING
C1934 bank_0/port_address_0/hierarchical_decoder_0/and2_dec_15/pinv_0/pmos_m1_w0_840_sli_dli_da_p_0/a_0_0# vdd 0.01736f ; **FLOATING
C1935 bank_0/port_address_0/hierarchical_decoder_0/and2_dec_15/pinv_0/pmos_m1_w0_840_sli_dli_da_p_0/a_54_0# vdd 0.01208f ; **FLOATING
C1936 bank_0/port_address_0/hierarchical_decoder_0/and2_dec_14/pnand2_0/nmos_m1_w0_840_sactive_dli_0/a_54_0# vdd 0.02328f ; **FLOATING
C1937 bank_0/port_address_0/hierarchical_decoder_0/and2_dec_14/pnand2_0/nmos_m1_w0_840_sli_dactive_0/D vdd 0.02391f ; **FLOATING
C1938 bank_0/port_address_0/hierarchical_decoder_0/and2_dec_14/pnand2_0/nmos_m1_w0_840_sli_dactive_0/a_0_0# vdd 0.01778f ; **FLOATING
C1939 bank_0/port_address_0/hierarchical_decoder_0/and2_dec_14/pnand2_0/pmos_m1_w0_840_sli_dli_1/a_0_0# vdd 0.01834f ; **FLOATING
C1940 bank_0/port_address_0/hierarchical_decoder_0/and2_dec_14/pnand2_0/pmos_m1_w0_840_sli_dli_0/a_0_0# vdd 0.02919f ; **FLOATING
C1941 bank_0/port_address_0/hierarchical_decoder_0/and2_dec_15/pinv_0/w_n127_244# vdd 13.33563f ; **FLOATING
C1942 bank_0/port_address_0/hierarchical_decoder_0/and2_dec_14/pnand2_0/pmos_m1_w0_840_sli_dli_0/a_54_0# vdd 0.02327f ; **FLOATING
C1943 bank_0/port_address_0/wordline_driver_array_0/in_1 vdd 0.91305f ; **FLOATING
C1944 bank_0/port_address_0/hierarchical_decoder_0/and2_dec_14/pinv_0/pmos_m1_w0_840_sli_dli_da_p_0/a_0_0# vdd 0.01676f ; **FLOATING
C1945 bank_0/port_address_0/hierarchical_decoder_0/and2_dec_14/pinv_0/pmos_m1_w0_840_sli_dli_da_p_0/a_54_0# vdd 0.01133f ; **FLOATING
C1946 bank_0/port_address_0/hierarchical_decoder_0/and2_dec_13/pnand2_0/nmos_m1_w0_840_sactive_dli_0/a_54_0# vdd 0.0233f ; **FLOATING
C1947 bank_0/port_address_0/hierarchical_decoder_0/and2_dec_13/pnand2_0/nmos_m1_w0_840_sli_dactive_0/D vdd 0.02406f ; **FLOATING
C1948 bank_0/port_address_0/hierarchical_decoder_0/and2_dec_13/pnand2_0/nmos_m1_w0_840_sli_dactive_0/a_0_0# vdd 0.0177f ; **FLOATING
C1949 bank_0/port_address_0/hierarchical_decoder_0/and2_dec_13/pnand2_0/pmos_m1_w0_840_sli_dli_1/a_0_0# vdd 0.01767f ; **FLOATING
C1950 bank_0/port_address_0/hierarchical_decoder_0/and2_dec_13/pnand2_0/pmos_m1_w0_840_sli_dli_0/a_0_0# vdd 0.02816f ; **FLOATING
C1951 bank_0/port_address_0/hierarchical_decoder_0/and2_dec_13/pnand2_0/pmos_m1_w0_840_sli_dli_0/a_54_0# vdd 0.02262f ; **FLOATING
C1952 bank_0/port_address_0/hierarchical_decoder_0/and2_dec_13/pinv_0/pmos_m1_w0_840_sli_dli_da_p_0/a_0_0# vdd 0.01587f ; **FLOATING
C1953 bank_0/port_address_0/hierarchical_decoder_0/and2_dec_13/pinv_0/pmos_m1_w0_840_sli_dli_da_p_0/a_54_0# vdd 0.01058f ; **FLOATING
C1954 bank_0/port_address_0/hierarchical_decoder_0/and2_dec_12/pnand2_0/nmos_m1_w0_840_sactive_dli_0/a_54_0# vdd 0.02457f ; **FLOATING
C1955 bank_0/port_address_0/hierarchical_decoder_0/and2_dec_12/pnand2_0/nmos_m1_w0_840_sli_dactive_0/D vdd 0.02704f ; **FLOATING
C1956 bank_0/port_address_0/hierarchical_decoder_0/and2_dec_12/pnand2_0/nmos_m1_w0_840_sli_dactive_0/a_0_0# vdd 0.01861f ; **FLOATING
C1957 bank_0/port_address_0/hierarchical_decoder_0/and2_dec_12/pnand2_0/pmos_m1_w0_840_sli_dli_1/a_0_0# vdd 0.01788f ; **FLOATING
C1958 bank_0/port_address_0/hierarchical_decoder_0/and2_dec_12/pnand2_0/pmos_m1_w0_840_sli_dli_0/a_0_0# vdd 0.0284f ; **FLOATING
C1959 bank_0/port_address_0/hierarchical_decoder_0/and2_dec_13/pinv_0/w_n127_244# vdd 13.2272f ; **FLOATING
C1960 bank_0/port_address_0/hierarchical_decoder_0/and2_dec_12/pnand2_0/pmos_m1_w0_840_sli_dli_0/a_54_0# vdd 0.02281f ; **FLOATING
C1961 bank_0/port_address_0/hierarchical_decoder_0/and2_dec_12/pinv_0/pmos_m1_w0_840_sli_dli_da_p_0/a_0_0# vdd 0.01627f ; **FLOATING
C1962 bank_0/port_address_0/hierarchical_decoder_0/and2_dec_12/pinv_0/pmos_m1_w0_840_sli_dli_da_p_0/a_54_0# vdd 0.01087f ; **FLOATING
C1963 bank_0/port_address_0/hierarchical_decoder_0/predecode_5 vdd 3.54893f ; **FLOATING
C1964 bank_0/port_address_0/hierarchical_decoder_0/and2_dec_11/pnand2_0/nmos_m1_w0_840_sactive_dli_0/a_54_0# vdd 0.02401f ; **FLOATING
C1965 bank_0/port_address_0/hierarchical_decoder_0/and2_dec_11/pnand2_0/nmos_m1_w0_840_sli_dactive_0/D vdd 0.02552f ; **FLOATING
C1966 bank_0/port_address_0/hierarchical_decoder_0/and2_dec_11/pnand2_0/nmos_m1_w0_840_sli_dactive_0/a_0_0# vdd 0.01828f ; **FLOATING
C1967 bank_0/port_address_0/hierarchical_decoder_0/and2_dec_11/pnand2_0/pmos_m1_w0_840_sli_dli_1/a_0_0# vdd 0.01786f ; **FLOATING
C1968 bank_0/port_address_0/hierarchical_decoder_0/and2_dec_11/pnand2_0/pmos_m1_w0_840_sli_dli_0/a_0_0# vdd 0.02836f ; **FLOATING
C1969 bank_0/port_address_0/hierarchical_decoder_0/and2_dec_11/pnand2_0/pmos_m1_w0_840_sli_dli_0/a_54_0# vdd 0.02288f ; **FLOATING
C1970 bank_0/port_address_0/hierarchical_decoder_0/and2_dec_11/pinv_0/pmos_m1_w0_840_sli_dli_da_p_0/a_0_0# vdd 0.01664f ; **FLOATING
C1971 bank_0/port_address_0/hierarchical_decoder_0/and2_dec_11/pinv_0/pmos_m1_w0_840_sli_dli_da_p_0/a_54_0# vdd 0.01093f ; **FLOATING
C1972 bank_0/port_address_0/hierarchical_decoder_0/and2_dec_10/pnand2_0/nmos_m1_w0_840_sactive_dli_0/a_54_0# vdd 0.02317f ; **FLOATING
C1973 bank_0/port_address_0/hierarchical_decoder_0/and2_dec_10/pnand2_0/nmos_m1_w0_840_sli_dactive_0/D vdd 0.02386f ; **FLOATING
C1974 bank_0/port_address_0/hierarchical_decoder_0/and2_dec_10/pnand2_0/nmos_m1_w0_840_sli_dactive_0/a_0_0# vdd 0.01773f ; **FLOATING
C1975 bank_0/port_address_0/hierarchical_decoder_0/and2_dec_10/pnand2_0/pmos_m1_w0_840_sli_dli_1/a_0_0# vdd 0.01762f ; **FLOATING
C1976 bank_0/port_address_0/hierarchical_decoder_0/and2_dec_10/pnand2_0/pmos_m1_w0_840_sli_dli_0/a_0_0# vdd 0.02773f ; **FLOATING
C1977 bank_0/port_address_0/hierarchical_decoder_0/and2_dec_11/pinv_0/w_n127_244# vdd 13.2225f ; **FLOATING
C1978 bank_0/port_address_0/hierarchical_decoder_0/and2_dec_10/pnand2_0/pmos_m1_w0_840_sli_dli_0/a_54_0# vdd 0.0226f ; **FLOATING
C1979 bank_0/port_address_0/wordline_driver_array_0/in_5 vdd 0.90785f ; **FLOATING
C1980 bank_0/port_address_0/hierarchical_decoder_0/and2_dec_10/pinv_0/pmos_m1_w0_840_sli_dli_da_p_0/a_0_0# vdd 0.01576f ; **FLOATING
C1981 bank_0/port_address_0/hierarchical_decoder_0/and2_dec_9/pnand2_0/nmos_m1_w0_840_sactive_dli_0/a_54_0# vdd 0.02378f ; **FLOATING
C1982 bank_0/port_address_0/hierarchical_decoder_0/and2_dec_9/pnand2_0/nmos_m1_w0_840_sli_dactive_0/D vdd 0.02525f ; **FLOATING
C1983 bank_0/port_address_0/hierarchical_decoder_0/and2_dec_9/pnand2_0/nmos_m1_w0_840_sli_dactive_0/a_0_0# vdd 0.01818f ; **FLOATING
C1984 bank_0/port_address_0/hierarchical_decoder_0/and2_dec_9/pnand2_0/pmos_m1_w0_840_sli_dli_1/a_0_0# vdd 0.01907f ; **FLOATING
C1985 bank_0/port_address_0/hierarchical_decoder_0/and2_dec_9/pnand2_0/pmos_m1_w0_840_sli_dli_0/a_0_0# vdd 0.02975f ; **FLOATING
C1986 bank_0/port_address_0/hierarchical_decoder_0/and2_dec_9/pnand2_0/pmos_m1_w0_840_sli_dli_0/a_54_0# vdd 0.02389f ; **FLOATING
C1987 bank_0/port_address_0/hierarchical_decoder_0/and2_dec_9/pinv_0/pmos_m1_w0_840_sli_dli_da_p_0/a_0_0# vdd 0.01734f ; **FLOATING
C1988 bank_0/port_address_0/hierarchical_decoder_0/and2_dec_9/pinv_0/pmos_m1_w0_840_sli_dli_da_p_0/a_54_0# vdd 0.01183f ; **FLOATING
C1989 bank_0/port_address_0/hierarchical_decoder_0/hierarchical_predecode2x4_1/pinv_0/Z vdd 3.69982f ; **FLOATING
C1990 bank_0/port_address_0/hierarchical_decoder_0/hierarchical_predecode2x4_1/pinv_1/Z vdd 2.92911f ; **FLOATING
C1991 bank_0/port_address_0/hierarchical_decoder_0/hierarchical_predecode2x4_1/and2_dec_3/pnand2_0/nmos_m1_w0_840_sactive_dli_0/a_54_0# vdd 0.02326f ; **FLOATING
C1992 bank_0/port_address_0/hierarchical_decoder_0/hierarchical_predecode2x4_1/and2_dec_3/pnand2_0/nmos_m1_w0_840_sli_dactive_0/D vdd 0.02416f ; **FLOATING
C1993 bank_0/port_address_0/hierarchical_decoder_0/hierarchical_predecode2x4_1/and2_dec_3/pnand2_0/nmos_m1_w0_840_sli_dactive_0/a_0_0# vdd 0.01793f ; **FLOATING
C1994 bank_0/port_address_0/hierarchical_decoder_0/hierarchical_predecode2x4_1/and2_dec_3/pnand2_0/pmos_m1_w0_840_sli_dli_1/a_0_0# vdd 0.01872f ; **FLOATING
C1995 bank_0/port_address_0/hierarchical_decoder_0/hierarchical_predecode2x4_1/and2_dec_3/pnand2_0/pmos_m1_w0_840_sli_dli_0/a_0_0# vdd 0.02962f ; **FLOATING
C1996 bank_0/port_address_0/hierarchical_decoder_0/hierarchical_predecode2x4_1/and2_dec_3/pnand2_0/pmos_m1_w0_840_sli_dli_0/a_54_0# vdd 0.02364f ; **FLOATING
C1997 bank_0/port_address_0/hierarchical_decoder_0/hierarchical_predecode2x4_1/and2_dec_3/pinv_0/pmos_m1_w0_840_sli_dli_da_p_0/a_0_0# vdd 0.01734f ; **FLOATING
C1998 bank_0/port_address_0/hierarchical_decoder_0/hierarchical_predecode2x4_1/and2_dec_3/pinv_0/pmos_m1_w0_840_sli_dli_da_p_0/a_54_0# vdd 0.01171f ; **FLOATING
C1999 bank_0/port_address_0/hierarchical_decoder_0/hierarchical_predecode2x4_1/pinv_1/pmos_m1_w0_840_sli_dli_da_p_0/a_0_0# vdd 0.01739f ; **FLOATING
C2000 bank_0/port_address_0/hierarchical_decoder_0/hierarchical_predecode2x4_1/pinv_1/pmos_m1_w0_840_sli_dli_da_p_0/a_54_0# vdd 0.01154f ; **FLOATING
C2001 bank_0/port_address_0/hierarchical_decoder_0/hierarchical_predecode2x4_1/pinv_1/w_n127_244# vdd 4.67451f ; **FLOATING
C2002 bank_0/port_address_0/hierarchical_decoder_0/hierarchical_predecode2x4_1/and2_dec_2/pnand2_0/nmos_m1_w0_840_sactive_dli_0/a_54_0# vdd 0.02423f ; **FLOATING
C2003 bank_0/port_address_0/hierarchical_decoder_0/hierarchical_predecode2x4_1/and2_dec_2/pnand2_0/nmos_m1_w0_840_sli_dactive_0/D vdd 0.0286f ; **FLOATING
C2004 bank_0/port_address_0/hierarchical_decoder_0/hierarchical_predecode2x4_1/and2_dec_2/pnand2_0/nmos_m1_w0_840_sli_dactive_0/a_0_0# vdd 0.02201f ; **FLOATING
C2005 bank_0/port_address_0/hierarchical_decoder_0/hierarchical_predecode2x4_1/and2_dec_2/pnand2_0/pmos_m1_w0_840_sli_dli_1/a_0_0# vdd 0.01986f ; **FLOATING
C2006 bank_0/port_address_0/hierarchical_decoder_0/hierarchical_predecode2x4_1/and2_dec_2/pnand2_0/pmos_m1_w0_840_sli_dli_0/a_0_0# vdd 0.03092f ; **FLOATING
C2007 bank_0/port_address_0/hierarchical_decoder_0/hierarchical_predecode2x4_1/and2_dec_3/pinv_0/w_n127_244# vdd 7.57498f ; **FLOATING
C2008 bank_0/port_address_0/hierarchical_decoder_0/hierarchical_predecode2x4_1/and2_dec_2/pnand2_0/pmos_m1_w0_840_sli_dli_0/a_54_0# vdd 0.02427f ; **FLOATING
C2009 bank_0/port_address_0/hierarchical_decoder_0/hierarchical_predecode2x4_1/and2_dec_2/pinv_0/pmos_m1_w0_840_sli_dli_da_p_0/a_0_0# vdd 0.01707f ; **FLOATING
C2010 bank_0/port_address_0/hierarchical_decoder_0/hierarchical_predecode2x4_1/and2_dec_2/pinv_0/pmos_m1_w0_840_sli_dli_da_p_0/a_54_0# vdd 0.01114f ; **FLOATING
C2011 bank_0/addr0_1 vdd 13.16601f
C2012 bank_0/port_address_0/hierarchical_decoder_0/hierarchical_predecode2x4_1/pinv_0/pmos_m1_w0_840_sli_dli_da_p_0/a_0_0# vdd 0.01751f ; **FLOATING
C2013 bank_0/port_address_0/hierarchical_decoder_0/hierarchical_predecode2x4_1/pinv_0/pmos_m1_w0_840_sli_dli_da_p_0/a_54_0# vdd 0.01312f ; **FLOATING
C2014 bank_0/port_address_0/hierarchical_decoder_0/hierarchical_predecode2x4_1/and2_dec_1/pnand2_0/nmos_m1_w0_840_sactive_dli_0/a_54_0# vdd 0.02429f ; **FLOATING
C2015 bank_0/port_address_0/hierarchical_decoder_0/hierarchical_predecode2x4_1/and2_dec_1/pnand2_0/nmos_m1_w0_840_sli_dactive_0/D vdd 0.027f ; **FLOATING
C2016 bank_0/port_address_0/hierarchical_decoder_0/hierarchical_predecode2x4_1/and2_dec_1/pnand2_0/nmos_m1_w0_840_sli_dactive_0/a_0_0# vdd 0.01915f ; **FLOATING
C2017 bank_0/port_address_0/hierarchical_decoder_0/hierarchical_predecode2x4_1/and2_dec_1/pnand2_0/pmos_m1_w0_840_sli_dli_1/a_0_0# vdd 0.01831f ; **FLOATING
C2018 bank_0/port_address_0/hierarchical_decoder_0/hierarchical_predecode2x4_1/and2_dec_1/pnand2_0/pmos_m1_w0_840_sli_dli_0/a_0_0# vdd 0.02949f ; **FLOATING
C2019 bank_0/port_address_0/hierarchical_decoder_0/hierarchical_predecode2x4_1/and2_dec_1/pnand2_0/pmos_m1_w0_840_sli_dli_0/a_54_0# vdd 0.02315f ; **FLOATING
C2020 bank_0/port_address_0/hierarchical_decoder_0/hierarchical_predecode2x4_1/and2_dec_1/pinv_0/pmos_m1_w0_840_sli_dli_da_p_0/a_0_0# vdd 0.01611f ; **FLOATING
C2021 bank_0/port_address_0/hierarchical_decoder_0/hierarchical_predecode2x4_1/and2_dec_1/pinv_0/pmos_m1_w0_840_sli_dli_da_p_0/a_54_0# vdd 0.01012f ; **FLOATING
C2022 bank_0/port_address_0/hierarchical_decoder_0/hierarchical_predecode2x4_1/and2_dec_0/pnand2_0/nmos_m1_w0_840_sactive_dli_0/a_54_0# vdd 0.02507f ; **FLOATING
C2023 bank_0/port_address_0/hierarchical_decoder_0/hierarchical_predecode2x4_1/and2_dec_0/pnand2_0/nmos_m1_w0_840_sli_dactive_0/D vdd 0.03048f ; **FLOATING
C2024 bank_0/port_address_0/hierarchical_decoder_0/hierarchical_predecode2x4_1/and2_dec_0/pnand2_0/nmos_m1_w0_840_sli_dactive_0/a_0_0# vdd 0.02282f ; **FLOATING
C2025 bank_0/port_address_0/hierarchical_decoder_0/hierarchical_predecode2x4_1/and2_dec_0/pnand2_0/pmos_m1_w0_840_sli_dli_1/a_0_0# vdd 0.01867f ; **FLOATING
C2026 bank_0/port_address_0/hierarchical_decoder_0/hierarchical_predecode2x4_1/and2_dec_0/pnand2_0/pmos_m1_w0_840_sli_dli_0/a_0_0# vdd 0.02983f ; **FLOATING
C2027 bank_0/port_address_0/hierarchical_decoder_0/hierarchical_predecode2x4_1/and2_dec_1/pinv_0/w_n127_244# vdd 7.49574f ; **FLOATING
C2028 bank_0/port_address_0/hierarchical_decoder_0/hierarchical_predecode2x4_1/and2_dec_0/pnand2_0/pmos_m1_w0_840_sli_dli_0/a_54_0# vdd 0.02329f ; **FLOATING
C2029 bank_0/port_address_0/hierarchical_decoder_0/predecode_3 vdd 4.63594f ; **FLOATING
C2030 bank_0/port_address_0/hierarchical_decoder_0/hierarchical_predecode2x4_1/and2_dec_0/pinv_0/pmos_m1_w0_840_sli_dli_da_p_0/a_0_0# vdd 0.01627f ; **FLOATING
C2031 bank_0/port_address_0/hierarchical_decoder_0/hierarchical_predecode2x4_1/and2_dec_0/pinv_0/pmos_m1_w0_840_sli_dli_da_p_0/a_54_0# vdd 0.01017f ; **FLOATING
C2032 bank_0/port_address_0/hierarchical_decoder_0/and2_dec_8/pnand2_0/nmos_m1_w0_840_sactive_dli_0/a_54_0# vdd 0.0238f ; **FLOATING
C2033 bank_0/port_address_0/hierarchical_decoder_0/and2_dec_8/pnand2_0/nmos_m1_w0_840_sli_dactive_0/D vdd 0.02502f ; **FLOATING
C2034 bank_0/port_address_0/hierarchical_decoder_0/and2_dec_8/pnand2_0/nmos_m1_w0_840_sli_dactive_0/a_0_0# vdd 0.01808f ; **FLOATING
C2035 bank_0/port_address_0/hierarchical_decoder_0/and2_dec_8/pnand2_0/pmos_m1_w0_840_sli_dli_1/a_0_0# vdd 0.01862f ; **FLOATING
C2036 bank_0/port_address_0/hierarchical_decoder_0/and2_dec_8/pnand2_0/pmos_m1_w0_840_sli_dli_0/a_0_0# vdd 0.02951f ; **FLOATING
C2037 bank_0/port_address_0/hierarchical_decoder_0/and2_dec_9/pinv_0/w_n127_244# vdd 13.39346f ; **FLOATING
C2038 bank_0/port_address_0/hierarchical_decoder_0/and2_dec_8/pnand2_0/pmos_m1_w0_840_sli_dli_0/a_54_0# vdd 0.02359f ; **FLOATING
C2039 bank_0/port_address_0/hierarchical_decoder_0/and2_dec_8/pinv_0/pmos_m1_w0_840_sli_dli_da_p_0/a_0_0# vdd 0.01723f ; **FLOATING
C2040 bank_0/port_address_0/hierarchical_decoder_0/and2_dec_8/pinv_0/pmos_m1_w0_840_sli_dli_da_p_0/a_54_0# vdd 0.01178f ; **FLOATING
C2041 bank_0/port_address_0/hierarchical_decoder_0/hierarchical_predecode2x4_0/pinv_0/Z vdd 2.15786f ; **FLOATING
C2042 bank_0/port_address_0/hierarchical_decoder_0/hierarchical_predecode2x4_0/pinv_1/Z vdd 2.73005f ; **FLOATING
C2043 bank_0/port_address_0/hierarchical_decoder_0/hierarchical_predecode2x4_0/and2_dec_3/pnand2_0/nmos_m1_w0_840_sactive_dli_0/a_54_0# vdd 0.02396f ; **FLOATING
C2044 bank_0/port_address_0/hierarchical_decoder_0/hierarchical_predecode2x4_0/and2_dec_3/pnand2_0/nmos_m1_w0_840_sli_dactive_0/D vdd 0.02606f ; **FLOATING
C2045 bank_0/port_address_0/hierarchical_decoder_0/hierarchical_predecode2x4_0/and2_dec_3/pnand2_0/nmos_m1_w0_840_sli_dactive_0/a_0_0# vdd 0.01835f ; **FLOATING
C2046 bank_0/port_address_0/hierarchical_decoder_0/hierarchical_predecode2x4_0/and2_dec_3/pnand2_0/pmos_m1_w0_840_sli_dli_1/a_0_0# vdd 0.01876f ; **FLOATING
C2047 bank_0/port_address_0/hierarchical_decoder_0/hierarchical_predecode2x4_0/and2_dec_3/pnand2_0/pmos_m1_w0_840_sli_dli_0/a_0_0# vdd 0.0299f ; **FLOATING
C2048 bank_0/port_address_0/hierarchical_decoder_0/hierarchical_predecode2x4_0/and2_dec_3/pnand2_0/pmos_m1_w0_840_sli_dli_0/a_54_0# vdd 0.02368f ; **FLOATING
C2049 bank_0/port_address_0/hierarchical_decoder_0/hierarchical_predecode2x4_0/and2_dec_3/pinv_0/pmos_m1_w0_840_sli_dli_da_p_0/a_0_0# vdd 0.01735f ; **FLOATING
C2050 bank_0/port_address_0/hierarchical_decoder_0/hierarchical_predecode2x4_0/and2_dec_3/pinv_0/pmos_m1_w0_840_sli_dli_da_p_0/a_54_0# vdd 0.01164f ; **FLOATING
C2051 bank_0/addr0_2 vdd 5.14761f
C2052 bank_0/port_address_0/hierarchical_decoder_0/hierarchical_predecode2x4_0/pinv_1/pmos_m1_w0_840_sli_dli_da_p_0/a_0_0# vdd 0.01627f ; **FLOATING
C2053 bank_0/port_address_0/hierarchical_decoder_0/hierarchical_predecode2x4_0/pinv_1/pmos_m1_w0_840_sli_dli_da_p_0/a_54_0# vdd 0.01153f ; **FLOATING
C2054 bank_0/port_address_0/hierarchical_decoder_0/hierarchical_predecode2x4_0/pinv_1/w_n127_244# vdd 4.57378f ; **FLOATING
C2055 bank_0/port_address_0/hierarchical_decoder_0/hierarchical_predecode2x4_0/and2_dec_2/pnand2_0/nmos_m1_w0_840_sactive_dli_0/a_54_0# vdd 0.02372f ; **FLOATING
C2056 bank_0/port_address_0/hierarchical_decoder_0/hierarchical_predecode2x4_0/and2_dec_2/pnand2_0/nmos_m1_w0_840_sli_dactive_0/D vdd 0.02503f ; **FLOATING
C2057 bank_0/port_address_0/hierarchical_decoder_0/hierarchical_predecode2x4_0/and2_dec_2/pnand2_0/nmos_m1_w0_840_sli_dactive_0/a_0_0# vdd 0.01803f ; **FLOATING
C2058 bank_0/port_address_0/hierarchical_decoder_0/hierarchical_predecode2x4_0/and2_dec_2/pnand2_0/pmos_m1_w0_840_sli_dli_1/a_0_0# vdd 0.01849f ; **FLOATING
C2059 bank_0/port_address_0/hierarchical_decoder_0/hierarchical_predecode2x4_0/and2_dec_2/pnand2_0/pmos_m1_w0_840_sli_dli_0/a_0_0# vdd 0.02971f ; **FLOATING
C2060 bank_0/port_address_0/hierarchical_decoder_0/hierarchical_predecode2x4_0/and2_dec_3/pinv_0/w_n127_244# vdd 7.51111f ; **FLOATING
C2061 bank_0/port_address_0/hierarchical_decoder_0/hierarchical_predecode2x4_0/and2_dec_2/pnand2_0/pmos_m1_w0_840_sli_dli_0/a_54_0# vdd 0.02327f ; **FLOATING
C2062 bank_0/port_address_0/hierarchical_decoder_0/hierarchical_predecode2x4_0/and2_dec_2/pinv_0/pmos_m1_w0_840_sli_dli_da_p_0/a_0_0# vdd 0.01641f ; **FLOATING
C2063 bank_0/port_address_0/hierarchical_decoder_0/hierarchical_predecode2x4_0/and2_dec_2/pinv_0/pmos_m1_w0_840_sli_dli_da_p_0/a_54_0# vdd 0.01071f ; **FLOATING
C2064 bank_0/addr0_3 vdd 8.33221f
C2065 bank_0/port_address_0/hierarchical_decoder_0/hierarchical_predecode2x4_0/pinv_0/pmos_m1_w0_840_sli_dli_da_p_0/a_0_0# vdd 0.01651f ; **FLOATING
C2066 bank_0/port_address_0/hierarchical_decoder_0/hierarchical_predecode2x4_0/pinv_0/pmos_m1_w0_840_sli_dli_da_p_0/a_54_0# vdd 0.01257f ; **FLOATING
C2067 bank_0/port_address_0/hierarchical_decoder_0/hierarchical_predecode2x4_0/and2_dec_1/pnand2_0/nmos_m1_w0_840_sactive_dli_0/a_54_0# vdd 0.02415f ; **FLOATING
C2068 bank_0/port_address_0/hierarchical_decoder_0/hierarchical_predecode2x4_0/and2_dec_1/pnand2_0/nmos_m1_w0_840_sli_dactive_0/D vdd 0.02587f ; **FLOATING
C2069 bank_0/port_address_0/hierarchical_decoder_0/hierarchical_predecode2x4_0/and2_dec_1/pnand2_0/nmos_m1_w0_840_sli_dactive_0/a_0_0# vdd 0.01837f ; **FLOATING
C2070 bank_0/port_address_0/hierarchical_decoder_0/hierarchical_predecode2x4_0/and2_dec_1/pnand2_0/pmos_m1_w0_840_sli_dli_1/a_0_0# vdd 0.01804f ; **FLOATING
C2071 bank_0/port_address_0/hierarchical_decoder_0/hierarchical_predecode2x4_0/and2_dec_1/pnand2_0/pmos_m1_w0_840_sli_dli_0/a_0_0# vdd 0.02901f ; **FLOATING
C2072 bank_0/port_address_0/hierarchical_decoder_0/hierarchical_predecode2x4_0/and2_dec_1/pnand2_0/pmos_m1_w0_840_sli_dli_0/a_54_0# vdd 0.02287f ; **FLOATING
C2073 bank_0/port_address_0/hierarchical_decoder_0/predecode_6 vdd 3.24712f ; **FLOATING
C2074 bank_0/port_address_0/hierarchical_decoder_0/hierarchical_predecode2x4_0/and2_dec_1/pinv_0/pmos_m1_w0_840_sli_dli_da_p_0/a_0_0# vdd 0.01577f ; **FLOATING
C2075 bank_0/port_address_0/hierarchical_decoder_0/hierarchical_predecode2x4_0/and2_dec_0/pnand2_0/nmos_m1_w0_840_sactive_dli_0/a_54_0# vdd 0.02376f ; **FLOATING
C2076 bank_0/port_address_0/hierarchical_decoder_0/hierarchical_predecode2x4_0/and2_dec_0/pnand2_0/nmos_m1_w0_840_sli_dactive_0/D vdd 0.02592f ; **FLOATING
C2077 bank_0/port_address_0/hierarchical_decoder_0/hierarchical_predecode2x4_0/and2_dec_0/pnand2_0/nmos_m1_w0_840_sli_dactive_0/a_0_0# vdd 0.0185f ; **FLOATING
C2078 bank_0/port_address_0/hierarchical_decoder_0/hierarchical_predecode2x4_0/and2_dec_0/pnand2_0/pmos_m1_w0_840_sli_dli_1/a_0_0# vdd 0.01786f ; **FLOATING
C2079 bank_0/port_address_0/hierarchical_decoder_0/hierarchical_predecode2x4_0/and2_dec_0/pnand2_0/pmos_m1_w0_840_sli_dli_0/a_0_0# vdd 0.02848f ; **FLOATING
C2080 bank_0/port_address_0/hierarchical_decoder_0/hierarchical_predecode2x4_0/and2_dec_1/pinv_0/w_n127_244# vdd 7.40297f ; **FLOATING
C2081 bank_0/port_address_0/hierarchical_decoder_0/hierarchical_predecode2x4_0/and2_dec_0/pnand2_0/pmos_m1_w0_840_sli_dli_0/a_54_0# vdd 0.02274f ; **FLOATING
C2082 bank_0/port_address_0/hierarchical_decoder_0/predecode_7 vdd 5.51367f ; **FLOATING
C2083 bank_0/port_address_0/hierarchical_decoder_0/hierarchical_predecode2x4_0/and2_dec_0/pinv_0/pmos_m1_w0_840_sli_dli_da_p_0/a_0_0# vdd 0.0157f ; **FLOATING
C2084 bank_0/port_address_0/hierarchical_decoder_0/and2_dec_7/pnand2_0/nmos_m1_w0_840_sactive_dli_0/a_54_0# vdd 0.02368f ; **FLOATING
C2085 bank_0/port_address_0/hierarchical_decoder_0/and2_dec_7/pnand2_0/nmos_m1_w0_840_sli_dactive_0/D vdd 0.02463f ; **FLOATING
C2086 bank_0/port_address_0/hierarchical_decoder_0/and2_dec_7/pnand2_0/nmos_m1_w0_840_sli_dactive_0/a_0_0# vdd 0.01794f ; **FLOATING
C2087 bank_0/port_address_0/hierarchical_decoder_0/and2_dec_7/pnand2_0/pmos_m1_w0_840_sli_dli_1/a_0_0# vdd 0.01766f ; **FLOATING
C2088 bank_0/port_address_0/hierarchical_decoder_0/and2_dec_7/pnand2_0/pmos_m1_w0_840_sli_dli_0/a_0_0# vdd 0.02813f ; **FLOATING
C2089 bank_0/port_address_0/hierarchical_decoder_0/and2_dec_7/pnand2_0/pmos_m1_w0_840_sli_dli_0/a_54_0# vdd 0.02267f ; **FLOATING
C2090 bank_0/port_address_0/hierarchical_decoder_0/and2_dec_7/pinv_0/pmos_m1_w0_840_sli_dli_da_p_0/a_0_0# vdd 0.01615f ; **FLOATING
C2091 bank_0/port_address_0/hierarchical_decoder_0/and2_dec_7/pinv_0/pmos_m1_w0_840_sli_dli_da_p_0/a_54_0# vdd 0.01068f ; **FLOATING
C2092 bank_0/port_address_0/hierarchical_decoder_0/and2_dec_6/pnand2_0/nmos_m1_w0_840_sactive_dli_0/a_54_0# vdd 0.02363f ; **FLOATING
C2093 bank_0/port_address_0/hierarchical_decoder_0/and2_dec_6/pnand2_0/nmos_m1_w0_840_sli_dactive_0/D vdd 0.02474f ; **FLOATING
C2094 bank_0/port_address_0/hierarchical_decoder_0/and2_dec_6/pnand2_0/nmos_m1_w0_840_sli_dactive_0/a_0_0# vdd 0.01797f ; **FLOATING
C2095 bank_0/port_address_0/hierarchical_decoder_0/and2_dec_6/pnand2_0/pmos_m1_w0_840_sli_dli_1/a_0_0# vdd 0.01765f ; **FLOATING
C2096 bank_0/port_address_0/hierarchical_decoder_0/and2_dec_6/pnand2_0/pmos_m1_w0_840_sli_dli_0/a_0_0# vdd 0.02801f ; **FLOATING
C2097 bank_0/port_address_0/hierarchical_decoder_0/and2_dec_7/pinv_0/w_n127_244# vdd 13.214f ; **FLOATING
C2098 bank_0/port_address_0/hierarchical_decoder_0/and2_dec_6/pnand2_0/pmos_m1_w0_840_sli_dli_0/a_54_0# vdd 0.02265f ; **FLOATING
C2099 bank_0/port_address_0/hierarchical_decoder_0/and2_dec_6/pinv_0/pmos_m1_w0_840_sli_dli_da_p_0/a_0_0# vdd 0.01602f ; **FLOATING
C2100 bank_0/port_address_0/hierarchical_decoder_0/and2_dec_6/pinv_0/pmos_m1_w0_840_sli_dli_da_p_0/a_54_0# vdd 0.01039f ; **FLOATING
C2101 bank_0/port_address_0/hierarchical_decoder_0/predecode_4 vdd 3.6285f ; **FLOATING
C2102 bank_0/port_address_0/hierarchical_decoder_0/and2_dec_5/pnand2_0/nmos_m1_w0_840_sactive_dli_0/a_54_0# vdd 0.02311f ; **FLOATING
C2103 bank_0/port_address_0/hierarchical_decoder_0/and2_dec_5/pnand2_0/nmos_m1_w0_840_sli_dactive_0/D vdd 0.02373f ; **FLOATING
C2104 bank_0/port_address_0/hierarchical_decoder_0/and2_dec_5/pnand2_0/nmos_m1_w0_840_sli_dactive_0/a_0_0# vdd 0.01768f ; **FLOATING
C2105 bank_0/port_address_0/hierarchical_decoder_0/and2_dec_5/pnand2_0/pmos_m1_w0_840_sli_dli_1/a_0_0# vdd 0.0176f ; **FLOATING
C2106 bank_0/port_address_0/hierarchical_decoder_0/and2_dec_5/pnand2_0/pmos_m1_w0_840_sli_dli_0/a_0_0# vdd 0.02793f ; **FLOATING
C2107 bank_0/port_address_0/hierarchical_decoder_0/and2_dec_5/pnand2_0/pmos_m1_w0_840_sli_dli_0/a_54_0# vdd 0.02264f ; **FLOATING
C2108 bank_0/port_address_0/hierarchical_decoder_0/and2_dec_5/pinv_0/pmos_m1_w0_840_sli_dli_da_p_0/a_0_0# vdd 0.016f ; **FLOATING
C2109 bank_0/port_address_0/hierarchical_decoder_0/and2_dec_5/pinv_0/pmos_m1_w0_840_sli_dli_da_p_0/a_54_0# vdd 0.01022f ; **FLOATING
C2110 bank_0/port_address_0/hierarchical_decoder_0/and2_dec_4/pnand2_0/nmos_m1_w0_840_sactive_dli_0/a_54_0# vdd 0.02296f ; **FLOATING
C2111 bank_0/port_address_0/hierarchical_decoder_0/and2_dec_4/pnand2_0/nmos_m1_w0_840_sli_dactive_0/D vdd 0.02305f ; **FLOATING
C2112 bank_0/port_address_0/hierarchical_decoder_0/and2_dec_4/pnand2_0/nmos_m1_w0_840_sli_dactive_0/a_0_0# vdd 0.01739f ; **FLOATING
C2113 bank_0/port_address_0/hierarchical_decoder_0/and2_dec_4/pnand2_0/pmos_m1_w0_840_sli_dli_1/a_0_0# vdd 0.01739f ; **FLOATING
C2114 bank_0/port_address_0/hierarchical_decoder_0/and2_dec_4/pnand2_0/pmos_m1_w0_840_sli_dli_0/a_0_0# vdd 0.02771f ; **FLOATING
C2115 bank_0/port_address_0/hierarchical_decoder_0/and2_dec_5/pinv_0/w_n127_244# vdd 13.10578f ; **FLOATING
C2116 bank_0/port_address_0/hierarchical_decoder_0/and2_dec_4/pnand2_0/pmos_m1_w0_840_sli_dli_0/a_54_0# vdd 0.02242f ; **FLOATING
C2117 bank_0/port_address_0/hierarchical_decoder_0/and2_dec_4/pinv_0/pmos_m1_w0_840_sli_dli_da_p_0/a_0_0# vdd 0.01575f ; **FLOATING
C2118 bank_0/port_address_0/hierarchical_decoder_0/and2_dec_4/pinv_0/pmos_m1_w0_840_sli_dli_da_p_0/a_54_0# vdd 0.01013f ; **FLOATING
C2119 bank_0/port_address_0/hierarchical_decoder_0/and2_dec_3/pnand2_0/nmos_m1_w0_840_sactive_dli_0/a_54_0# vdd 0.02299f ; **FLOATING
C2120 bank_0/port_address_0/hierarchical_decoder_0/and2_dec_3/pnand2_0/nmos_m1_w0_840_sli_dactive_0/D vdd 0.02333f ; **FLOATING
C2121 bank_0/port_address_0/hierarchical_decoder_0/and2_dec_3/pnand2_0/nmos_m1_w0_840_sli_dactive_0/a_0_0# vdd 0.01743f ; **FLOATING
C2122 bank_0/port_address_0/hierarchical_decoder_0/and2_dec_3/pnand2_0/pmos_m1_w0_840_sli_dli_1/a_0_0# vdd 0.01732f ; **FLOATING
C2123 bank_0/port_address_0/hierarchical_decoder_0/and2_dec_3/pnand2_0/pmos_m1_w0_840_sli_dli_0/a_0_0# vdd 0.02762f ; **FLOATING
C2124 bank_0/port_address_0/hierarchical_decoder_0/and2_dec_3/pnand2_0/pmos_m1_w0_840_sli_dli_0/a_54_0# vdd 0.02234f ; **FLOATING
C2125 bank_0/port_address_0/hierarchical_decoder_0/and2_dec_3/pinv_0/pmos_m1_w0_840_sli_dli_da_p_0/a_0_0# vdd 0.01557f ; **FLOATING
C2126 bank_0/port_address_0/hierarchical_decoder_0/and2_dec_3/pinv_0/pmos_m1_w0_840_sli_dli_da_p_0/a_54_0# vdd 0.01001f ; **FLOATING
C2127 bank_0/port_address_0/hierarchical_decoder_0/and2_dec_2/pnand2_0/nmos_m1_w0_840_sactive_dli_0/a_54_0# vdd 0.02345f ; **FLOATING
C2128 bank_0/port_address_0/hierarchical_decoder_0/and2_dec_2/pnand2_0/nmos_m1_w0_840_sli_dactive_0/D vdd 0.0244f ; **FLOATING
C2129 bank_0/port_address_0/hierarchical_decoder_0/and2_dec_2/pnand2_0/nmos_m1_w0_840_sli_dactive_0/a_0_0# vdd 0.01774f ; **FLOATING
C2130 bank_0/port_address_0/hierarchical_decoder_0/and2_dec_2/pnand2_0/pmos_m1_w0_840_sli_dli_1/a_0_0# vdd 0.0176f ; **FLOATING
C2131 bank_0/port_address_0/hierarchical_decoder_0/and2_dec_2/pnand2_0/pmos_m1_w0_840_sli_dli_0/a_0_0# vdd 0.02808f ; **FLOATING
C2132 bank_0/port_address_0/hierarchical_decoder_0/and2_dec_3/pinv_0/w_n127_244# vdd 13.14196f ; **FLOATING
C2133 bank_0/port_address_0/hierarchical_decoder_0/and2_dec_2/pnand2_0/pmos_m1_w0_840_sli_dli_0/a_54_0# vdd 0.02265f ; **FLOATING
C2134 bank_0/port_address_0/hierarchical_decoder_0/and2_dec_2/pinv_0/pmos_m1_w0_840_sli_dli_da_p_0/a_0_0# vdd 0.01608f ; **FLOATING
C2135 bank_0/port_address_0/hierarchical_decoder_0/and2_dec_2/pinv_0/pmos_m1_w0_840_sli_dli_da_p_0/a_54_0# vdd 0.01065f ; **FLOATING
C2136 bank_0/port_address_0/hierarchical_decoder_0/and2_dec_1/pnand2_0/nmos_m1_w0_840_sactive_dli_0/a_54_0# vdd 0.02319f ; **FLOATING
C2137 bank_0/port_address_0/hierarchical_decoder_0/and2_dec_1/pnand2_0/nmos_m1_w0_840_sli_dactive_0/D vdd 0.02374f ; **FLOATING
C2138 bank_0/port_address_0/hierarchical_decoder_0/and2_dec_1/pnand2_0/nmos_m1_w0_840_sli_dactive_0/a_0_0# vdd 0.01766f ; **FLOATING
C2139 bank_0/port_address_0/hierarchical_decoder_0/and2_dec_1/pnand2_0/pmos_m1_w0_840_sli_dli_1/a_0_0# vdd 0.01779f ; **FLOATING
C2140 bank_0/port_address_0/hierarchical_decoder_0/and2_dec_1/pnand2_0/pmos_m1_w0_840_sli_dli_0/a_0_0# vdd 0.02808f ; **FLOATING
C2141 bank_0/port_address_0/hierarchical_decoder_0/and2_dec_1/pnand2_0/pmos_m1_w0_840_sli_dli_0/a_54_0# vdd 0.0229f ; **FLOATING
C2142 bank_0/port_address_0/hierarchical_decoder_0/and2_dec_1/pinv_0/pmos_m1_w0_840_sli_dli_da_p_0/a_0_0# vdd 0.0166f ; **FLOATING
C2143 bank_0/port_address_0/hierarchical_decoder_0/and2_dec_1/pinv_0/pmos_m1_w0_840_sli_dli_da_p_0/a_54_0# vdd 0.01064f ; **FLOATING
C2144 bank_0/port_address_0/hierarchical_decoder_0/and2_dec_0/pnand2_0/nmos_m1_w0_840_sactive_dli_0/a_54_0# vdd 0.02276f ; **FLOATING
C2145 bank_0/port_address_0/hierarchical_decoder_0/and2_dec_0/pnand2_0/nmos_m1_w0_840_sli_dactive_0/D vdd 0.02286f ; **FLOATING
C2146 bank_0/port_address_0/hierarchical_decoder_0/and2_dec_0/pnand2_0/nmos_m1_w0_840_sli_dactive_0/a_0_0# vdd 0.01737f ; **FLOATING
C2147 bank_0/port_address_0/hierarchical_decoder_0/and2_dec_0/pnand2_0/pmos_m1_w0_840_sli_dli_1/a_0_0# vdd 0.01754f ; **FLOATING
C2148 bank_0/port_address_0/hierarchical_decoder_0/and2_dec_0/pnand2_0/pmos_m1_w0_840_sli_dli_0/a_0_0# vdd 0.02783f ; **FLOATING
C2149 bank_0/port_address_0/hierarchical_decoder_0/and2_dec_1/pinv_0/w_n127_244# vdd 13.14102f ; **FLOATING
C2150 bank_0/port_address_0/hierarchical_decoder_0/and2_dec_0/pnand2_0/pmos_m1_w0_840_sli_dli_0/a_54_0# vdd 0.02262f ; **FLOATING
C2151 bank_0/port_address_0/hierarchical_decoder_0/and2_dec_0/pinv_0/pmos_m1_w0_840_sli_dli_da_p_0/a_0_0# vdd 0.01613f ; **FLOATING
C2152 bank_0/port_address_0/hierarchical_decoder_0/and2_dec_0/pinv_0/pmos_m1_w0_840_sli_dli_da_p_0/a_54_0# vdd 0.01035f ; **FLOATING
C2153 bank_0/port_address_0/and2_dec_0_0/pnand2_0/nmos_m1_w0_840_sactive_dli_0/a_54_0# vdd 0.02565f ; **FLOATING
C2154 bank_0/port_address_0/and2_dec_0_0/pnand2_0/nmos_m1_w0_840_sli_dactive_0/D vdd 0.02767f ; **FLOATING
C2155 bank_0/port_address_0/and2_dec_0_0/pnand2_0/nmos_m1_w0_840_sli_dactive_0/a_0_0# vdd 0.01961f ; **FLOATING
C2156 bank_0/port_address_0/and2_dec_0_0/pnand2_0/pmos_m1_w0_840_sli_dli_1/a_0_0# vdd 0.02049f ; **FLOATING
C2157 bank_0/port_address_0/and2_dec_0_0/pnand2_0/pmos_m1_w0_840_sli_dli_0/a_0_0# vdd 0.03042f ; **FLOATING
C2158 bank_0/port_address_0/and2_dec_0_0/pinv_0/w_n127_244# vdd 6.84936f ; **FLOATING
C2159 bank_0/port_address_0/and2_dec_0_0/pnand2_0/pmos_m1_w0_840_sli_dli_0/a_54_0# vdd 0.02331f ; **FLOATING
C2160 bank_0/port_address_0/and2_dec_0_0/pinv_0/pmos_m1_w0_840_sli_dli_da_p_0/a_0_0# vdd 0.01682f ; **FLOATING
C2161 bank_0/port_address_0/and2_dec_0_0/pinv_0/pmos_m1_w0_840_sli_dli_da_p_0/a_54_0# vdd 0.0112f ; **FLOATING
C2162 bank_0/port_data_0/precharge_array_0/precharge_0_2/pmos_m1_w0_840_sli_dli_2/a_0_0# vdd 0.02296f ; **FLOATING
C2163 bank_0/port_data_0/precharge_array_0/precharge_0_2/pmos_m1_w0_840_sli_dli_2/a_54_0# vdd 0.02129f ; **FLOATING
C2164 bank_0/port_data_0/precharge_array_0/precharge_0_2/pmos_m1_w0_840_sli_dli_1/a_0_0# vdd 0.02544f ; **FLOATING
C2165 bank_0/port_data_0/precharge_array_0/precharge_0_2/pmos_m1_w0_840_sli_dli_0/a_0_0# vdd 0.03084f ; **FLOATING
C2166 bank_0/p_en_bar0 vdd 8.06684f ; **FLOATING
C2167 bank_0/port_data_0/precharge_array_0/precharge_0_2/pmos_m1_w0_840_sli_dli_0/a_54_0# vdd 0.02348f ; **FLOATING
C2168 bank_0/port_data_0/precharge_array_0/precharge_0_1/pmos_m1_w0_840_sli_dli_2/a_0_0# vdd 0.02362f ; **FLOATING
C2169 bank_0/port_data_0/precharge_array_0/precharge_0_1/pmos_m1_w0_840_sli_dli_2/a_54_0# vdd 0.02232f ; **FLOATING
C2170 bank_0/port_data_0/precharge_array_0/precharge_0_1/pmos_m1_w0_840_sli_dli_1/a_0_0# vdd 0.02614f ; **FLOATING
C2171 bank_0/port_data_0/precharge_array_0/precharge_0_1/pmos_m1_w0_840_sli_dli_0/a_0_0# vdd 0.03167f ; **FLOATING
C2172 bank_0/port_data_0/precharge_array_0/precharge_0_2/w_0_0# vdd 11.87683f ; **FLOATING
C2173 bank_0/port_data_0/precharge_array_0/precharge_0_1/pmos_m1_w0_840_sli_dli_0/a_54_0# vdd 0.02415f ; **FLOATING
C2174 bank_0/port_data_0/precharge_array_0/precharge_0_0/pmos_m1_w0_840_sli_dli_2/a_0_0# vdd 0.02437f ; **FLOATING
C2175 bank_0/port_data_0/precharge_array_0/precharge_0_0/pmos_m1_w0_840_sli_dli_2/a_54_0# vdd 0.02173f ; **FLOATING
C2176 bank_0/port_data_0/precharge_array_0/precharge_0_0/pmos_m1_w0_840_sli_dli_1/a_0_0# vdd 0.02662f ; **FLOATING
C2177 bank_0/port_data_0/precharge_array_0/precharge_0_0/pmos_m1_w0_840_sli_dli_0/a_0_0# vdd 0.03115f ; **FLOATING
C2178 bank_0/port_data_0/precharge_array_0/precharge_0_0/pmos_m1_w0_840_sli_dli_0/a_54_0# vdd 0.02281f ; **FLOATING
C2179 bank_0/port_data_0/write_driver_array_0/write_driver_0/net6 vdd 0.18947f
C2180 bank_0/port_data_0/write_driver_array_0/write_driver_0/net5 vdd 0.20405f
C2181 bank_0/port_data_0/sense_amp_array_0/sense_amp_1/net1 vdd 0.8613f
C2182 row_addr_dff_0/dff_3/net5 vdd 0.47962f
C2183 row_addr_dff_0/dff_3/net2 vdd 0.36049f
C2184 row_addr_dff_0/dff_3/net4 vdd 1.00645f
C2185 row_addr_dff_0/dff_3/net1 vdd 0.66051f
C2186 row_addr_dff_0/dff_3/net3 vdd 0.83372f
C2187 row_addr_dff_0/dff_3/clkb vdd 1.36078f
C2188 row_addr_dff_0/dff_3/clk vdd 7.41981f
C2189 row_addr_dff_0/dff_2/net5 vdd 0.38106f
C2190 row_addr_dff_0/dff_2/net2 vdd 0.35096f
C2191 addr0[1] vdd 0.81553f
C2192 row_addr_dff_0/dff_2/net4 vdd 0.7377f
C2193 row_addr_dff_0/dff_2/net1 vdd 0.62622f
C2194 row_addr_dff_0/dff_2/net3 vdd 0.82331f
C2195 row_addr_dff_0/dff_2/clkb vdd 1.28409f
C2196 row_addr_dff_0/dff_1/net5 vdd 0.37459f
C2197 row_addr_dff_0/dff_1/net2 vdd 0.35203f
C2198 addr0[2] vdd 0.44417f
C2199 row_addr_dff_0/dff_1/net4 vdd 0.73207f
C2200 row_addr_dff_0/dff_1/net1 vdd 0.62644f
C2201 row_addr_dff_0/dff_1/net3 vdd 0.82415f
C2202 row_addr_dff_0/dff_1/clkb vdd 1.27685f
C2203 row_addr_dff_0/dff_0/net5 vdd 0.3618f
C2204 row_addr_dff_0/dff_0/net2 vdd 0.33784f
C2205 addr0[3] vdd 0.46169f
C2206 row_addr_dff_0/dff_0/net4 vdd 0.71684f
C2207 row_addr_dff_0/dff_0/net1 vdd 0.61318f
C2208 row_addr_dff_0/dff_0/net3 vdd 0.80031f
C2209 row_addr_dff_0/dff_0/clkb vdd 1.25361f
C2210 control_logic_rw_0/pdriver_0_0/pinv_5_0/Z vdd 0.41656f ; **FLOATING
C2211 control_logic_rw_0/pdriver_0_0/pinv_6_0/A vdd 0.61048f ; **FLOATING
C2212 control_logic_rw_0/pdriver_0_0/pinv_7_0/A vdd 1.93675f ; **FLOATING
C2213 clk0 vdd 0.66003f ; **FLOATING
C2214 control_logic_rw_0/pdriver_0_0/pinv_7_0/pmos_m11_w1_150_sli_dli_da_p_0/a_132_0# vdd 0.02483f ; **FLOATING
C2215 control_logic_rw_0/pdriver_0_0/pinv_7_0/pmos_m11_w1_150_sli_dli_da_p_0/a_210_0# vdd 0.03465f ; **FLOATING
C2216 control_logic_rw_0/pdriver_0_0/pinv_7_0/pmos_m11_w1_150_sli_dli_da_p_0/a_288_0# vdd 0.02528f ; **FLOATING
C2217 control_logic_rw_0/pdriver_0_0/pinv_7_0/pmos_m11_w1_150_sli_dli_da_p_0/a_366_0# vdd 0.03586f ; **FLOATING
C2218 control_logic_rw_0/pdriver_0_0/pinv_7_0/pmos_m11_w1_150_sli_dli_da_p_0/a_444_0# vdd 0.03092f ; **FLOATING
C2219 control_logic_rw_0/pdriver_0_0/pinv_7_0/pmos_m11_w1_150_sli_dli_da_p_0/a_522_0# vdd 0.03768f ; **FLOATING
C2220 control_logic_rw_0/pdriver_0_0/pinv_7_0/pmos_m11_w1_150_sli_dli_da_p_0/a_600_0# vdd 0.0272f ; **FLOATING
C2221 control_logic_rw_0/pdriver_0_0/pinv_7_0/pmos_m11_w1_150_sli_dli_da_p_0/a_678_0# vdd 0.03759f ; **FLOATING
C2222 control_logic_rw_0/pdriver_0_0/pinv_7_0/pmos_m11_w1_150_sli_dli_da_p_0/a_756_0# vdd 0.02783f ; **FLOATING
C2223 control_logic_rw_0/pdriver_0_0/pinv_7_0/pmos_m11_w1_150_sli_dli_da_p_0/a_834_0# vdd 0.02216f ; **FLOATING
C2224 control_logic_rw_0/pinv_3_1/w_n127_195# vdd 17.45749f ; **FLOATING
C2225 control_logic_rw_0/pdriver_0_0/pinv_7_0/pmos_m11_w1_150_sli_dli_da_p_0/a_54_0# vdd 0.02968f ; **FLOATING
C2226 control_logic_rw_0/pdriver_0_0/gnd vdd 2.38788f
C2227 control_logic_rw_0/pdriver_0_0/pinv_7_0/nmos_m11_w0_570_sli_dli_da_p_0/a_54_0# vdd 0.01961f ; **FLOATING
C2228 control_logic_rw_0/pdriver_0_0/pinv_7_0/nmos_m11_w0_570_sli_dli_da_p_0/a_132_0# vdd 0.01422f ; **FLOATING
C2229 control_logic_rw_0/pdriver_0_0/pinv_7_0/nmos_m11_w0_570_sli_dli_da_p_0/a_210_0# vdd 0.02311f ; **FLOATING
C2230 control_logic_rw_0/pdriver_0_0/pinv_7_0/nmos_m11_w0_570_sli_dli_da_p_0/a_288_0# vdd 0.01502f ; **FLOATING
C2231 control_logic_rw_0/pdriver_0_0/pinv_7_0/nmos_m11_w0_570_sli_dli_da_p_0/a_366_0# vdd 0.02408f ; **FLOATING
C2232 control_logic_rw_0/pdriver_0_0/pinv_7_0/nmos_m11_w0_570_sli_dli_da_p_0/a_444_0# vdd 0.01862f ; **FLOATING
C2233 control_logic_rw_0/pdriver_0_0/pinv_7_0/nmos_m11_w0_570_sli_dli_da_p_0/a_522_0# vdd 0.02433f ; **FLOATING
C2234 control_logic_rw_0/pdriver_0_0/pinv_7_0/nmos_m11_w0_570_sli_dli_da_p_0/a_600_0# vdd 0.01525f ; **FLOATING
C2235 control_logic_rw_0/pdriver_0_0/pinv_7_0/nmos_m11_w0_570_sli_dli_da_p_0/a_678_0# vdd 0.02329f ; **FLOATING
C2236 control_logic_rw_0/pdriver_0_0/pinv_7_0/nmos_m11_w0_570_sli_dli_da_p_0/a_756_0# vdd 0.01462f ; **FLOATING
C2237 control_logic_rw_0/pdriver_0_0/pinv_7_0/nmos_m11_w0_570_sli_dli_da_p_0/a_834_0# vdd 0.01274f ; **FLOATING
C2238 control_logic_rw_0/pinv_3_0/A vdd 16.69625f ; **FLOATING
C2239 control_logic_rw_0/pand3_0/C vdd 11.95383f ; **FLOATING
C2240 control_logic_rw_0/pand2_1/A vdd 0.28519f ; **FLOATING
C2241 control_logic_rw_0/pand2_1/gnd vdd 1.00963f
C2242 control_logic_rw_0/pand2_0/Z vdd 1.61544f ; **FLOATING
C2243 control_logic_rw_0/pdriver_4_0/pinv_8_0/A vdd 0.30399f ; **FLOATING
C2244 control_logic_rw_0/delay_chain_0/pinv_11_44/Z vdd 5.23134f ; **FLOATING
C2245 control_logic_rw_0/delay_chain_0/pinv_11_34/Z vdd 4.552f ; **FLOATING
C2246 control_logic_rw_0/delay_chain_0/pinv_11_29/Z vdd 4.9971f ; **FLOATING
C2247 control_logic_rw_0/delay_chain_0/pinv_11_24/Z vdd 4.69639f ; **FLOATING
C2248 control_logic_rw_0/delay_chain_0/pinv_11_9/Z vdd 5.17661f ; **FLOATING
C2249 control_logic_rw_0/delay_chain_0/pinv_11_19/Z vdd 5.02711f ; **FLOATING
C2250 control_logic_rw_0/delay_chain_0/pinv_11_19/pmos_m1_w0_840_sli_dli_da_p_0/a_0_0# vdd 0.01444f ; **FLOATING
C2251 control_logic_rw_0/delay_chain_0/pinv_11_29/pmos_m1_w0_840_sli_dli_da_p_0/a_0_0# vdd 0.01424f ; **FLOATING
C2252 control_logic_rw_0/delay_chain_0/pinv_11_18/Z vdd 0.54933f
C2253 control_logic_rw_0/delay_chain_0/pinv_11_18/pmos_m1_w0_840_sli_dli_da_p_0/a_0_0# vdd 0.01538f ; **FLOATING
C2254 control_logic_rw_0/delay_chain_0/pinv_11_18/pmos_m1_w0_840_sli_dli_da_p_0/a_54_0# vdd 0.01043f ; **FLOATING
C2255 control_logic_rw_0/delay_chain_0/pinv_11_28/Z vdd 0.54026f
C2256 control_logic_rw_0/delay_chain_0/pinv_11_28/pmos_m1_w0_840_sli_dli_da_p_0/a_0_0# vdd 0.01521f ; **FLOATING
C2257 control_logic_rw_0/delay_chain_0/pinv_11_28/pmos_m1_w0_840_sli_dli_da_p_0/a_54_0# vdd 0.01032f ; **FLOATING
C2258 control_logic_rw_0/delay_chain_0/pinv_11_39/Z vdd 4.98548f ; **FLOATING
C2259 control_logic_rw_0/delay_chain_0/pinv_11_39/pmos_m1_w0_840_sli_dli_da_p_0/a_0_0# vdd 0.01457f ; **FLOATING
C2260 control_logic_rw_0/delay_chain_0/pinv_11_17/Z vdd 0.56251f
C2261 control_logic_rw_0/delay_chain_0/pinv_11_17/pmos_m1_w0_840_sli_dli_da_p_0/a_0_0# vdd 0.0166f ; **FLOATING
C2262 control_logic_rw_0/delay_chain_0/pinv_11_17/pmos_m1_w0_840_sli_dli_da_p_0/a_54_0# vdd 0.01149f ; **FLOATING
C2263 control_logic_rw_0/delay_chain_0/pinv_11_38/Z vdd 0.55342f
C2264 control_logic_rw_0/delay_chain_0/pinv_11_38/pmos_m1_w0_840_sli_dli_da_p_0/a_0_0# vdd 0.01537f ; **FLOATING
C2265 control_logic_rw_0/delay_chain_0/pinv_11_38/pmos_m1_w0_840_sli_dli_da_p_0/a_54_0# vdd 0.01037f ; **FLOATING
C2266 control_logic_rw_0/delay_chain_0/pinv_11_27/Z vdd 0.55624f
C2267 control_logic_rw_0/delay_chain_0/pinv_11_27/pmos_m1_w0_840_sli_dli_da_p_0/a_0_0# vdd 0.0163f ; **FLOATING
C2268 control_logic_rw_0/delay_chain_0/pinv_11_27/pmos_m1_w0_840_sli_dli_da_p_0/a_54_0# vdd 0.01153f ; **FLOATING
C2269 control_logic_rw_0/delay_chain_0/pinv_11_16/Z vdd 0.56397f
C2270 control_logic_rw_0/delay_chain_0/pinv_11_16/pmos_m1_w0_840_sli_dli_da_p_0/a_0_0# vdd 0.01659f ; **FLOATING
C2271 control_logic_rw_0/delay_chain_0/pinv_11_16/pmos_m1_w0_840_sli_dli_da_p_0/a_54_0# vdd 0.01148f ; **FLOATING
C2272 control_logic_rw_0/delay_chain_0/pinv_11_37/Z vdd 0.56326f
C2273 control_logic_rw_0/delay_chain_0/pinv_11_37/pmos_m1_w0_840_sli_dli_da_p_0/a_0_0# vdd 0.0163f ; **FLOATING
C2274 control_logic_rw_0/delay_chain_0/pinv_11_37/pmos_m1_w0_840_sli_dli_da_p_0/a_54_0# vdd 0.01123f ; **FLOATING
C2275 control_logic_rw_0/delay_chain_0/pinv_11_26/Z vdd 0.57371f
C2276 control_logic_rw_0/delay_chain_0/pinv_11_26/pmos_m1_w0_840_sli_dli_da_p_0/a_0_0# vdd 0.01643f ; **FLOATING
C2277 control_logic_rw_0/delay_chain_0/pinv_11_26/pmos_m1_w0_840_sli_dli_da_p_0/a_54_0# vdd 0.01163f ; **FLOATING
C2278 control_logic_rw_0/delay_chain_0/pinv_11_15/Z vdd 0.54597f
C2279 control_logic_rw_0/delay_chain_0/pinv_11_15/pmos_m1_w0_840_sli_dli_da_p_0/a_0_0# vdd 0.01532f ; **FLOATING
C2280 control_logic_rw_0/delay_chain_0/pinv_11_36/Z vdd 0.55849f
C2281 control_logic_rw_0/delay_chain_0/pinv_11_36/pmos_m1_w0_840_sli_dli_da_p_0/a_0_0# vdd 0.01611f ; **FLOATING
C2282 control_logic_rw_0/delay_chain_0/pinv_11_36/pmos_m1_w0_840_sli_dli_da_p_0/a_54_0# vdd 0.01154f ; **FLOATING
C2283 control_logic_rw_0/delay_chain_0/pinv_11_25/Z vdd 0.54664f
C2284 control_logic_rw_0/delay_chain_0/pinv_11_25/pmos_m1_w0_840_sli_dli_da_p_0/a_0_0# vdd 0.01547f ; **FLOATING
C2285 control_logic_rw_0/delay_chain_0/pinv_11_25/pmos_m1_w0_840_sli_dli_da_p_0/a_54_0# vdd 0.01004f ; **FLOATING
C2286 control_logic_rw_0/delay_chain_0/pinv_11_9/A vdd 4.69148f ; **FLOATING
C2287 control_logic_rw_0/delay_chain_0/pinv_11_14/pmos_m1_w0_840_sli_dli_da_p_0/a_0_0# vdd 0.01452f ; **FLOATING
C2288 control_logic_rw_0/delay_chain_0/pinv_11_35/Z vdd 0.53782f
C2289 control_logic_rw_0/delay_chain_0/pinv_11_35/pmos_m1_w0_840_sli_dli_da_p_0/a_0_0# vdd 0.01497f ; **FLOATING
C2290 control_logic_rw_0/delay_chain_0/pinv_11_24/pmos_m1_w0_840_sli_dli_da_p_0/a_0_0# vdd 0.01461f ; **FLOATING
C2291 control_logic_rw_0/delay_chain_0/pinv_11_13/Z vdd 0.54716f
C2292 control_logic_rw_0/delay_chain_0/pinv_11_13/pmos_m1_w0_840_sli_dli_da_p_0/a_0_0# vdd 0.01533f ; **FLOATING
C2293 control_logic_rw_0/delay_chain_0/pinv_11_13/pmos_m1_w0_840_sli_dli_da_p_0/a_54_0# vdd 0.01014f ; **FLOATING
C2294 control_logic_rw_0/delay_chain_0/pinv_11_9/w_n127_403# vdd 21.94629f ; **FLOATING
C2295 control_logic_rw_0/delay_chain_0/pinv_11_34/pmos_m1_w0_840_sli_dli_da_p_0/a_0_0# vdd 0.01447f ; **FLOATING
C2296 control_logic_rw_0/delay_chain_0/pinv_11_23/Z vdd 0.54988f
C2297 control_logic_rw_0/delay_chain_0/pinv_11_23/pmos_m1_w0_840_sli_dli_da_p_0/a_0_0# vdd 0.01552f ; **FLOATING
C2298 control_logic_rw_0/delay_chain_0/pinv_11_23/pmos_m1_w0_840_sli_dli_da_p_0/a_54_0# vdd 0.0107f ; **FLOATING
C2299 control_logic_rw_0/delay_chain_0/pinv_11_24/w_n127_403# vdd 21.9641f ; **FLOATING
C2300 control_logic_rw_0/delay_chain_0/pinv_11_12/Z vdd 0.55806f
C2301 control_logic_rw_0/delay_chain_0/pinv_11_12/pmos_m1_w0_840_sli_dli_da_p_0/a_0_0# vdd 0.01655f ; **FLOATING
C2302 control_logic_rw_0/delay_chain_0/pinv_11_12/pmos_m1_w0_840_sli_dli_da_p_0/a_54_0# vdd 0.01179f ; **FLOATING
C2303 control_logic_rw_0/delay_chain_0/pinv_11_33/Z vdd 0.5459f
C2304 control_logic_rw_0/delay_chain_0/pinv_11_33/pmos_m1_w0_840_sli_dli_da_p_0/a_0_0# vdd 0.01531f ; **FLOATING
C2305 control_logic_rw_0/delay_chain_0/pinv_11_33/pmos_m1_w0_840_sli_dli_da_p_0/a_54_0# vdd 0.01017f ; **FLOATING
C2306 control_logic_rw_0/delay_chain_0/pinv_11_34/w_n127_403# vdd 21.89776f ; **FLOATING
C2307 control_logic_rw_0/delay_chain_0/pinv_11_44/pmos_m1_w0_840_sli_dli_da_p_0/a_0_0# vdd 0.0154f ; **FLOATING
C2308 control_logic_rw_0/delay_chain_0/pinv_11_22/Z vdd 0.56049f
C2309 control_logic_rw_0/delay_chain_0/pinv_11_22/pmos_m1_w0_840_sli_dli_da_p_0/a_0_0# vdd 0.01709f ; **FLOATING
C2310 control_logic_rw_0/delay_chain_0/pinv_11_22/pmos_m1_w0_840_sli_dli_da_p_0/a_54_0# vdd 0.01263f ; **FLOATING
C2311 control_logic_rw_0/delay_chain_0/pinv_11_11/Z vdd 0.56097f
C2312 control_logic_rw_0/delay_chain_0/pinv_11_11/pmos_m1_w0_840_sli_dli_da_p_0/a_0_0# vdd 0.01654f ; **FLOATING
C2313 control_logic_rw_0/delay_chain_0/pinv_11_11/pmos_m1_w0_840_sli_dli_da_p_0/a_54_0# vdd 0.01148f ; **FLOATING
C2314 control_logic_rw_0/delay_chain_0/pinv_11_32/Z vdd 0.56255f
C2315 control_logic_rw_0/delay_chain_0/pinv_11_32/pmos_m1_w0_840_sli_dli_da_p_0/a_0_0# vdd 0.01667f ; **FLOATING
C2316 control_logic_rw_0/delay_chain_0/pinv_11_32/pmos_m1_w0_840_sli_dli_da_p_0/a_54_0# vdd 0.01201f ; **FLOATING
C2317 control_logic_rw_0/delay_chain_0/pinv_11_43/Z vdd 0.55144f
C2318 control_logic_rw_0/delay_chain_0/pinv_11_43/pmos_m1_w0_840_sli_dli_da_p_0/a_0_0# vdd 0.01553f ; **FLOATING
C2319 control_logic_rw_0/delay_chain_0/pinv_11_43/pmos_m1_w0_840_sli_dli_da_p_0/a_54_0# vdd 0.01071f ; **FLOATING
C2320 control_logic_rw_0/delay_chain_0/pinv_11_44/w_n127_403# vdd 21.97009f ; **FLOATING
C2321 control_logic_rw_0/delay_chain_0/pinv_11_21/Z vdd 0.56722f
C2322 control_logic_rw_0/delay_chain_0/pinv_11_21/pmos_m1_w0_840_sli_dli_da_p_0/a_0_0# vdd 0.01718f ; **FLOATING
C2323 control_logic_rw_0/delay_chain_0/pinv_11_21/pmos_m1_w0_840_sli_dli_da_p_0/a_54_0# vdd 0.01194f ; **FLOATING
C2324 control_logic_rw_0/delay_chain_0/pinv_11_10/Z vdd 0.54477f
C2325 control_logic_rw_0/delay_chain_0/pinv_11_10/pmos_m1_w0_840_sli_dli_da_p_0/a_0_0# vdd 0.01529f ; **FLOATING
C2326 control_logic_rw_0/delay_chain_0/pinv_11_31/Z vdd 0.56788f
C2327 control_logic_rw_0/delay_chain_0/pinv_11_31/pmos_m1_w0_840_sli_dli_da_p_0/a_0_0# vdd 0.01663f ; **FLOATING
C2328 control_logic_rw_0/delay_chain_0/pinv_11_31/pmos_m1_w0_840_sli_dli_da_p_0/a_54_0# vdd 0.01182f ; **FLOATING
C2329 control_logic_rw_0/delay_chain_0/pinv_11_42/Z vdd 0.56183f
C2330 control_logic_rw_0/delay_chain_0/pinv_11_42/pmos_m1_w0_840_sli_dli_da_p_0/a_0_0# vdd 0.01691f ; **FLOATING
C2331 control_logic_rw_0/delay_chain_0/pinv_11_42/pmos_m1_w0_840_sli_dli_da_p_0/a_54_0# vdd 0.01266f ; **FLOATING
C2332 control_logic_rw_0/delay_chain_0/pinv_11_20/Z vdd 0.54609f
C2333 control_logic_rw_0/delay_chain_0/pinv_11_20/pmos_m1_w0_840_sli_dli_da_p_0/a_0_0# vdd 0.01573f ; **FLOATING
C2334 control_logic_rw_0/delay_chain_0/pinv_11_20/pmos_m1_w0_840_sli_dli_da_p_0/a_54_0# vdd 0.01006f ; **FLOATING
C2335 control_logic_rw_0/delay_chain_0/pinv_11_30/Z vdd 0.54074f
C2336 control_logic_rw_0/delay_chain_0/pinv_11_30/pmos_m1_w0_840_sli_dli_da_p_0/a_0_0# vdd 0.01524f ; **FLOATING
C2337 control_logic_rw_0/delay_chain_0/pinv_11_41/Z vdd 0.56731f
C2338 control_logic_rw_0/delay_chain_0/pinv_11_41/pmos_m1_w0_840_sli_dli_da_p_0/a_0_0# vdd 0.01689f ; **FLOATING
C2339 control_logic_rw_0/delay_chain_0/pinv_11_41/pmos_m1_w0_840_sli_dli_da_p_0/a_54_0# vdd 0.01157f ; **FLOATING
C2340 control_logic_rw_0/delay_chain_0/pinv_11_40/Z vdd 0.54609f
C2341 control_logic_rw_0/delay_chain_0/pinv_11_40/pmos_m1_w0_840_sli_dli_da_p_0/a_0_0# vdd 0.01545f ; **FLOATING
C2342 control_logic_rw_0/delay_chain_0/pinv_11_40/pmos_m1_w0_840_sli_dli_da_p_0/a_54_0# vdd 0.01003f ; **FLOATING
C2343 control_logic_rw_0/delay_chain_0/pinv_11_9/pmos_m1_w0_840_sli_dli_da_p_0/a_0_0# vdd 0.01465f ; **FLOATING
C2344 control_logic_rw_0/delay_chain_0/pinv_11_9/pmos_m1_w0_840_sli_dli_da_p_0/a_54_0# vdd 0.01004f ; **FLOATING
C2345 control_logic_rw_0/delay_chain_0/pinv_11_8/Z vdd 0.5584f
C2346 control_logic_rw_0/delay_chain_0/pinv_11_8/pmos_m1_w0_840_sli_dli_da_p_0/a_0_0# vdd 0.01561f ; **FLOATING
C2347 control_logic_rw_0/delay_chain_0/pinv_11_8/pmos_m1_w0_840_sli_dli_da_p_0/a_54_0# vdd 0.01077f ; **FLOATING
C2348 control_logic_rw_0/delay_chain_0/pinv_11_7/Z vdd 0.56351f
C2349 control_logic_rw_0/delay_chain_0/pinv_11_7/pmos_m1_w0_840_sli_dli_da_p_0/a_0_0# vdd 0.01644f ; **FLOATING
C2350 control_logic_rw_0/delay_chain_0/pinv_11_7/pmos_m1_w0_840_sli_dli_da_p_0/a_54_0# vdd 0.01164f ; **FLOATING
C2351 control_logic_rw_0/delay_chain_0/pinv_11_6/Z vdd 0.55377f
C2352 control_logic_rw_0/delay_chain_0/pinv_11_6/pmos_m1_w0_840_sli_dli_da_p_0/a_0_0# vdd 0.01629f ; **FLOATING
C2353 control_logic_rw_0/delay_chain_0/pinv_11_6/pmos_m1_w0_840_sli_dli_da_p_0/a_54_0# vdd 0.01129f ; **FLOATING
C2354 control_logic_rw_0/delay_chain_0/pinv_11_5/Z vdd 0.53779f
C2355 control_logic_rw_0/delay_chain_0/pinv_11_5/pmos_m1_w0_840_sli_dli_da_p_0/a_0_0# vdd 0.01517f ; **FLOATING
C2356 control_logic_rw_0/delay_chain_0/pinv_11_4/pmos_m1_w0_840_sli_dli_da_p_0/a_0_0# vdd 0.01544f ; **FLOATING
C2357 control_logic_rw_0/delay_chain_0/pinv_11_4/pmos_m1_w0_840_sli_dli_da_p_0/a_54_0# vdd 0.01077f ; **FLOATING
C2358 control_logic_rw_0/delay_chain_0/pinv_11_3/Z vdd 0.56071f
C2359 control_logic_rw_0/delay_chain_0/pinv_11_3/pmos_m1_w0_840_sli_dli_da_p_0/a_0_0# vdd 0.01616f ; **FLOATING
C2360 control_logic_rw_0/delay_chain_0/pinv_11_3/pmos_m1_w0_840_sli_dli_da_p_0/a_54_0# vdd 0.01135f ; **FLOATING
C2361 control_logic_rw_0/delay_chain_0/pinv_11_4/w_n127_403# vdd 16.71952f ; **FLOATING
C2362 control_logic_rw_0/delay_chain_0/pinv_11_2/Z vdd 0.56782f
C2363 control_logic_rw_0/delay_chain_0/pinv_11_2/pmos_m1_w0_840_sli_dli_da_p_0/a_0_0# vdd 0.01703f ; **FLOATING
C2364 control_logic_rw_0/delay_chain_0/pinv_11_2/pmos_m1_w0_840_sli_dli_da_p_0/a_54_0# vdd 0.01176f ; **FLOATING
C2365 control_logic_rw_0/delay_chain_0/pinv_11_1/Z vdd 0.56084f
C2366 control_logic_rw_0/delay_chain_0/pinv_11_1/pmos_m1_w0_840_sli_dli_da_p_0/a_0_0# vdd 0.01733f ; **FLOATING
C2367 control_logic_rw_0/delay_chain_0/pinv_11_1/pmos_m1_w0_840_sli_dli_da_p_0/a_54_0# vdd 0.01149f ; **FLOATING
C2368 control_logic_rw_0/delay_chain_0/pinv_11_0/Z vdd 0.53843f
C2369 control_logic_rw_0/delay_chain_0/pinv_11_0/pmos_m1_w0_840_sli_dli_da_p_0/a_0_0# vdd 0.01543f ; **FLOATING
C2370 control_logic_rw_0/delay_chain_0/pinv_11_0/pmos_m1_w0_840_sli_dli_da_p_0/a_54_0# vdd 0.01002f ; **FLOATING
C2371 control_logic_rw_0/pdriver_1_0/pinv_6_0/A vdd 0.59404f ; **FLOATING
C2372 control_logic_rw_0/pand3_0/gnd vdd 1.45516f
C2373 control_logic_rw_0/pdriver_1_0/w_n127_195# vdd 13.09632f ; **FLOATING
C2374 control_logic_rw_0/pdriver_1_0/pinv_8_0/A vdd 0.26849f ; **FLOATING
C2375 control_logic_rw_0/pdriver_1_0/pinv_8_0/Z vdd 0.42092f ; **FLOATING
C2376 control_logic_rw_0/pand3_0/pdriver_2_0/pinv_9_0/pmos_m7_w1_200_sli_dli_da_p_0/a_132_0# vdd 0.02524f ; **FLOATING
C2377 control_logic_rw_0/pand3_0/pdriver_2_0/pinv_9_0/pmos_m7_w1_200_sli_dli_da_p_0/a_54_0# vdd 0.02982f ; **FLOATING
C2378 control_logic_rw_0/pand3_0/pdriver_2_0/pinv_9_0/pmos_m7_w1_200_sli_dli_da_p_0/a_210_0# vdd 0.03583f ; **FLOATING
C2379 control_logic_rw_0/pand3_0/pdriver_2_0/pinv_9_0/pmos_m7_w1_200_sli_dli_da_p_0/a_288_0# vdd 0.03114f ; **FLOATING
C2380 control_logic_rw_0/pand3_0/pdriver_2_0/pinv_9_0/pmos_m7_w1_200_sli_dli_da_p_0/a_366_0# vdd 0.03988f ; **FLOATING
C2381 control_logic_rw_0/pand3_0/pdriver_2_0/pinv_9_0/pmos_m7_w1_200_sli_dli_da_p_0/a_444_0# vdd 0.02881f ; **FLOATING
C2382 control_logic_rw_0/pand3_0/pdriver_2_0/pinv_9_0/pmos_m7_w1_200_sli_dli_da_p_0/a_522_0# vdd 0.02267f ; **FLOATING
C2383 control_logic_rw_0/pnand2_1_0/w_n127_195# vdd 9.67315f ; **FLOATING
C2384 control_logic_rw_0/pand3_0/pdriver_2_0/pinv_9_0/nmos_m7_w0_600_sli_dli_da_p_0/a_54_0# vdd 0.01791f ; **FLOATING
C2385 control_logic_rw_0/pand3_0/pdriver_2_0/pinv_9_0/nmos_m7_w0_600_sli_dli_da_p_0/a_132_0# vdd 0.0125f ; **FLOATING
C2386 control_logic_rw_0/pand3_0/pdriver_2_0/pinv_9_0/nmos_m7_w0_600_sli_dli_da_p_0/a_210_0# vdd 0.02095f ; **FLOATING
C2387 control_logic_rw_0/pand3_0/pdriver_2_0/pinv_9_0/nmos_m7_w0_600_sli_dli_da_p_0/a_288_0# vdd 0.01546f ; **FLOATING
C2388 control_logic_rw_0/pand3_0/pdriver_2_0/pinv_9_0/nmos_m7_w0_600_sli_dli_da_p_0/a_366_0# vdd 0.02303f ; **FLOATING
C2389 control_logic_rw_0/pand3_0/pdriver_2_0/pinv_9_0/nmos_m7_w0_600_sli_dli_da_p_0/a_522_0# vdd 0.01312f ; **FLOATING
C2390 control_logic_rw_0/pand3_0/pdriver_2_0/pinv_9_0/nmos_m7_w0_600_sli_dli_da_p_0/a_444_0# vdd 0.01468f ; **FLOATING
C2391 control_logic_rw_0/pand3_0/B vdd 3.35562f ; **FLOATING
C2392 control_logic_rw_0/dff_buf_array_0/dff_buf_0_1/pinv_1_0/vdd vdd 0.60269f
C2393 control_logic_rw_0/dff_buf_array_0/dff_buf_0_0/dff_0/Q vdd 1.46444f
C2394 control_logic_rw_0/dff_buf_array_0/dff_buf_0_0/pinv_1_0/gnd vdd 1.09327f
C2395 control_logic_rw_0/dff_buf_array_0/dff_buf_0_1/pinv_1_0/w_n127_195# vdd 7.33255f ; **FLOATING
C2396 control_logic_rw_0/dff_buf_array_0/dff_buf_0_0/dff_0/net5 vdd 0.39462f
C2397 control_logic_rw_0/dff_buf_array_0/dff_buf_0_0/dff_0/net2 vdd 0.43865f
C2398 web0 vdd 1.06875f
C2399 control_logic_rw_0/dff_buf_array_0/dff_buf_0_0/dff_0/net4 vdd 0.86091f
C2400 control_logic_rw_0/dff_buf_array_0/dff_buf_0_0/dff_0/net1 vdd 0.94696f
C2401 control_logic_rw_0/dff_buf_array_0/dff_buf_0_0/dff_0/net3 vdd 0.8532f
C2402 control_logic_rw_0/dff_buf_array_0/dff_buf_0_0/dff_0/clkb vdd 2.13039f
C2403 control_logic_rw_0/dff_buf_array_0/dff_buf_0_1/dff_0/Q vdd 1.46163f
C2404 control_logic_rw_0/dff_buf_array_0/dff_buf_0_1/pinv_1_0/gnd vdd 1.10017f
C2405 control_logic_rw_0/dff_buf_array_0/dout_0 vdd 0.21535f
C2406 control_logic_rw_0/dff_buf_array_0/dff_buf_0_1/dff_0/net5 vdd 0.3904f
C2407 control_logic_rw_0/dff_buf_array_0/dff_buf_0_1/dff_0/net2 vdd 0.41609f
C2408 csb0 vdd 0.91214f
C2409 control_logic_rw_0/dff_buf_array_0/dff_buf_0_1/dff_0/net4 vdd 0.855f
C2410 control_logic_rw_0/dff_buf_array_0/dff_buf_0_1/dff_0/net1 vdd 0.91526f
C2411 control_logic_rw_0/dff_buf_array_0/dff_buf_0_1/dff_0/net3 vdd 0.84107f
C2412 control_logic_rw_0/dff_buf_array_0/dff_buf_0_1/dff_0/clkb vdd 2.08372f
C2413 control_logic_rw_0/pinv_3_0/vdd vdd 0.19083f
C2414 control_logic_rw_0/pand3_0_0/pdriver_3_0/pinv_10_0/pmos_m2_w0_840_sli_dli_da_p_0/a_54_0# vdd 0.02326f ; **FLOATING
C2415 control_logic_rw_0/pand3_0_0/gnd vdd 0.77904f
C2416 control_logic_rw_0/pand3_0_0/pdriver_3_0/pinv_10_0/nmos_m2_w0_420_sli_dli_da_p_0/a_54_0# vdd 0.01253f ; **FLOATING
C2417 control_logic_rw_0/pand3_0_0/C vdd 3.75528f ; **FLOATING
C2418 control_logic_rw_0/pinv_3_0/w_n127_195# vdd 6.6675f ; **FLOATING
C2419 data_dff_0/dff_1/net5 vdd 0.67217f
C2420 data_dff_0/dff_1/net2 vdd 0.41636f
C2421 data_dff_0/dff_1/net1 vdd 0.93923f
C2422 data_dff_0/dff_1/net3 vdd 0.95454f
C2423 data_dff_0/dff_1/clkb vdd 2.26885f
C2424 data_dff_0/dff_0/net5 vdd 0.55404f
C2425 data_dff_0/dff_0/net2 vdd 0.51586f
C2426 data_dff_0/dff_0/net4 vdd 1.24431f
C2427 data_dff_0/dff_0/net1 vdd 1.22309f
C2428 data_dff_0/dff_0/net3 vdd 1.05572f
