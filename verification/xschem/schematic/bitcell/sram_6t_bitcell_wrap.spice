* LVS wrapper
.subckt sram_6t_bitcell_wrap BL BLB WL VDD GND
Xcell BL BLB WL VDD GND your_actual_subckt_name
.ends
.include YOUR_ACTUAL_SCHEMATIC.spice
