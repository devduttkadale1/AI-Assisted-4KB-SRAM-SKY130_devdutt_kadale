* 6T SRAM bitcell for SKY130
.subckt sram_6t_bitcell BL BLB WL VDD VSS Q QB

* Cross-coupled inverters
M1 Q   QB  VDD VDD sky130_fd_pr__pfet_01v8 W=1.5u L=0.15u
M2 QB  Q   VDD VDD sky130_fd_pr__pfet_01v8 W=1.5u L=0.15u
M3 Q   QB  VSS VSS sky130_fd_pr__nfet_01v8 W=1.0u L=0.15u
M4 QB  Q   VSS VSS sky130_fd_pr__nfet_01v8 W=1.0u L=0.15u

* Access transistors
M5 Q   WL  BL  VSS sky130_fd_pr__nfet_01v8 W=0.8u L=0.15u
M6 QB  WL  BLB VSS sky130_fd_pr__nfet_01v8 W=0.8u L=0.15u

.ends sram_6t_bitcell
