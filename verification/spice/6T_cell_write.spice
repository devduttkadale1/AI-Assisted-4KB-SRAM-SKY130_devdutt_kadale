* 6T SRAM Cell - WRITE Operation
* Author: Devdutt Kadale | VSD Internship Week 2

.lib "/usr/local/share/pdk/sky130A/libs.tech/combined/sky130.lib.spice" tt

.subckt sram_6t BL BLB WL VDD GND
XM1 Q  QB  GND GND sky130_fd_pr__nfet_01v8 W=1 L=0.15 nf=1 ad=0 as=0 pd=0 ps=0 mult=1
XM2 Q  QB  VDD VDD sky130_fd_pr__pfet_01v8 W=0.5 L=0.15 nf=1 ad=0 as=0 pd=0 ps=0 mult=1
XM3 QB Q   GND GND sky130_fd_pr__nfet_01v8 W=1 L=0.15 nf=1 ad=0 as=0 pd=0 ps=0 mult=1
XM4 QB Q   VDD VDD sky130_fd_pr__pfet_01v8 W=0.5 L=0.15 nf=1 ad=0 as=0 pd=0 ps=0 mult=1
XM5 BL  Q  WL GND sky130_fd_pr__nfet_01v8 W=0.5 L=0.15 nf=1 ad=0 as=0 pd=0 ps=0 mult=1
XM6 BLB QB WL GND sky130_fd_pr__nfet_01v8 W=0.5 L=0.15 nf=1 ad=0 as=0 pd=0 ps=0 mult=1
.ends sram_6t

* Write 0 into cell (BL=0, BLB=1, WL=HIGH)
Vvdd VDD 0 DC 1.8
VBL  BL  0 PWL(0n 1.8 2n 0)
VBLB BLB 0 PWL(0n 0   2n 1.8)
VWL  WL  0 PULSE(0 1.8 2n 100p 100p 6n 20n)

X1 BL BLB WL VDD 0 sram_6t

* Cell initially storing 1 (Q=1, QB=0)
.ic V(X1.Q)=1.8 V(X1.QB)=0

.tran 10p 20n

.control
  run
  hardcopy ../waveforms/6T_write_waveform.ps V(BL) V(BLB) V(WL) V(X1.Q) V(X1.QB)
  write ../simulations/6T_write.raw
  echo "*** WRITE SIMULATION COMPLETE ***"
.endc

.end
