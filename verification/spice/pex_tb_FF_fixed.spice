* Post-LVS simulation — sram_2_16_sky130A TT corner
.lib /usr/local/share/pdk/sky130A/libs.tech/ngspice/sky130.lib.spice ff
.include /tmp/sky130_fd_pr_mos_wrapper.spice
.include /home/devdutt/AI-Assisted-4KB-SRAM-SKY130/results/spice/sram_2_16_sky130A.lvs.fixed.sp

Vvdd vdd GND 1.95
Vgnd gnd GND 0
Vclk clk0 GND pulse(0 1.8 2n 0.1n 0.1n 5n 10n)

Vcsb csb0 GND pwl(0 1.8 4.9n 1.8 5n 0 14.9n 0 15n 1.8 24.9n 1.8 25n 0 34.9n 0 35n 1.8)
Vweb web0 GND pwl(0 1.8 4.9n 1.8 5n 0 14.9n 0 15n 1.8 25n 1.8)

Vaddr0 addr0[0] GND 0
Vaddr1 addr0[1] GND 0
Vaddr2 addr0[2] GND 0
Vaddr3 addr0[3] GND 0

Vdin0 din0[0] GND pwl(0 0 4.9n 0 5n 1.8 15n 0)
Vdin1 din0[1] GND 0

Xdut din0[0] din0[1] addr0[0] addr0[1] addr0[2] addr0[3] csb0 web0 clk0 dout0[0] dout0[1] vdd gnd sram_2_16_sky130A

.tran 0.1n 60n

.measure tran t_access_rise
+ TRIG v(clk0)     VAL=0.9 RISE=3
+ TARG v(dout0[0]) VAL=0.9 RISE=1

.measure tran i_leakage AVG i(Vvdd) FROM=50n TO=60n

.control
run
wrdata /home/devdutt/AI-Assisted-4KB-SRAM-SKY130/verification/results/pex_TT_waves.txt v(dout0[0]) v(clk0)
.endc
